* NGSPICE file created from picorv32_axi.ext - technology: sky130A

* Black-box entry subcircuit for sky130_fd_sc_hd__fill_1 abstract view
.subckt sky130_fd_sc_hd__fill_1 VGND VNB VPB VPWR
.ends

* Black-box entry subcircuit for sky130_fd_sc_hd__o21a_1 abstract view
.subckt sky130_fd_sc_hd__o21a_1 A1 A2 B1 VGND VNB VPB VPWR X
.ends

* Black-box entry subcircuit for sky130_fd_sc_hd__a31o_1 abstract view
.subckt sky130_fd_sc_hd__a31o_1 A1 A2 A3 B1 VGND VNB VPB VPWR X
.ends

* Black-box entry subcircuit for sky130_fd_sc_hd__nor2_1 abstract view
.subckt sky130_fd_sc_hd__nor2_1 A B VGND VNB VPB VPWR Y
.ends

* Black-box entry subcircuit for sky130_ef_sc_hd__decap_12 abstract view
.subckt sky130_ef_sc_hd__decap_12 VPWR VGND VPB VNB
.ends

* Black-box entry subcircuit for sky130_fd_sc_hd__fill_2 abstract view
.subckt sky130_fd_sc_hd__fill_2 VGND VNB VPB VPWR
.ends

* Black-box entry subcircuit for sky130_fd_sc_hd__mux2_1 abstract view
.subckt sky130_fd_sc_hd__mux2_1 A0 A1 S VGND VNB VPB VPWR X
.ends

* Black-box entry subcircuit for sky130_fd_sc_hd__decap_4 abstract view
.subckt sky130_fd_sc_hd__decap_4 VGND VNB VPB VPWR
.ends

* Black-box entry subcircuit for sky130_fd_sc_hd__or2_1 abstract view
.subckt sky130_fd_sc_hd__or2_1 A B VGND VNB VPB VPWR X
.ends

* Black-box entry subcircuit for sky130_fd_sc_hd__or2_2 abstract view
.subckt sky130_fd_sc_hd__or2_2 A B VGND VNB VPB VPWR X
.ends

* Black-box entry subcircuit for sky130_fd_sc_hd__a221o_1 abstract view
.subckt sky130_fd_sc_hd__a221o_1 A1 A2 B1 B2 C1 VGND VNB VPB VPWR X
.ends

* Black-box entry subcircuit for sky130_fd_sc_hd__and2b_1 abstract view
.subckt sky130_fd_sc_hd__and2b_1 A_N B VGND VNB VPB VPWR X
.ends

* Black-box entry subcircuit for sky130_fd_sc_hd__decap_6 abstract view
.subckt sky130_fd_sc_hd__decap_6 VGND VNB VPB VPWR
.ends

* Black-box entry subcircuit for sky130_fd_sc_hd__tapvpwrvgnd_1 abstract view
.subckt sky130_fd_sc_hd__tapvpwrvgnd_1 VGND VPWR
.ends

* Black-box entry subcircuit for sky130_fd_sc_hd__mux2_2 abstract view
.subckt sky130_fd_sc_hd__mux2_2 A0 A1 S VGND VNB VPB VPWR X
.ends

* Black-box entry subcircuit for sky130_fd_sc_hd__nand2_1 abstract view
.subckt sky130_fd_sc_hd__nand2_1 A B VGND VNB VPB VPWR Y
.ends

* Black-box entry subcircuit for sky130_fd_sc_hd__dlygate4sd3_1 abstract view
.subckt sky130_fd_sc_hd__dlygate4sd3_1 A VGND VNB VPB VPWR X
.ends

* Black-box entry subcircuit for sky130_fd_sc_hd__nor3_4 abstract view
.subckt sky130_fd_sc_hd__nor3_4 A B C VGND VNB VPB VPWR Y
.ends

* Black-box entry subcircuit for sky130_fd_sc_hd__buf_2 abstract view
.subckt sky130_fd_sc_hd__buf_2 A VGND VNB VPB VPWR X
.ends

* Black-box entry subcircuit for sky130_fd_sc_hd__clkbuf_4 abstract view
.subckt sky130_fd_sc_hd__clkbuf_4 A VGND VNB VPB VPWR X
.ends

* Black-box entry subcircuit for sky130_fd_sc_hd__a22o_1 abstract view
.subckt sky130_fd_sc_hd__a22o_1 A1 A2 B1 B2 VGND VNB VPB VPWR X
.ends

* Black-box entry subcircuit for sky130_fd_sc_hd__buf_4 abstract view
.subckt sky130_fd_sc_hd__buf_4 A VGND VNB VPB VPWR X
.ends

* Black-box entry subcircuit for sky130_fd_sc_hd__decap_3 abstract view
.subckt sky130_fd_sc_hd__decap_3 VGND VNB VPB VPWR
.ends

* Black-box entry subcircuit for sky130_fd_sc_hd__clkbuf_1 abstract view
.subckt sky130_fd_sc_hd__clkbuf_1 A VGND VNB VPB VPWR X
.ends

* Black-box entry subcircuit for sky130_fd_sc_hd__dfxtp_1 abstract view
.subckt sky130_fd_sc_hd__dfxtp_1 CLK D VGND VNB VPB VPWR Q
.ends

* Black-box entry subcircuit for sky130_fd_sc_hd__a21o_1 abstract view
.subckt sky130_fd_sc_hd__a21o_1 A1 A2 B1 VGND VNB VPB VPWR X
.ends

* Black-box entry subcircuit for sky130_fd_sc_hd__and4_1 abstract view
.subckt sky130_fd_sc_hd__and4_1 A B C D VGND VNB VPB VPWR X
.ends

* Black-box entry subcircuit for sky130_fd_sc_hd__and3b_1 abstract view
.subckt sky130_fd_sc_hd__and3b_1 A_N B C VGND VNB VPB VPWR X
.ends

* Black-box entry subcircuit for sky130_fd_sc_hd__o31a_1 abstract view
.subckt sky130_fd_sc_hd__o31a_1 A1 A2 A3 B1 VGND VNB VPB VPWR X
.ends

* Black-box entry subcircuit for sky130_fd_sc_hd__mux4_1 abstract view
.subckt sky130_fd_sc_hd__mux4_1 A0 A1 A2 A3 S0 S1 VGND VNB VPB VPWR X
.ends

* Black-box entry subcircuit for sky130_fd_sc_hd__a21oi_1 abstract view
.subckt sky130_fd_sc_hd__a21oi_1 A1 A2 B1 VGND VNB VPB VPWR Y
.ends

* Black-box entry subcircuit for sky130_fd_sc_hd__and2_1 abstract view
.subckt sky130_fd_sc_hd__and2_1 A B VGND VNB VPB VPWR X
.ends

* Black-box entry subcircuit for sky130_fd_sc_hd__or3b_1 abstract view
.subckt sky130_fd_sc_hd__or3b_1 A B C_N VGND VNB VPB VPWR X
.ends

* Black-box entry subcircuit for sky130_fd_sc_hd__a211o_1 abstract view
.subckt sky130_fd_sc_hd__a211o_1 A1 A2 B1 C1 VGND VNB VPB VPWR X
.ends

* Black-box entry subcircuit for sky130_fd_sc_hd__o22a_1 abstract view
.subckt sky130_fd_sc_hd__o22a_1 A1 A2 B1 B2 VGND VNB VPB VPWR X
.ends

* Black-box entry subcircuit for sky130_fd_sc_hd__or2_4 abstract view
.subckt sky130_fd_sc_hd__or2_4 A B VGND VNB VPB VPWR X
.ends

* Black-box entry subcircuit for sky130_fd_sc_hd__decap_8 abstract view
.subckt sky130_fd_sc_hd__decap_8 VGND VNB VPB VPWR
.ends

* Black-box entry subcircuit for sky130_fd_sc_hd__clkbuf_2 abstract view
.subckt sky130_fd_sc_hd__clkbuf_2 A VGND VNB VPB VPWR X
.ends

* Black-box entry subcircuit for sky130_fd_sc_hd__dfxtp_2 abstract view
.subckt sky130_fd_sc_hd__dfxtp_2 CLK D VGND VNB VPB VPWR Q
.ends

* Black-box entry subcircuit for sky130_fd_sc_hd__a32o_1 abstract view
.subckt sky130_fd_sc_hd__a32o_1 A1 A2 A3 B1 B2 VGND VNB VPB VPWR X
.ends

* Black-box entry subcircuit for sky130_fd_sc_hd__clkbuf_8 abstract view
.subckt sky130_fd_sc_hd__clkbuf_8 A VGND VNB VPB VPWR X
.ends

* Black-box entry subcircuit for sky130_fd_sc_hd__nor2_2 abstract view
.subckt sky130_fd_sc_hd__nor2_2 A B VGND VNB VPB VPWR Y
.ends

* Black-box entry subcircuit for sky130_fd_sc_hd__and3_1 abstract view
.subckt sky130_fd_sc_hd__and3_1 A B C VGND VNB VPB VPWR X
.ends

* Black-box entry subcircuit for sky130_fd_sc_hd__or3_2 abstract view
.subckt sky130_fd_sc_hd__or3_2 A B C VGND VNB VPB VPWR X
.ends

* Black-box entry subcircuit for sky130_fd_sc_hd__o21ai_1 abstract view
.subckt sky130_fd_sc_hd__o21ai_1 A1 A2 B1 VGND VNB VPB VPWR Y
.ends

* Black-box entry subcircuit for sky130_fd_sc_hd__nand3_1 abstract view
.subckt sky130_fd_sc_hd__nand3_1 A B C VGND VNB VPB VPWR Y
.ends

* Black-box entry subcircuit for sky130_fd_sc_hd__or4b_1 abstract view
.subckt sky130_fd_sc_hd__or4b_1 A B C D_N VGND VNB VPB VPWR X
.ends

* Black-box entry subcircuit for sky130_fd_sc_hd__inv_12 abstract view
.subckt sky130_fd_sc_hd__inv_12 A VGND VNB VPB VPWR Y
.ends

* Black-box entry subcircuit for sky130_fd_sc_hd__o211a_1 abstract view
.subckt sky130_fd_sc_hd__o211a_1 A1 A2 B1 C1 VGND VNB VPB VPWR X
.ends

* Black-box entry subcircuit for sky130_fd_sc_hd__conb_1 abstract view
.subckt sky130_fd_sc_hd__conb_1 VGND VNB VPB VPWR HI LO
.ends

* Black-box entry subcircuit for sky130_fd_sc_hd__diode_2 abstract view
.subckt sky130_fd_sc_hd__diode_2 DIODE VGND VNB VPB VPWR
.ends

* Black-box entry subcircuit for sky130_fd_sc_hd__a311o_1 abstract view
.subckt sky130_fd_sc_hd__a311o_1 A1 A2 A3 B1 C1 VGND VNB VPB VPWR X
.ends

* Black-box entry subcircuit for sky130_fd_sc_hd__nand2b_1 abstract view
.subckt sky130_fd_sc_hd__nand2b_1 A_N B VGND VNB VPB VPWR Y
.ends

* Black-box entry subcircuit for sky130_fd_sc_hd__inv_2 abstract view
.subckt sky130_fd_sc_hd__inv_2 A VGND VNB VPB VPWR Y
.ends

* Black-box entry subcircuit for sky130_fd_sc_hd__or4_2 abstract view
.subckt sky130_fd_sc_hd__or4_2 A B C D VGND VNB VPB VPWR X
.ends

* Black-box entry subcircuit for sky130_fd_sc_hd__o21ba_4 abstract view
.subckt sky130_fd_sc_hd__o21ba_4 A1 A2 B1_N VGND VNB VPB VPWR X
.ends

* Black-box entry subcircuit for sky130_fd_sc_hd__or3_1 abstract view
.subckt sky130_fd_sc_hd__or3_1 A B C VGND VNB VPB VPWR X
.ends

* Black-box entry subcircuit for sky130_fd_sc_hd__or4_1 abstract view
.subckt sky130_fd_sc_hd__or4_1 A B C D VGND VNB VPB VPWR X
.ends

* Black-box entry subcircuit for sky130_fd_sc_hd__xnor2_1 abstract view
.subckt sky130_fd_sc_hd__xnor2_1 A B VGND VNB VPB VPWR Y
.ends

* Black-box entry subcircuit for sky130_fd_sc_hd__nand4_1 abstract view
.subckt sky130_fd_sc_hd__nand4_1 A B C D VGND VNB VPB VPWR Y
.ends

* Black-box entry subcircuit for sky130_fd_sc_hd__a2bb2o_1 abstract view
.subckt sky130_fd_sc_hd__a2bb2o_1 A1_N A2_N B1 B2 VGND VNB VPB VPWR X
.ends

* Black-box entry subcircuit for sky130_fd_sc_hd__clkinv_4 abstract view
.subckt sky130_fd_sc_hd__clkinv_4 A VGND VNB VPB VPWR Y
.ends

* Black-box entry subcircuit for sky130_fd_sc_hd__o221a_1 abstract view
.subckt sky130_fd_sc_hd__o221a_1 A1 A2 B1 B2 C1 VGND VNB VPB VPWR X
.ends

* Black-box entry subcircuit for sky130_fd_sc_hd__clkinv_2 abstract view
.subckt sky130_fd_sc_hd__clkinv_2 A VGND VNB VPB VPWR Y
.ends

* Black-box entry subcircuit for sky130_fd_sc_hd__a2111o_1 abstract view
.subckt sky130_fd_sc_hd__a2111o_1 A1 A2 B1 C1 D1 VGND VNB VPB VPWR X
.ends

* Black-box entry subcircuit for sky130_fd_sc_hd__or3b_2 abstract view
.subckt sky130_fd_sc_hd__or3b_2 A B C_N VGND VNB VPB VPWR X
.ends

* Black-box entry subcircuit for sky130_fd_sc_hd__or3b_4 abstract view
.subckt sky130_fd_sc_hd__or3b_4 A B C_N VGND VNB VPB VPWR X
.ends

* Black-box entry subcircuit for sky130_fd_sc_hd__dfxtp_4 abstract view
.subckt sky130_fd_sc_hd__dfxtp_4 CLK D VGND VNB VPB VPWR Q
.ends

* Black-box entry subcircuit for sky130_fd_sc_hd__nand4b_1 abstract view
.subckt sky130_fd_sc_hd__nand4b_1 A_N B C D VGND VNB VPB VPWR Y
.ends

* Black-box entry subcircuit for sky130_fd_sc_hd__clkinv_8 abstract view
.subckt sky130_fd_sc_hd__clkinv_8 A VGND VNB VPB VPWR Y
.ends

* Black-box entry subcircuit for sky130_fd_sc_hd__inv_6 abstract view
.subckt sky130_fd_sc_hd__inv_6 A VGND VNB VPB VPWR Y
.ends

* Black-box entry subcircuit for sky130_fd_sc_hd__a211oi_1 abstract view
.subckt sky130_fd_sc_hd__a211oi_1 A1 A2 B1 C1 VGND VNB VPB VPWR Y
.ends

* Black-box entry subcircuit for sky130_fd_sc_hd__buf_1 abstract view
.subckt sky130_fd_sc_hd__buf_1 A VGND VNB VPB VPWR X
.ends

* Black-box entry subcircuit for sky130_fd_sc_hd__xor2_1 abstract view
.subckt sky130_fd_sc_hd__xor2_1 A B VGND VNB VPB VPWR X
.ends

* Black-box entry subcircuit for sky130_fd_sc_hd__dlymetal6s2s_1 abstract view
.subckt sky130_fd_sc_hd__dlymetal6s2s_1 A VGND VNB VPB VPWR X
.ends

* Black-box entry subcircuit for sky130_fd_sc_hd__clkinvlp_4 abstract view
.subckt sky130_fd_sc_hd__clkinvlp_4 A VGND VNB VPB VPWR Y
.ends

* Black-box entry subcircuit for sky130_fd_sc_hd__a41o_1 abstract view
.subckt sky130_fd_sc_hd__a41o_1 A1 A2 A3 A4 B1 VGND VNB VPB VPWR X
.ends

* Black-box entry subcircuit for sky130_fd_sc_hd__a21bo_1 abstract view
.subckt sky130_fd_sc_hd__a21bo_1 A1 A2 B1_N VGND VNB VPB VPWR X
.ends

* Black-box entry subcircuit for sky130_fd_sc_hd__and4bb_1 abstract view
.subckt sky130_fd_sc_hd__and4bb_1 A_N B_N C D VGND VNB VPB VPWR X
.ends

* Black-box entry subcircuit for sky130_fd_sc_hd__a2111oi_1 abstract view
.subckt sky130_fd_sc_hd__a2111oi_1 A1 A2 B1 C1 D1 VGND VNB VPB VPWR Y
.ends

* Black-box entry subcircuit for sky130_fd_sc_hd__nor4_1 abstract view
.subckt sky130_fd_sc_hd__nor4_1 A B C D VGND VNB VPB VPWR Y
.ends

* Black-box entry subcircuit for sky130_fd_sc_hd__o21bai_1 abstract view
.subckt sky130_fd_sc_hd__o21bai_1 A1 A2 B1_N VGND VNB VPB VPWR Y
.ends

* Black-box entry subcircuit for sky130_fd_sc_hd__bufinv_16 abstract view
.subckt sky130_fd_sc_hd__bufinv_16 A VGND VNB VPB VPWR Y
.ends

* Black-box entry subcircuit for sky130_fd_sc_hd__inv_8 abstract view
.subckt sky130_fd_sc_hd__inv_8 A VGND VNB VPB VPWR Y
.ends

* Black-box entry subcircuit for sky130_fd_sc_hd__a21boi_1 abstract view
.subckt sky130_fd_sc_hd__a21boi_1 A1 A2 B1_N VGND VNB VPB VPWR Y
.ends

* Black-box entry subcircuit for sky130_fd_sc_hd__a211o_2 abstract view
.subckt sky130_fd_sc_hd__a211o_2 A1 A2 B1 C1 VGND VNB VPB VPWR X
.ends

* Black-box entry subcircuit for sky130_fd_sc_hd__nor3_2 abstract view
.subckt sky130_fd_sc_hd__nor3_2 A B C VGND VNB VPB VPWR Y
.ends

* Black-box entry subcircuit for sky130_fd_sc_hd__a31oi_2 abstract view
.subckt sky130_fd_sc_hd__a31oi_2 A1 A2 A3 B1 VGND VNB VPB VPWR Y
.ends

* Black-box entry subcircuit for sky130_fd_sc_hd__and4bb_2 abstract view
.subckt sky130_fd_sc_hd__and4bb_2 A_N B_N C D VGND VNB VPB VPWR X
.ends

* Black-box entry subcircuit for sky130_fd_sc_hd__nor2_4 abstract view
.subckt sky130_fd_sc_hd__nor2_4 A B VGND VNB VPB VPWR Y
.ends

* Black-box entry subcircuit for sky130_fd_sc_hd__o211ai_1 abstract view
.subckt sky130_fd_sc_hd__o211ai_1 A1 A2 B1 C1 VGND VNB VPB VPWR Y
.ends

* Black-box entry subcircuit for sky130_fd_sc_hd__o2bb2a_1 abstract view
.subckt sky130_fd_sc_hd__o2bb2a_1 A1_N A2_N B1 B2 VGND VNB VPB VPWR X
.ends

* Black-box entry subcircuit for sky130_fd_sc_hd__o311ai_4 abstract view
.subckt sky130_fd_sc_hd__o311ai_4 A1 A2 A3 B1 C1 VGND VNB VPB VPWR Y
.ends

* Black-box entry subcircuit for sky130_fd_sc_hd__o21ai_2 abstract view
.subckt sky130_fd_sc_hd__o21ai_2 A1 A2 B1 VGND VNB VPB VPWR Y
.ends

* Black-box entry subcircuit for sky130_fd_sc_hd__o32a_1 abstract view
.subckt sky130_fd_sc_hd__o32a_1 A1 A2 A3 B1 B2 VGND VNB VPB VPWR X
.ends

* Black-box entry subcircuit for sky130_fd_sc_hd__a21o_2 abstract view
.subckt sky130_fd_sc_hd__a21o_2 A1 A2 B1 VGND VNB VPB VPWR X
.ends

* Black-box entry subcircuit for sky130_fd_sc_hd__clkbuf_16 abstract view
.subckt sky130_fd_sc_hd__clkbuf_16 A VGND VNB VPB VPWR X
.ends

* Black-box entry subcircuit for sky130_fd_sc_hd__nor2_8 abstract view
.subckt sky130_fd_sc_hd__nor2_8 A B VGND VNB VPB VPWR Y
.ends

* Black-box entry subcircuit for sky130_fd_sc_hd__o211ai_2 abstract view
.subckt sky130_fd_sc_hd__o211ai_2 A1 A2 B1 C1 VGND VNB VPB VPWR Y
.ends

* Black-box entry subcircuit for sky130_fd_sc_hd__nand3_4 abstract view
.subckt sky130_fd_sc_hd__nand3_4 A B C VGND VNB VPB VPWR Y
.ends

* Black-box entry subcircuit for sky130_fd_sc_hd__and2_2 abstract view
.subckt sky130_fd_sc_hd__and2_2 A B VGND VNB VPB VPWR X
.ends

* Black-box entry subcircuit for sky130_fd_sc_hd__and4b_1 abstract view
.subckt sky130_fd_sc_hd__and4b_1 A_N B C D VGND VNB VPB VPWR X
.ends

* Black-box entry subcircuit for sky130_fd_sc_hd__or3_4 abstract view
.subckt sky130_fd_sc_hd__or3_4 A B C VGND VNB VPB VPWR X
.ends

* Black-box entry subcircuit for sky130_fd_sc_hd__and3_2 abstract view
.subckt sky130_fd_sc_hd__and3_2 A B C VGND VNB VPB VPWR X
.ends

* Black-box entry subcircuit for sky130_fd_sc_hd__nor3_1 abstract view
.subckt sky130_fd_sc_hd__nor3_1 A B C VGND VNB VPB VPWR Y
.ends

* Black-box entry subcircuit for sky130_fd_sc_hd__o21ba_1 abstract view
.subckt sky130_fd_sc_hd__o21ba_1 A1 A2 B1_N VGND VNB VPB VPWR X
.ends

* Black-box entry subcircuit for sky130_fd_sc_hd__o2111a_1 abstract view
.subckt sky130_fd_sc_hd__o2111a_1 A1 A2 B1 C1 D1 VGND VNB VPB VPWR X
.ends

* Black-box entry subcircuit for sky130_fd_sc_hd__and4_2 abstract view
.subckt sky130_fd_sc_hd__and4_2 A B C D VGND VNB VPB VPWR X
.ends

* Black-box entry subcircuit for sky130_fd_sc_hd__mux2_4 abstract view
.subckt sky130_fd_sc_hd__mux2_4 A0 A1 S VGND VNB VPB VPWR X
.ends

* Black-box entry subcircuit for sky130_fd_sc_hd__or4_4 abstract view
.subckt sky130_fd_sc_hd__or4_4 A B C D VGND VNB VPB VPWR X
.ends

* Black-box entry subcircuit for sky130_fd_sc_hd__o2111ai_2 abstract view
.subckt sky130_fd_sc_hd__o2111ai_2 A1 A2 B1 C1 D1 VGND VNB VPB VPWR Y
.ends

* Black-box entry subcircuit for sky130_fd_sc_hd__nand2_2 abstract view
.subckt sky130_fd_sc_hd__nand2_2 A B VGND VNB VPB VPWR Y
.ends

* Black-box entry subcircuit for sky130_fd_sc_hd__nand3b_2 abstract view
.subckt sky130_fd_sc_hd__nand3b_2 A_N B C VGND VNB VPB VPWR Y
.ends

* Black-box entry subcircuit for sky130_fd_sc_hd__nor4_2 abstract view
.subckt sky130_fd_sc_hd__nor4_2 A B C D VGND VNB VPB VPWR Y
.ends

* Black-box entry subcircuit for sky130_fd_sc_hd__nand2_4 abstract view
.subckt sky130_fd_sc_hd__nand2_4 A B VGND VNB VPB VPWR Y
.ends

* Black-box entry subcircuit for sky130_fd_sc_hd__mux4_2 abstract view
.subckt sky130_fd_sc_hd__mux4_2 A0 A1 A2 A3 S0 S1 VGND VNB VPB VPWR X
.ends

* Black-box entry subcircuit for sky130_fd_sc_hd__a221oi_2 abstract view
.subckt sky130_fd_sc_hd__a221oi_2 A1 A2 B1 B2 C1 VGND VNB VPB VPWR Y
.ends

* Black-box entry subcircuit for sky130_fd_sc_hd__o2111ai_4 abstract view
.subckt sky130_fd_sc_hd__o2111ai_4 A1 A2 B1 C1 D1 VGND VNB VPB VPWR Y
.ends

* Black-box entry subcircuit for sky130_fd_sc_hd__nand3b_4 abstract view
.subckt sky130_fd_sc_hd__nand3b_4 A_N B C VGND VNB VPB VPWR Y
.ends

* Black-box entry subcircuit for sky130_fd_sc_hd__o41a_1 abstract view
.subckt sky130_fd_sc_hd__o41a_1 A1 A2 A3 A4 B1 VGND VNB VPB VPWR X
.ends

* Black-box entry subcircuit for sky130_fd_sc_hd__a31oi_1 abstract view
.subckt sky130_fd_sc_hd__a31oi_1 A1 A2 A3 B1 VGND VNB VPB VPWR Y
.ends

* Black-box entry subcircuit for sky130_fd_sc_hd__or4bb_1 abstract view
.subckt sky130_fd_sc_hd__or4bb_1 A B C_N D_N VGND VNB VPB VPWR X
.ends

* Black-box entry subcircuit for sky130_fd_sc_hd__o21bai_2 abstract view
.subckt sky130_fd_sc_hd__o21bai_2 A1 A2 B1_N VGND VNB VPB VPWR Y
.ends

* Black-box entry subcircuit for sky130_fd_sc_hd__a221oi_1 abstract view
.subckt sky130_fd_sc_hd__a221oi_1 A1 A2 B1 B2 C1 VGND VNB VPB VPWR Y
.ends

* Black-box entry subcircuit for sky130_fd_sc_hd__a311oi_2 abstract view
.subckt sky130_fd_sc_hd__a311oi_2 A1 A2 A3 B1 C1 VGND VNB VPB VPWR Y
.ends

* Black-box entry subcircuit for sky130_fd_sc_hd__o311a_1 abstract view
.subckt sky130_fd_sc_hd__o311a_1 A1 A2 A3 B1 C1 VGND VNB VPB VPWR X
.ends

* Black-box entry subcircuit for sky130_fd_sc_hd__a31o_2 abstract view
.subckt sky130_fd_sc_hd__a31o_2 A1 A2 A3 B1 VGND VNB VPB VPWR X
.ends

* Black-box entry subcircuit for sky130_fd_sc_hd__o22ai_1 abstract view
.subckt sky130_fd_sc_hd__o22ai_1 A1 A2 B1 B2 VGND VNB VPB VPWR Y
.ends

* Black-box entry subcircuit for sky130_fd_sc_hd__nand3_2 abstract view
.subckt sky130_fd_sc_hd__nand3_2 A B C VGND VNB VPB VPWR Y
.ends

* Black-box entry subcircuit for sky130_fd_sc_hd__nand3b_1 abstract view
.subckt sky130_fd_sc_hd__nand3b_1 A_N B C VGND VNB VPB VPWR Y
.ends

* Black-box entry subcircuit for sky130_fd_sc_hd__a211oi_2 abstract view
.subckt sky130_fd_sc_hd__a211oi_2 A1 A2 B1 C1 VGND VNB VPB VPWR Y
.ends

* Black-box entry subcircuit for sky130_fd_sc_hd__o221ai_1 abstract view
.subckt sky130_fd_sc_hd__o221ai_1 A1 A2 B1 B2 C1 VGND VNB VPB VPWR Y
.ends

* Black-box entry subcircuit for sky130_fd_sc_hd__buf_6 abstract view
.subckt sky130_fd_sc_hd__buf_6 A VGND VNB VPB VPWR X
.ends

* Black-box entry subcircuit for sky130_fd_sc_hd__a311oi_1 abstract view
.subckt sky130_fd_sc_hd__a311oi_1 A1 A2 A3 B1 C1 VGND VNB VPB VPWR Y
.ends

* Black-box entry subcircuit for sky130_fd_sc_hd__o21ai_4 abstract view
.subckt sky130_fd_sc_hd__o21ai_4 A1 A2 B1 VGND VNB VPB VPWR Y
.ends

* Black-box entry subcircuit for sky130_fd_sc_hd__o31ai_2 abstract view
.subckt sky130_fd_sc_hd__o31ai_2 A1 A2 A3 B1 VGND VNB VPB VPWR Y
.ends

* Black-box entry subcircuit for sky130_fd_sc_hd__and2_4 abstract view
.subckt sky130_fd_sc_hd__and2_4 A B VGND VNB VPB VPWR X
.ends

.subckt picorv32_axi VGND VPWR clk eoi[0] eoi[10] eoi[11] eoi[12] eoi[13] eoi[14]
+ eoi[15] eoi[16] eoi[17] eoi[18] eoi[19] eoi[1] eoi[20] eoi[21] eoi[22] eoi[23] eoi[24]
+ eoi[25] eoi[26] eoi[27] eoi[28] eoi[29] eoi[2] eoi[30] eoi[31] eoi[3] eoi[4] eoi[5]
+ eoi[6] eoi[7] eoi[8] eoi[9] irq[0] irq[10] irq[11] irq[12] irq[13] irq[14] irq[15]
+ irq[16] irq[17] irq[18] irq[19] irq[1] irq[20] irq[21] irq[22] irq[23] irq[24] irq[25]
+ irq[26] irq[27] irq[28] irq[29] irq[2] irq[30] irq[31] irq[3] irq[4] irq[5] irq[6]
+ irq[7] irq[8] irq[9] mem_axi_araddr[0] mem_axi_araddr[10] mem_axi_araddr[11] mem_axi_araddr[12]
+ mem_axi_araddr[13] mem_axi_araddr[14] mem_axi_araddr[15] mem_axi_araddr[16] mem_axi_araddr[17]
+ mem_axi_araddr[18] mem_axi_araddr[19] mem_axi_araddr[1] mem_axi_araddr[20] mem_axi_araddr[21]
+ mem_axi_araddr[22] mem_axi_araddr[23] mem_axi_araddr[24] mem_axi_araddr[25] mem_axi_araddr[26]
+ mem_axi_araddr[27] mem_axi_araddr[28] mem_axi_araddr[29] mem_axi_araddr[2] mem_axi_araddr[30]
+ mem_axi_araddr[31] mem_axi_araddr[3] mem_axi_araddr[4] mem_axi_araddr[5] mem_axi_araddr[6]
+ mem_axi_araddr[7] mem_axi_araddr[8] mem_axi_araddr[9] mem_axi_arprot[0] mem_axi_arprot[1]
+ mem_axi_arprot[2] mem_axi_arready mem_axi_arvalid mem_axi_awaddr[0] mem_axi_awaddr[10]
+ mem_axi_awaddr[11] mem_axi_awaddr[12] mem_axi_awaddr[13] mem_axi_awaddr[14] mem_axi_awaddr[15]
+ mem_axi_awaddr[16] mem_axi_awaddr[17] mem_axi_awaddr[18] mem_axi_awaddr[19] mem_axi_awaddr[1]
+ mem_axi_awaddr[20] mem_axi_awaddr[21] mem_axi_awaddr[22] mem_axi_awaddr[23] mem_axi_awaddr[24]
+ mem_axi_awaddr[25] mem_axi_awaddr[26] mem_axi_awaddr[27] mem_axi_awaddr[28] mem_axi_awaddr[29]
+ mem_axi_awaddr[2] mem_axi_awaddr[30] mem_axi_awaddr[31] mem_axi_awaddr[3] mem_axi_awaddr[4]
+ mem_axi_awaddr[5] mem_axi_awaddr[6] mem_axi_awaddr[7] mem_axi_awaddr[8] mem_axi_awaddr[9]
+ mem_axi_awprot[0] mem_axi_awprot[1] mem_axi_awprot[2] mem_axi_awready mem_axi_awvalid
+ mem_axi_bready mem_axi_bvalid mem_axi_rdata[0] mem_axi_rdata[10] mem_axi_rdata[11]
+ mem_axi_rdata[12] mem_axi_rdata[13] mem_axi_rdata[14] mem_axi_rdata[15] mem_axi_rdata[16]
+ mem_axi_rdata[17] mem_axi_rdata[18] mem_axi_rdata[19] mem_axi_rdata[1] mem_axi_rdata[20]
+ mem_axi_rdata[21] mem_axi_rdata[22] mem_axi_rdata[23] mem_axi_rdata[24] mem_axi_rdata[25]
+ mem_axi_rdata[26] mem_axi_rdata[27] mem_axi_rdata[28] mem_axi_rdata[29] mem_axi_rdata[2]
+ mem_axi_rdata[30] mem_axi_rdata[31] mem_axi_rdata[3] mem_axi_rdata[4] mem_axi_rdata[5]
+ mem_axi_rdata[6] mem_axi_rdata[7] mem_axi_rdata[8] mem_axi_rdata[9] mem_axi_rready
+ mem_axi_rvalid mem_axi_wdata[0] mem_axi_wdata[10] mem_axi_wdata[11] mem_axi_wdata[12]
+ mem_axi_wdata[13] mem_axi_wdata[14] mem_axi_wdata[15] mem_axi_wdata[16] mem_axi_wdata[17]
+ mem_axi_wdata[18] mem_axi_wdata[19] mem_axi_wdata[1] mem_axi_wdata[20] mem_axi_wdata[21]
+ mem_axi_wdata[22] mem_axi_wdata[23] mem_axi_wdata[24] mem_axi_wdata[25] mem_axi_wdata[26]
+ mem_axi_wdata[27] mem_axi_wdata[28] mem_axi_wdata[29] mem_axi_wdata[2] mem_axi_wdata[30]
+ mem_axi_wdata[31] mem_axi_wdata[3] mem_axi_wdata[4] mem_axi_wdata[5] mem_axi_wdata[6]
+ mem_axi_wdata[7] mem_axi_wdata[8] mem_axi_wdata[9] mem_axi_wready mem_axi_wstrb[0]
+ mem_axi_wstrb[1] mem_axi_wstrb[2] mem_axi_wstrb[3] mem_axi_wvalid pcpi_insn[0] pcpi_insn[10]
+ pcpi_insn[11] pcpi_insn[12] pcpi_insn[13] pcpi_insn[14] pcpi_insn[15] pcpi_insn[16]
+ pcpi_insn[17] pcpi_insn[18] pcpi_insn[19] pcpi_insn[1] pcpi_insn[20] pcpi_insn[21]
+ pcpi_insn[22] pcpi_insn[23] pcpi_insn[24] pcpi_insn[25] pcpi_insn[26] pcpi_insn[27]
+ pcpi_insn[28] pcpi_insn[29] pcpi_insn[2] pcpi_insn[30] pcpi_insn[31] pcpi_insn[3]
+ pcpi_insn[4] pcpi_insn[5] pcpi_insn[6] pcpi_insn[7] pcpi_insn[8] pcpi_insn[9] pcpi_rd[0]
+ pcpi_rd[10] pcpi_rd[11] pcpi_rd[12] pcpi_rd[13] pcpi_rd[14] pcpi_rd[15] pcpi_rd[16]
+ pcpi_rd[17] pcpi_rd[18] pcpi_rd[19] pcpi_rd[1] pcpi_rd[20] pcpi_rd[21] pcpi_rd[22]
+ pcpi_rd[23] pcpi_rd[24] pcpi_rd[25] pcpi_rd[26] pcpi_rd[27] pcpi_rd[28] pcpi_rd[29]
+ pcpi_rd[2] pcpi_rd[30] pcpi_rd[31] pcpi_rd[3] pcpi_rd[4] pcpi_rd[5] pcpi_rd[6] pcpi_rd[7]
+ pcpi_rd[8] pcpi_rd[9] pcpi_ready pcpi_rs1[0] pcpi_rs1[10] pcpi_rs1[11] pcpi_rs1[12]
+ pcpi_rs1[13] pcpi_rs1[14] pcpi_rs1[15] pcpi_rs1[16] pcpi_rs1[17] pcpi_rs1[18] pcpi_rs1[19]
+ pcpi_rs1[1] pcpi_rs1[20] pcpi_rs1[21] pcpi_rs1[22] pcpi_rs1[23] pcpi_rs1[24] pcpi_rs1[25]
+ pcpi_rs1[26] pcpi_rs1[27] pcpi_rs1[28] pcpi_rs1[29] pcpi_rs1[2] pcpi_rs1[30] pcpi_rs1[31]
+ pcpi_rs1[3] pcpi_rs1[4] pcpi_rs1[5] pcpi_rs1[6] pcpi_rs1[7] pcpi_rs1[8] pcpi_rs1[9]
+ pcpi_rs2[0] pcpi_rs2[10] pcpi_rs2[11] pcpi_rs2[12] pcpi_rs2[13] pcpi_rs2[14] pcpi_rs2[15]
+ pcpi_rs2[16] pcpi_rs2[17] pcpi_rs2[18] pcpi_rs2[19] pcpi_rs2[1] pcpi_rs2[20] pcpi_rs2[21]
+ pcpi_rs2[22] pcpi_rs2[23] pcpi_rs2[24] pcpi_rs2[25] pcpi_rs2[26] pcpi_rs2[27] pcpi_rs2[28]
+ pcpi_rs2[29] pcpi_rs2[2] pcpi_rs2[30] pcpi_rs2[31] pcpi_rs2[3] pcpi_rs2[4] pcpi_rs2[5]
+ pcpi_rs2[6] pcpi_rs2[7] pcpi_rs2[8] pcpi_rs2[9] pcpi_valid pcpi_wait pcpi_wr resetn
+ trace_data[0] trace_data[10] trace_data[11] trace_data[12] trace_data[13] trace_data[14]
+ trace_data[15] trace_data[16] trace_data[17] trace_data[18] trace_data[19] trace_data[1]
+ trace_data[20] trace_data[21] trace_data[22] trace_data[23] trace_data[24] trace_data[25]
+ trace_data[26] trace_data[27] trace_data[28] trace_data[29] trace_data[2] trace_data[30]
+ trace_data[31] trace_data[32] trace_data[33] trace_data[34] trace_data[35] trace_data[3]
+ trace_data[4] trace_data[5] trace_data[6] trace_data[7] trace_data[8] trace_data[9]
+ trace_valid trap
XFILLER_79_391 VGND VGND VPWR VPWR sky130_fd_sc_hd__fill_1
X_05903_ _02331_ _02374_ net672 VGND VGND VPWR VPWR _02375_ sky130_fd_sc_hd__o21a_1
X_09671_ net470 _04783_ _04847_ _04846_ VGND VGND VPWR VPWR _04848_ sky130_fd_sc_hd__a31o_1
X_06883_ _03102_ _03103_ VGND VGND VPWR VPWR _03104_ sky130_fd_sc_hd__nor2_1
XFILLER_94_383 VGND VGND VPWR VPWR sky130_fd_sc_hd__fill_1
XFILLER_55_748 VPWR VGND VPWR VGND sky130_ef_sc_hd__decap_12
XFILLER_54_214 VGND VGND VPWR VPWR sky130_fd_sc_hd__fill_2
X_08622_ net1756 net504 net391 VGND VGND VPWR VPWR _00773_ sky130_fd_sc_hd__mux2_1
XFILLER_27_428 VGND VGND VPWR VPWR sky130_fd_sc_hd__decap_4
X_05834_ net809 _02310_ VGND VGND VPWR VPWR _02312_ sky130_fd_sc_hd__or2_1
X_05765_ picorv32_core.instr_xor picorv32_core.instr_xori VGND VGND VPWR VPWR _02249_
+ sky130_fd_sc_hd__or2_2
X_08553_ net466 net1374 net399 VGND VGND VPWR VPWR _00678_ sky130_fd_sc_hd__mux2_1
X_07504_ net780 _03623_ net533 VGND VGND VPWR VPWR _03624_ sky130_fd_sc_hd__mux2_1
X_08484_ net1280 net465 net407 VGND VGND VPWR VPWR _00614_ sky130_fd_sc_hd__mux2_1
X_05696_ _02176_ _02177_ _02178_ _02179_ _02175_ VGND VGND VPWR VPWR _02180_ sky130_fd_sc_hd__a221o_1
X_07435_ picorv32_core.instr_lui picorv32_core.is_lui_auipc_jal VGND VGND VPWR VPWR
+ _03575_ sky130_fd_sc_hd__and2b_1
XFILLER_52_29 VGND VGND VPWR VPWR sky130_fd_sc_hd__decap_6
XFILLER_10_306 VGND VGND VPWR VPWR sky130_fd_sc_hd__fill_2
XTAP_TAPCELL_ROW_98_1723 VGND VPWR sky130_fd_sc_hd__tapvpwrvgnd_1
X_07366_ net783 picorv32_core.decoded_imm\[19\] VGND VGND VPWR VPWR _03506_ sky130_fd_sc_hd__nor2_1
X_09105_ net251 net1802 net334 VGND VGND VPWR VPWR _01272_ sky130_fd_sc_hd__mux2_1
X_06317_ _02724_ _02727_ net565 VGND VGND VPWR VPWR _02728_ sky130_fd_sc_hd__mux2_2
X_07297_ net801 picorv32_core.decoded_imm\[10\] VGND VGND VPWR VPWR _03437_ sky130_fd_sc_hd__nand2_1
X_09036_ net266 net1989 net342 VGND VGND VPWR VPWR _01205_ sky130_fd_sc_hd__mux2_1
X_06248_ net1996 net499 net434 VGND VGND VPWR VPWR _00040_ sky130_fd_sc_hd__mux2_1
Xhold362 picorv32_core.cpuregs\[7\]\[26\] VGND VGND VPWR VPWR net1471 sky130_fd_sc_hd__dlygate4sd3_1
XFILLER_132_720 VPWR VGND VPWR VGND sky130_ef_sc_hd__decap_12
XFILLER_117_783 VGND VGND VPWR VPWR sky130_fd_sc_hd__fill_1
XFILLER_89_111 VGND VGND VPWR VPWR sky130_fd_sc_hd__fill_1
Xhold340 picorv32_core.cpuregs\[13\]\[6\] VGND VGND VPWR VPWR net1449 sky130_fd_sc_hd__dlygate4sd3_1
Xhold351 picorv32_core.cpuregs\[24\]\[1\] VGND VGND VPWR VPWR net1460 sky130_fd_sc_hd__dlygate4sd3_1
X_06179_ picorv32_core.decoded_imm_j\[3\] picorv32_core.decoded_imm_j\[4\] _02610_
+ VGND VGND VPWR VPWR _02611_ sky130_fd_sc_hd__nor3_4
Xhold373 picorv32_core.cpuregs\[21\]\[28\] VGND VGND VPWR VPWR net1482 sky130_fd_sc_hd__dlygate4sd3_1
Xhold395 picorv32_core.cpuregs\[14\]\[30\] VGND VGND VPWR VPWR net1504 sky130_fd_sc_hd__dlygate4sd3_1
Xhold384 net60 VGND VGND VPWR VPWR net1493 sky130_fd_sc_hd__dlygate4sd3_1
XFILLER_104_433 VGND VGND VPWR VPWR sky130_fd_sc_hd__decap_4
XFILLER_2_549 VGND VGND VPWR VPWR sky130_fd_sc_hd__fill_2
XFILLER_104_477 VGND VGND VPWR VPWR sky130_fd_sc_hd__decap_6
XFILLER_77_306 VGND VGND VPWR VPWR sky130_fd_sc_hd__fill_1
Xfanout820 net821 VGND VGND VPWR VPWR net820 sky130_fd_sc_hd__buf_2
Xfanout842 net843 VGND VGND VPWR VPWR net842 sky130_fd_sc_hd__clkbuf_4
Xfanout831 net834 VGND VGND VPWR VPWR net831 sky130_fd_sc_hd__clkbuf_4
X_09938_ net2022 net474 _05036_ _05038_ VGND VGND VPWR VPWR _01417_ sky130_fd_sc_hd__a22o_1
Xfanout864 net865 VGND VGND VPWR VPWR net864 sky130_fd_sc_hd__clkbuf_4
XTAP_TAPCELL_ROW_51_1041 VGND VPWR sky130_fd_sc_hd__tapvpwrvgnd_1
Xfanout875 net876 VGND VGND VPWR VPWR net875 sky130_fd_sc_hd__buf_4
Xfanout853 net854 VGND VGND VPWR VPWR net853 sky130_fd_sc_hd__clkbuf_4
XTAP_TAPCELL_ROW_125_2119 VGND VPWR sky130_fd_sc_hd__tapvpwrvgnd_1
Xfanout897 net899 VGND VGND VPWR VPWR net897 sky130_fd_sc_hd__buf_4
Xhold1040 picorv32_core.cpuregs\[5\]\[14\] VGND VGND VPWR VPWR net2149 sky130_fd_sc_hd__dlygate4sd3_1
XTAP_TAPCELL_ROW_5_376 VGND VPWR sky130_fd_sc_hd__tapvpwrvgnd_1
Xfanout886 net888 VGND VGND VPWR VPWR net886 sky130_fd_sc_hd__clkbuf_4
X_09869_ net1631 net429 net324 VGND VGND VPWR VPWR _01357_ sky130_fd_sc_hd__mux2_1
Xhold1051 axi_adapter.xfer_done VGND VGND VPWR VPWR net2160 sky130_fd_sc_hd__dlygate4sd3_1
Xhold1084 picorv32_core.cpuregs\[18\]\[0\] VGND VGND VPWR VPWR net2193 sky130_fd_sc_hd__dlygate4sd3_1
Xhold1073 picorv32_core.cpuregs\[16\]\[4\] VGND VGND VPWR VPWR net2182 sky130_fd_sc_hd__dlygate4sd3_1
Xhold1062 picorv32_core.cpuregs\[18\]\[10\] VGND VGND VPWR VPWR net2171 sky130_fd_sc_hd__dlygate4sd3_1
XFILLER_45_225 VGND VGND VPWR VPWR sky130_fd_sc_hd__fill_2
XFILLER_45_236 VGND VGND VPWR VPWR sky130_fd_sc_hd__decap_3
XTAP_TAPCELL_ROW_107_1852 VGND VPWR sky130_fd_sc_hd__tapvpwrvgnd_1
Xhold1095 picorv32_core.cpuregs\[16\]\[19\] VGND VGND VPWR VPWR net2204 sky130_fd_sc_hd__dlygate4sd3_1
X_11831_ net64 VGND VGND VPWR VPWR net96 sky130_fd_sc_hd__clkbuf_1
XFILLER_45_247 VGND VGND VPWR VPWR sky130_fd_sc_hd__fill_1
XTAP_TAPCELL_ROW_107_1863 VGND VPWR sky130_fd_sc_hd__tapvpwrvgnd_1
XFILLER_61_729 VGND VGND VPWR VPWR sky130_fd_sc_hd__fill_1
XTAP_TAPCELL_ROW_44_938 VGND VPWR sky130_fd_sc_hd__tapvpwrvgnd_1
XTAP_TAPCELL_ROW_44_949 VGND VPWR sky130_fd_sc_hd__tapvpwrvgnd_1
XFILLER_13_111 VGND VGND VPWR VPWR sky130_fd_sc_hd__fill_1
X_10713_ clknet_leaf_27_clk _00564_ VGND VGND VPWR VPWR net119 sky130_fd_sc_hd__dfxtp_1
XFILLER_13_166 VGND VGND VPWR VPWR sky130_fd_sc_hd__fill_2
XTAP_TAPCELL_ROW_24_651 VGND VPWR sky130_fd_sc_hd__tapvpwrvgnd_1
X_11693_ clknet_leaf_1_clk _01524_ VGND VGND VPWR VPWR picorv32_core.cpuregs\[27\]\[10\]
+ sky130_fd_sc_hd__dfxtp_1
X_10644_ clknet_leaf_7_clk _00498_ VGND VGND VPWR VPWR picorv32_core.cpuregs\[20\]\[12\]
+ sky130_fd_sc_hd__dfxtp_1
XFILLER_127_503 VGND VGND VPWR VPWR sky130_fd_sc_hd__fill_1
X_10575_ clknet_leaf_60_clk _00429_ VGND VGND VPWR VPWR picorv32_core.cpuregs\[25\]\[31\]
+ sky130_fd_sc_hd__dfxtp_1
XFILLER_6_811 VGND VGND VPWR VPWR sky130_fd_sc_hd__fill_1
XFILLER_6_833 VGND VGND VPWR VPWR sky130_fd_sc_hd__fill_1
XFILLER_54_9 VGND VGND VPWR VPWR sky130_fd_sc_hd__decap_3
XFILLER_123_753 VPWR VGND VPWR VGND sky130_ef_sc_hd__decap_12
XFILLER_123_797 VPWR VGND VPWR VGND sky130_ef_sc_hd__decap_12
XFILLER_96_615 VGND VGND VPWR VPWR sky130_fd_sc_hd__fill_1
X_11127_ clknet_leaf_16_clk _00978_ VGND VGND VPWR VPWR picorv32_core.cpuregs\[8\]\[13\]
+ sky130_fd_sc_hd__dfxtp_1
XFILLER_95_169 VGND VGND VPWR VPWR sky130_fd_sc_hd__decap_4
XTAP_TAPCELL_ROW_69_1302 VGND VPWR sky130_fd_sc_hd__tapvpwrvgnd_1
XFILLER_64_501 VPWR VGND VPWR VGND sky130_ef_sc_hd__decap_12
X_11058_ clknet_leaf_13_clk _00909_ VGND VGND VPWR VPWR picorv32_core.cpuregs\[10\]\[8\]
+ sky130_fd_sc_hd__dfxtp_1
X_10009_ net1298 net494 net309 VGND VGND VPWR VPWR _01485_ sky130_fd_sc_hd__mux2_1
X_05550_ net922 _02034_ _02035_ _02041_ VGND VGND VPWR VPWR _01563_ sky130_fd_sc_hd__a31o_1
X_05481_ net923 _01971_ _01977_ VGND VGND VPWR VPWR _01557_ sky130_fd_sc_hd__a21o_1
X_07220_ picorv32_core.count_cycle\[52\] picorv32_core.count_cycle\[53\] picorv32_core.count_cycle\[54\]
+ _03365_ VGND VGND VPWR VPWR _03370_ sky130_fd_sc_hd__and4_1
X_07151_ net2323 _03324_ _03326_ VGND VGND VPWR VPWR _00289_ sky130_fd_sc_hd__o21a_1
X_06102_ net768 net192 net569 _02558_ VGND VGND VPWR VPWR _02559_ sky130_fd_sc_hd__a31o_1
XFILLER_9_682 VGND VGND VPWR VPWR sky130_fd_sc_hd__decap_4
XFILLER_8_170 VPWR VGND VPWR VGND sky130_ef_sc_hd__decap_12
X_07082_ _03283_ net983 _03282_ VGND VGND VPWR VPWR _00263_ sky130_fd_sc_hd__and3b_1
XFILLER_105_219 VGND VGND VPWR VPWR sky130_fd_sc_hd__decap_4
XTAP_TAPCELL_ROW_93_1653 VGND VPWR sky130_fd_sc_hd__tapvpwrvgnd_1
X_06033_ net955 net186 _02469_ net670 VGND VGND VPWR VPWR _02495_ sky130_fd_sc_hd__o31a_1
XFILLER_113_274 VGND VGND VPWR VPWR sky130_fd_sc_hd__decap_6
X_07984_ picorv32_core.cpuregs\[4\]\[26\] picorv32_core.cpuregs\[5\]\[26\] picorv32_core.cpuregs\[6\]\[26\]
+ picorv32_core.cpuregs\[7\]\[26\] net760 net727 VGND VGND VPWR VPWR _04063_ sky130_fd_sc_hd__mux4_1
X_09723_ picorv32_core.cpuregs\[4\]\[24\] picorv32_core.cpuregs\[5\]\[24\] picorv32_core.cpuregs\[6\]\[24\]
+ picorv32_core.cpuregs\[7\]\[24\] net894 net860 VGND VGND VPWR VPWR _04898_ sky130_fd_sc_hd__mux4_1
X_06935_ _03150_ _03151_ net994 VGND VGND VPWR VPWR _00248_ sky130_fd_sc_hd__o21a_1
X_09654_ picorv32_core.cpuregs\[4\]\[21\] picorv32_core.cpuregs\[5\]\[21\] picorv32_core.cpuregs\[6\]\[21\]
+ picorv32_core.cpuregs\[7\]\[21\] net897 net863 VGND VGND VPWR VPWR _04832_ sky130_fd_sc_hd__mux4_1
XFILLER_95_692 VGND VGND VPWR VPWR sky130_fd_sc_hd__fill_1
X_06866_ _02925_ _03062_ _02926_ VGND VGND VPWR VPWR _03088_ sky130_fd_sc_hd__a21oi_1
XTAP_TAPCELL_ROW_2_335 VGND VPWR sky130_fd_sc_hd__tapvpwrvgnd_1
X_08605_ net245 net2239 net396 VGND VGND VPWR VPWR _00728_ sky130_fd_sc_hd__mux2_1
XFILLER_103_57 VGND VGND VPWR VPWR sky130_fd_sc_hd__decap_3
XFILLER_94_191 VGND VGND VPWR VPWR sky130_fd_sc_hd__fill_2
X_05817_ net811 _02295_ VGND VGND VPWR VPWR _02296_ sky130_fd_sc_hd__and2_1
X_09585_ picorv32_core.cpuregs\[28\]\[18\] picorv32_core.cpuregs\[29\]\[18\] picorv32_core.cpuregs\[30\]\[18\]
+ picorv32_core.cpuregs\[31\]\[18\] net892 net858 VGND VGND VPWR VPWR _04766_ sky130_fd_sc_hd__mux4_1
XFILLER_70_515 VGND VGND VPWR VPWR sky130_fd_sc_hd__fill_1
XFILLER_63_28 VGND VGND VPWR VPWR sky130_fd_sc_hd__decap_4
X_06797_ _02988_ _03002_ _03017_ _02999_ _03016_ VGND VGND VPWR VPWR _03024_ sky130_fd_sc_hd__a221o_1
XTAP_TAPCELL_ROW_120_2049 VGND VPWR sky130_fd_sc_hd__tapvpwrvgnd_1
XTAP_TAPCELL_ROW_120_2038 VGND VPWR sky130_fd_sc_hd__tapvpwrvgnd_1
X_08536_ net2047 net244 net404 VGND VGND VPWR VPWR _00663_ sky130_fd_sc_hd__mux2_1
X_05748_ net785 _02144_ net182 VGND VGND VPWR VPWR _02232_ sky130_fd_sc_hd__or3b_1
X_05679_ net971 net197 VGND VGND VPWR VPWR _02163_ sky130_fd_sc_hd__nand2_1
X_08467_ net674 picorv32_core.decoded_imm_j\[4\] _04227_ picorv32_core.mem_rdata_q\[24\]
+ net525 VGND VGND VPWR VPWR _04315_ sky130_fd_sc_hd__a221o_1
X_07418_ net833 _03550_ _03557_ net829 VGND VGND VPWR VPWR _03558_ sky130_fd_sc_hd__a211o_1
XTAP_TAPCELL_ROW_102_1782 VGND VPWR sky130_fd_sc_hd__tapvpwrvgnd_1
XFILLER_10_103 VGND VGND VPWR VPWR sky130_fd_sc_hd__decap_4
X_08398_ net1373 net461 _04275_ _03583_ VGND VGND VPWR VPWR _00576_ sky130_fd_sc_hd__o22a_1
XTAP_TAPCELL_ROW_21_610 VGND VPWR sky130_fd_sc_hd__tapvpwrvgnd_1
X_07349_ _03429_ _03488_ _03427_ VGND VGND VPWR VPWR _03489_ sky130_fd_sc_hd__a21o_1
XFILLER_136_322 VGND VGND VPWR VPWR sky130_fd_sc_hd__fill_1
X_10360_ clknet_leaf_82_clk _00279_ VGND VGND VPWR VPWR picorv32_core.count_cycle\[18\]
+ sky130_fd_sc_hd__dfxtp_1
XFILLER_12_65 VPWR VGND VPWR VGND sky130_ef_sc_hd__decap_12
XFILLER_128_65 VPWR VGND VPWR VGND sky130_ef_sc_hd__decap_12
X_10291_ clknet_leaf_90_clk _00210_ VGND VGND VPWR VPWR picorv32_core.reg_pc\[12\]
+ sky130_fd_sc_hd__dfxtp_1
X_09019_ _02666_ _04327_ VGND VGND VPWR VPWR _04348_ sky130_fd_sc_hd__or2_4
XFILLER_105_753 VPWR VGND VPWR VGND sky130_ef_sc_hd__decap_12
Xhold170 picorv32_core.cpuregs\[3\]\[9\] VGND VGND VPWR VPWR net1279 sky130_fd_sc_hd__dlygate4sd3_1
Xhold192 picorv32_core.cpuregs\[19\]\[31\] VGND VGND VPWR VPWR net1301 sky130_fd_sc_hd__dlygate4sd3_1
Xhold181 picorv32_core.cpuregs\[14\]\[7\] VGND VGND VPWR VPWR net1290 sky130_fd_sc_hd__dlygate4sd3_1
XFILLER_120_745 VGND VGND VPWR VPWR sky130_fd_sc_hd__decap_8
Xfanout650 net651 VGND VGND VPWR VPWR net650 sky130_fd_sc_hd__buf_4
Xfanout661 net662 VGND VGND VPWR VPWR net661 sky130_fd_sc_hd__buf_2
Xfanout672 _01579_ VGND VGND VPWR VPWR net672 sky130_fd_sc_hd__clkbuf_2
Xfanout683 _00004_ VGND VGND VPWR VPWR net683 sky130_fd_sc_hd__clkbuf_4
Xfanout694 _00002_ VGND VGND VPWR VPWR net694 sky130_fd_sc_hd__clkbuf_4
XFILLER_86_670 VGND VGND VPWR VPWR sky130_fd_sc_hd__decap_8
XFILLER_19_726 VGND VGND VPWR VPWR sky130_fd_sc_hd__fill_2
XTAP_TAPCELL_ROW_29_721 VGND VPWR sky130_fd_sc_hd__tapvpwrvgnd_1
XTAP_TAPCELL_ROW_29_732 VGND VPWR sky130_fd_sc_hd__tapvpwrvgnd_1
XTAP_TAPCELL_ROW_64_1232 VGND VPWR sky130_fd_sc_hd__tapvpwrvgnd_1
XFILLER_61_559 VGND VGND VPWR VPWR sky130_fd_sc_hd__fill_1
XFILLER_42_740 VGND VGND VPWR VPWR sky130_fd_sc_hd__fill_1
XFILLER_42_784 VGND VGND VPWR VPWR sky130_fd_sc_hd__fill_2
X_11676_ clknet_leaf_70_clk _01507_ VGND VGND VPWR VPWR picorv32_core.cpuregs\[26\]\[25\]
+ sky130_fd_sc_hd__dfxtp_1
XFILLER_139_193 VGND VGND VPWR VPWR sky130_fd_sc_hd__decap_6
X_10627_ clknet_leaf_98_clk _00481_ VGND VGND VPWR VPWR picorv32_core.decoded_imm_j\[12\]
+ sky130_fd_sc_hd__dfxtp_1
X_10558_ clknet_leaf_23_clk _00412_ VGND VGND VPWR VPWR picorv32_core.cpuregs\[25\]\[14\]
+ sky130_fd_sc_hd__dfxtp_1
X_10489_ clknet_leaf_17_clk _00375_ VGND VGND VPWR VPWR net179 sky130_fd_sc_hd__dfxtp_2
XFILLER_96_401 VPWR VGND VPWR VGND sky130_ef_sc_hd__decap_12
XTAP_TAPCELL_ROW_75_1394 VGND VPWR sky130_fd_sc_hd__tapvpwrvgnd_1
XFILLER_110_233 VGND VGND VPWR VPWR sky130_fd_sc_hd__decap_3
XFILLER_84_629 VGND VGND VPWR VPWR sky130_fd_sc_hd__decap_4
XFILLER_84_618 VGND VGND VPWR VPWR sky130_fd_sc_hd__decap_8
X_06720_ net514 _02952_ _02953_ net551 net1195 VGND VGND VPWR VPWR _00231_ sky130_fd_sc_hd__a32o_1
XFILLER_37_523 VGND VGND VPWR VPWR sky130_fd_sc_hd__fill_2
XFILLER_92_662 VGND VGND VPWR VPWR sky130_fd_sc_hd__decap_3
X_06651_ _02675_ picorv32_core.reg_next_pc\[3\] net555 VGND VGND VPWR VPWR _02915_
+ sky130_fd_sc_hd__mux2_2
X_05602_ net910 net302 _02085_ _02089_ VGND VGND VPWR VPWR _02090_ sky130_fd_sc_hd__a31o_1
XFILLER_80_835 VGND VGND VPWR VPWR sky130_fd_sc_hd__fill_2
XFILLER_18_781 VPWR VGND VPWR VGND sky130_ef_sc_hd__decap_12
XFILLER_25_729 VPWR VGND VPWR VGND sky130_ef_sc_hd__decap_12
X_06582_ _02869_ _02870_ VGND VGND VPWR VPWR _00176_ sky130_fd_sc_hd__nor2_1
XFILLER_52_548 VGND VGND VPWR VPWR sky130_fd_sc_hd__decap_6
X_09370_ net836 _04551_ net643 VGND VGND VPWR VPWR _04561_ sky130_fd_sc_hd__o21a_1
X_05533_ net580 _02024_ _02025_ net776 net916 VGND VGND VPWR VPWR _02026_ sky130_fd_sc_hd__a32o_1
X_08321_ picorv32_core.is_beq_bne_blt_bge_bltu_bgeu _01650_ net475 VGND VGND VPWR
+ VPWR _00540_ sky130_fd_sc_hd__o21a_1
XFILLER_32_250 VGND VGND VPWR VPWR sky130_fd_sc_hd__fill_2
X_05464_ net946 picorv32_core.count_cycle\[50\] net604 _01961_ VGND VGND VPWR VPWR
+ _01962_ sky130_fd_sc_hd__a211o_1
X_08252_ picorv32_core.decoded_imm_j\[9\] _00770_ net440 VGND VGND VPWR VPWR _00479_
+ sky130_fd_sc_hd__mux2_1
XFILLER_32_283 VGND VGND VPWR VPWR sky130_fd_sc_hd__decap_3
X_07203_ picorv32_core.count_cycle\[46\] picorv32_core.count_cycle\[47\] picorv32_core.count_cycle\[48\]
+ _03354_ VGND VGND VPWR VPWR _03359_ sky130_fd_sc_hd__and4_1
Xclkbuf_4_12_0_clk clknet_0_clk VGND VGND VPWR VPWR clknet_4_12_0_clk sky130_fd_sc_hd__clkbuf_8
X_05395_ picorv32_core.count_instr\[45\] net936 net944 picorv32_core.count_cycle\[45\]
+ VGND VGND VPWR VPWR _01898_ sky130_fd_sc_hd__a22o_1
X_08183_ picorv32_core.is_lb_lh_lw_lbu_lhu net526 VGND VGND VPWR VPWR _04197_ sky130_fd_sc_hd__and2_1
X_07134_ picorv32_core.count_cycle\[22\] _03314_ net977 VGND VGND VPWR VPWR _03316_
+ sky130_fd_sc_hd__a21oi_1
X_07065_ net666 picorv32_core.reg_next_pc\[30\] _02942_ net490 VGND VGND VPWR VPWR
+ _03271_ sky130_fd_sc_hd__a22o_1
X_06016_ _02476_ _02477_ _02478_ _02474_ VGND VGND VPWR VPWR _02480_ sky130_fd_sc_hd__a31o_1
XTAP_TAPCELL_ROW_7_405 VGND VPWR sky130_fd_sc_hd__tapvpwrvgnd_1
XFILLER_114_561 VPWR VGND VPWR VGND sky130_ef_sc_hd__decap_12
XFILLER_102_701 VPWR VGND VPWR VGND sky130_ef_sc_hd__decap_12
XFILLER_102_745 VGND VGND VPWR VPWR sky130_fd_sc_hd__decap_8
XFILLER_101_211 VGND VGND VPWR VPWR sky130_fd_sc_hd__decap_4
XFILLER_87_445 VGND VGND VPWR VPWR sky130_fd_sc_hd__decap_3
X_07967_ picorv32_core.cpuregs\[24\]\[25\] picorv32_core.cpuregs\[25\]\[25\] picorv32_core.cpuregs\[26\]\[25\]
+ picorv32_core.cpuregs\[27\]\[25\] net762 net729 VGND VGND VPWR VPWR _04047_ sky130_fd_sc_hd__mux4_1
X_09706_ net651 _04881_ VGND VGND VPWR VPWR _04882_ sky130_fd_sc_hd__or2_1
XFILLER_87_489 VGND VGND VPWR VPWR sky130_fd_sc_hd__fill_1
X_06918_ _02929_ _03111_ _02930_ VGND VGND VPWR VPWR _03136_ sky130_fd_sc_hd__a21oi_1
X_07898_ picorv32_core.cpuregs\[0\]\[21\] picorv32_core.cpuregs\[1\]\[21\] picorv32_core.cpuregs\[2\]\[21\]
+ picorv32_core.cpuregs\[3\]\[21\] net755 net722 VGND VGND VPWR VPWR _03982_ sky130_fd_sc_hd__mux4_1
XFILLER_74_27 VGND VGND VPWR VPWR sky130_fd_sc_hd__fill_1
X_09637_ net838 _04810_ net828 VGND VGND VPWR VPWR _04816_ sky130_fd_sc_hd__o21a_1
X_06849_ _03035_ _03049_ _03070_ _03071_ _03057_ VGND VGND VPWR VPWR _03072_ sky130_fd_sc_hd__a32o_1
XFILLER_28_589 VGND VGND VPWR VPWR sky130_fd_sc_hd__decap_4
XTAP_TAPCELL_ROW_104_1811 VGND VPWR sky130_fd_sc_hd__tapvpwrvgnd_1
X_09568_ _04741_ _04742_ _04745_ _04746_ net657 net650 VGND VGND VPWR VPWR _04750_
+ sky130_fd_sc_hd__mux4_1
XFILLER_43_559 VGND VGND VPWR VPWR sky130_fd_sc_hd__fill_1
XFILLER_130_77 VGND VGND VPWR VPWR sky130_fd_sc_hd__decap_6
X_08519_ net1472 net465 net403 VGND VGND VPWR VPWR _00646_ sky130_fd_sc_hd__mux2_1
XFILLER_23_250 VGND VGND VPWR VPWR sky130_fd_sc_hd__fill_2
XFILLER_90_48 VGND VGND VPWR VPWR sky130_fd_sc_hd__decap_3
X_09499_ picorv32_core.cpuregs\[28\]\[14\] picorv32_core.cpuregs\[29\]\[14\] picorv32_core.cpuregs\[30\]\[14\]
+ picorv32_core.cpuregs\[31\]\[14\] net880 net847 VGND VGND VPWR VPWR _04684_ sky130_fd_sc_hd__mux4_1
X_11530_ clknet_leaf_11_clk _01361_ VGND VGND VPWR VPWR picorv32_core.cpuregs\[30\]\[11\]
+ sky130_fd_sc_hd__dfxtp_1
XFILLER_135_3 VPWR VGND VPWR VGND sky130_ef_sc_hd__decap_12
XPHY_EDGE_ROW_137_Right_137 VGND VGND VPWR VPWR sky130_fd_sc_hd__decap_3
X_11461_ clknet_leaf_9_clk _01297_ VGND VGND VPWR VPWR picorv32_core.cpuregs\[24\]\[12\]
+ sky130_fd_sc_hd__dfxtp_1
XFILLER_7_449 VGND VGND VPWR VPWR sky130_fd_sc_hd__fill_2
XFILLER_136_141 VGND VGND VPWR VPWR sky130_fd_sc_hd__decap_3
XTAP_TAPCELL_ROW_133_2229 VGND VPWR sky130_fd_sc_hd__tapvpwrvgnd_1
X_11392_ clknet_leaf_131_clk _01228_ VGND VGND VPWR VPWR picorv32_core.cpuregs\[31\]\[7\]
+ sky130_fd_sc_hd__dfxtp_1
X_10412_ clknet_leaf_120_clk _01574_ VGND VGND VPWR VPWR picorv32_core.reg_out\[5\]
+ sky130_fd_sc_hd__dfxtp_1
XFILLER_137_697 VPWR VGND VPWR VGND sky130_ef_sc_hd__decap_12
XFILLER_99_57 VGND VGND VPWR VPWR sky130_fd_sc_hd__fill_1
X_10343_ clknet_leaf_107_clk _00262_ VGND VGND VPWR VPWR picorv32_core.count_cycle\[1\]
+ sky130_fd_sc_hd__dfxtp_1
XFILLER_124_347 VGND VGND VPWR VPWR sky130_fd_sc_hd__fill_1
XTAP_TAPCELL_ROW_115_1973 VGND VPWR sky130_fd_sc_hd__tapvpwrvgnd_1
XFILLER_2_121 VPWR VGND VPWR VGND sky130_ef_sc_hd__decap_12
X_10274_ clknet_leaf_78_clk _00193_ VGND VGND VPWR VPWR picorv32_core.count_instr\[58\]
+ sky130_fd_sc_hd__dfxtp_1
XFILLER_2_165 VPWR VGND VPWR VGND sky130_ef_sc_hd__decap_12
XFILLER_120_531 VGND VGND VPWR VPWR sky130_fd_sc_hd__fill_1
XFILLER_93_437 VGND VGND VPWR VPWR sky130_fd_sc_hd__fill_1
Xfanout480 net481 VGND VGND VPWR VPWR net480 sky130_fd_sc_hd__buf_4
Xfanout491 _02973_ VGND VGND VPWR VPWR net491 sky130_fd_sc_hd__buf_2
XFILLER_48_72 VGND VGND VPWR VPWR sky130_fd_sc_hd__decap_4
XFILLER_48_94 VGND VGND VPWR VPWR sky130_fd_sc_hd__fill_1
XFILLER_58_191 VGND VGND VPWR VPWR sky130_fd_sc_hd__decap_4
XFILLER_0_24 VGND VGND VPWR VPWR sky130_fd_sc_hd__decap_4
XFILLER_62_835 VGND VGND VPWR VPWR sky130_fd_sc_hd__fill_2
XFILLER_0_57 VPWR VGND VPWR VGND sky130_ef_sc_hd__decap_12
XPHY_EDGE_ROW_104_Right_104 VGND VGND VPWR VPWR sky130_fd_sc_hd__decap_3
XFILLER_80_81 VGND VGND VPWR VPWR sky130_fd_sc_hd__decap_3
X_11659_ clknet_leaf_129_clk _01490_ VGND VGND VPWR VPWR picorv32_core.cpuregs\[26\]\[8\]
+ sky130_fd_sc_hd__dfxtp_1
XTAP_TAPCELL_ROW_77_1423 VGND VPWR sky130_fd_sc_hd__tapvpwrvgnd_1
XTAP_TAPCELL_ROW_12_473 VGND VPWR sky130_fd_sc_hd__tapvpwrvgnd_1
XTAP_TAPCELL_ROW_12_484 VGND VPWR sky130_fd_sc_hd__tapvpwrvgnd_1
X_05180_ net665 _01702_ VGND VGND VPWR VPWR _01703_ sky130_fd_sc_hd__nor2_2
XFILLER_127_163 VGND VGND VPWR VPWR sky130_fd_sc_hd__decap_4
Xhold906 picorv32_core.cpuregs\[18\]\[24\] VGND VGND VPWR VPWR net2015 sky130_fd_sc_hd__dlygate4sd3_1
Xhold928 picorv32_core.cpuregs\[29\]\[9\] VGND VGND VPWR VPWR net2037 sky130_fd_sc_hd__dlygate4sd3_1
Xhold917 picorv32_core.cpuregs\[26\]\[0\] VGND VGND VPWR VPWR net2026 sky130_fd_sc_hd__dlygate4sd3_1
Xhold939 picorv32_core.cpuregs\[17\]\[19\] VGND VGND VPWR VPWR net2048 sky130_fd_sc_hd__dlygate4sd3_1
XTAP_TAPCELL_ROW_90_1612 VGND VPWR sky130_fd_sc_hd__tapvpwrvgnd_1
XFILLER_69_401 VGND VGND VPWR VPWR sky130_fd_sc_hd__decap_6
X_08870_ net266 net2240 net363 VGND VGND VPWR VPWR _01045_ sky130_fd_sc_hd__mux2_1
X_07821_ picorv32_core.cpuregs\[4\]\[17\] picorv32_core.cpuregs\[5\]\[17\] picorv32_core.cpuregs\[6\]\[17\]
+ picorv32_core.cpuregs\[7\]\[17\] net747 net714 VGND VGND VPWR VPWR _03909_ sky130_fd_sc_hd__mux4_1
X_07752_ picorv32_core.cpuregs\[4\]\[13\] picorv32_core.cpuregs\[5\]\[13\] picorv32_core.cpuregs\[6\]\[13\]
+ picorv32_core.cpuregs\[7\]\[13\] net740 net707 VGND VGND VPWR VPWR _03844_ sky130_fd_sc_hd__mux4_1
XFILLER_56_139 VGND VGND VPWR VPWR sky130_fd_sc_hd__fill_1
X_06703_ _02782_ picorv32_core.reg_next_pc\[29\] net559 VGND VGND VPWR VPWR _02941_
+ sky130_fd_sc_hd__mux2_2
XTAP_TAPCELL_ROW_88_1585 VGND VPWR sky130_fd_sc_hd__tapvpwrvgnd_1
XTAP_TAPCELL_ROW_88_1574 VGND VPWR sky130_fd_sc_hd__tapvpwrvgnd_1
XFILLER_65_684 VGND VGND VPWR VPWR sky130_fd_sc_hd__decap_4
XFILLER_53_813 VGND VGND VPWR VPWR sky130_fd_sc_hd__fill_2
X_07683_ _03773_ _03774_ net627 VGND VGND VPWR VPWR _03779_ sky130_fd_sc_hd__mux2_1
X_06634_ picorv32_core.count_instr\[60\] picorv32_core.count_instr\[59\] _02900_ VGND
+ VGND VPWR VPWR _02904_ sky130_fd_sc_hd__and3_1
XFILLER_92_481 VGND VGND VPWR VPWR sky130_fd_sc_hd__decap_4
X_09422_ _03439_ _03484_ _03437_ VGND VGND VPWR VPWR _04610_ sky130_fd_sc_hd__o21a_1
XFILLER_53_835 VGND VGND VPWR VPWR sky130_fd_sc_hd__fill_2
XFILLER_44_19 VGND VGND VPWR VPWR sky130_fd_sc_hd__decap_8
XFILLER_80_654 VGND VGND VPWR VPWR sky130_fd_sc_hd__decap_6
X_09353_ net808 net281 VGND VGND VPWR VPWR _04545_ sky130_fd_sc_hd__and2_1
X_08304_ picorv32_core.instr_jalr picorv32_core.is_lb_lh_lw_lbu_lhu picorv32_core.is_alu_reg_imm
+ VGND VGND VPWR VPWR _04227_ sky130_fd_sc_hd__or3_2
XFILLER_40_529 VGND VGND VPWR VPWR sky130_fd_sc_hd__decap_3
X_06565_ net2273 _02858_ net985 VGND VGND VPWR VPWR _02860_ sky130_fd_sc_hd__o21ai_1
XFILLER_100_58 VGND VGND VPWR VPWR sky130_fd_sc_hd__fill_1
X_05516_ _01994_ _01997_ _02007_ VGND VGND VPWR VPWR _02010_ sky130_fd_sc_hd__nand3_1
X_06496_ net2254 _02814_ net986 VGND VGND VPWR VPWR _02816_ sky130_fd_sc_hd__o21ai_1
XFILLER_21_765 VPWR VGND VPWR VGND sky130_ef_sc_hd__decap_12
X_09284_ net485 _04454_ _04457_ net282 VGND VGND VPWR VPWR _04479_ sky130_fd_sc_hd__o31a_1
XFILLER_33_592 VGND VGND VPWR VPWR sky130_fd_sc_hd__fill_1
X_05447_ _01934_ _01944_ VGND VGND VPWR VPWR _01946_ sky130_fd_sc_hd__and2_1
X_08235_ picorv32_core.mem_rdata_q\[22\] picorv32_core.mem_rdata_q\[23\] picorv32_core.mem_rdata_q\[20\]
+ picorv32_core.mem_rdata_q\[21\] VGND VGND VPWR VPWR _04220_ sky130_fd_sc_hd__or4b_1
XFILLER_60_29 VGND VGND VPWR VPWR sky130_fd_sc_hd__decap_3
XFILLER_20_253 VGND VGND VPWR VPWR sky130_fd_sc_hd__decap_4
XTAP_TAPCELL_ROW_31_760 VGND VPWR sky130_fd_sc_hd__tapvpwrvgnd_1
XFILLER_118_141 VGND VGND VPWR VPWR sky130_fd_sc_hd__fill_2
X_08166_ net2044 net476 _04185_ _04188_ VGND VGND VPWR VPWR _00436_ sky130_fd_sc_hd__a22o_1
X_05378_ _01856_ _01861_ VGND VGND VPWR VPWR _01882_ sky130_fd_sc_hd__nor2_1
X_07117_ _03304_ _03305_ VGND VGND VPWR VPWR _00276_ sky130_fd_sc_hd__nor2_1
X_08097_ net931 picorv32_core.instr_jalr _04163_ VGND VGND VPWR VPWR _04168_ sky130_fd_sc_hd__o21a_1
XFILLER_134_678 VGND VGND VPWR VPWR sky130_fd_sc_hd__decap_4
X_07048_ net933 _02941_ VGND VGND VPWR VPWR _03255_ sky130_fd_sc_hd__nor2_1
XFILLER_69_49 VGND VGND VPWR VPWR sky130_fd_sc_hd__decap_6
Xclkload90 clknet_leaf_91_clk VGND VGND VPWR VPWR clkload90/Y sky130_fd_sc_hd__inv_12
XFILLER_125_55 VGND VGND VPWR VPWR sky130_fd_sc_hd__fill_1
XFILLER_88_754 VGND VGND VPWR VPWR sky130_fd_sc_hd__fill_2
XFILLER_102_575 VGND VGND VPWR VPWR sky130_fd_sc_hd__decap_4
X_08999_ net288 net1994 net344 VGND VGND VPWR VPWR _01169_ sky130_fd_sc_hd__mux2_1
XFILLER_29_821 VGND VGND VPWR VPWR sky130_fd_sc_hd__decap_6
XFILLER_47_117 VGND VGND VPWR VPWR sky130_fd_sc_hd__fill_1
XFILLER_18_53 VPWR VGND VPWR VGND sky130_ef_sc_hd__decap_12
XFILLER_90_418 VGND VGND VPWR VPWR sky130_fd_sc_hd__fill_2
X_10961_ clknet_leaf_128_clk _00812_ VGND VGND VPWR VPWR picorv32_core.cpuregs\[13\]\[7\]
+ sky130_fd_sc_hd__dfxtp_1
XTAP_TAPCELL_ROW_39_871 VGND VPWR sky130_fd_sc_hd__tapvpwrvgnd_1
XFILLER_44_813 VGND VGND VPWR VPWR sky130_fd_sc_hd__fill_1
XTAP_TAPCELL_ROW_48_1002 VGND VPWR sky130_fd_sc_hd__tapvpwrvgnd_1
X_10892_ clknet_leaf_98_clk _00743_ VGND VGND VPWR VPWR picorv32_core.mem_rdata_q\[2\]
+ sky130_fd_sc_hd__dfxtp_1
XFILLER_71_698 VGND VGND VPWR VPWR sky130_fd_sc_hd__fill_2
XFILLER_34_85 VGND VGND VPWR VPWR sky130_fd_sc_hd__fill_1
X_11513_ clknet_leaf_58_clk _01349_ VGND VGND VPWR VPWR net164 sky130_fd_sc_hd__dfxtp_1
XFILLER_7_213 VGND VGND VPWR VPWR sky130_fd_sc_hd__fill_2
X_11444_ clknet_leaf_42_clk _01280_ VGND VGND VPWR VPWR picorv32_core.cpuregs\[1\]\[27\]
+ sky130_fd_sc_hd__dfxtp_1
XFILLER_8_769 VPWR VGND VPWR VGND sky130_ef_sc_hd__decap_12
X_11375_ clknet_leaf_42_clk _01216_ VGND VGND VPWR VPWR picorv32_core.cpuregs\[18\]\[27\]
+ sky130_fd_sc_hd__dfxtp_1
XTAP_TAPCELL_ROW_59_1164 VGND VPWR sky130_fd_sc_hd__tapvpwrvgnd_1
XFILLER_79_710 VGND VGND VPWR VPWR sky130_fd_sc_hd__decap_3
X_10326_ clknet_leaf_88_clk _00245_ VGND VGND VPWR VPWR picorv32_core.reg_next_pc\[16\]
+ sky130_fd_sc_hd__dfxtp_1
XTAP_TAPCELL_ROW_72_1353 VGND VPWR sky130_fd_sc_hd__tapvpwrvgnd_1
XTAP_TAPCELL_ROW_72_1342 VGND VPWR sky130_fd_sc_hd__tapvpwrvgnd_1
X_10257_ clknet_leaf_101_clk _00176_ VGND VGND VPWR VPWR picorv32_core.count_instr\[41\]
+ sky130_fd_sc_hd__dfxtp_1
XFILLER_105_391 VGND VGND VPWR VPWR sky130_fd_sc_hd__fill_1
XFILLER_79_776 VGND VGND VPWR VPWR sky130_fd_sc_hd__fill_2
XFILLER_94_713 VGND VGND VPWR VPWR sky130_fd_sc_hd__decap_8
X_10188_ clknet_leaf_115_clk _00107_ VGND VGND VPWR VPWR picorv32_core.cpuregs\[9\]\[4\]
+ sky130_fd_sc_hd__dfxtp_1
XFILLER_93_245 VGND VGND VPWR VPWR sky130_fd_sc_hd__fill_2
XFILLER_15_6 VPWR VGND VPWR VGND sky130_ef_sc_hd__decap_12
XFILLER_47_673 VGND VGND VPWR VPWR sky130_fd_sc_hd__fill_1
XFILLER_62_643 VGND VGND VPWR VPWR sky130_fd_sc_hd__fill_1
XFILLER_34_334 VGND VGND VPWR VPWR sky130_fd_sc_hd__decap_4
XTAP_TAPCELL_ROW_17_554 VGND VPWR sky130_fd_sc_hd__tapvpwrvgnd_1
XFILLER_98_3 VPWR VGND VPWR VGND sky130_ef_sc_hd__decap_12
X_06350_ picorv32_core.reg_pc\[22\] _02750_ VGND VGND VPWR VPWR _02754_ sky130_fd_sc_hd__nor2_1
X_06281_ net2077 net426 net433 VGND VGND VPWR VPWR _00047_ sky130_fd_sc_hd__mux2_1
X_05301_ _01809_ net920 _01808_ VGND VGND VPWR VPWR _01810_ sky130_fd_sc_hd__and3b_1
X_08020_ picorv32_core.cpuregs\[0\]\[28\] picorv32_core.cpuregs\[1\]\[28\] picorv32_core.cpuregs\[2\]\[28\]
+ picorv32_core.cpuregs\[3\]\[28\] net754 net721 VGND VGND VPWR VPWR _04097_ sky130_fd_sc_hd__mux4_1
X_05232_ picorv32_core.reg_pc\[1\] picorv32_core.decoded_imm\[1\] _01743_ _01744_
+ VGND VGND VPWR VPWR _01746_ sky130_fd_sc_hd__and4_1
Xhold703 picorv32_core.cpuregs\[2\]\[2\] VGND VGND VPWR VPWR net1812 sky130_fd_sc_hd__dlygate4sd3_1
Xhold736 picorv32_core.cpuregs\[16\]\[30\] VGND VGND VPWR VPWR net1845 sky130_fd_sc_hd__dlygate4sd3_1
XFILLER_115_133 VGND VGND VPWR VPWR sky130_fd_sc_hd__decap_3
Xhold714 picorv32_core.cpuregs\[25\]\[18\] VGND VGND VPWR VPWR net1823 sky130_fd_sc_hd__dlygate4sd3_1
Xhold725 picorv32_core.cpuregs\[9\]\[12\] VGND VGND VPWR VPWR net1834 sky130_fd_sc_hd__dlygate4sd3_1
X_05163_ picorv32_core.reg_sh\[4\] _01687_ VGND VGND VPWR VPWR _01688_ sky130_fd_sc_hd__nor2_2
X_09971_ net1956 net208 net319 VGND VGND VPWR VPWR _01449_ sky130_fd_sc_hd__mux2_1
Xhold747 picorv32_core.cpuregs\[12\]\[29\] VGND VGND VPWR VPWR net1856 sky130_fd_sc_hd__dlygate4sd3_1
Xhold758 picorv32_core.cpuregs\[18\]\[13\] VGND VGND VPWR VPWR net1867 sky130_fd_sc_hd__dlygate4sd3_1
Xhold769 picorv32_core.cpuregs\[9\]\[5\] VGND VGND VPWR VPWR net1878 sky130_fd_sc_hd__dlygate4sd3_1
X_05094_ _01588_ _01625_ VGND VGND VPWR VPWR _01626_ sky130_fd_sc_hd__nor2_2
XFILLER_130_103 VGND VGND VPWR VPWR sky130_fd_sc_hd__fill_1
X_08922_ net496 net2177 net357 VGND VGND VPWR VPWR _01095_ sky130_fd_sc_hd__mux2_1
X_08853_ _02666_ _04340_ VGND VGND VPWR VPWR _04342_ sky130_fd_sc_hd__or2_1
X_08784_ net210 net1663 net376 VGND VGND VPWR VPWR _00931_ sky130_fd_sc_hd__mux2_1
X_05996_ net783 _02460_ VGND VGND VPWR VPWR _02461_ sky130_fd_sc_hd__nor2_1
X_07804_ picorv32_core.cpuregs\[12\]\[16\] picorv32_core.cpuregs\[13\]\[16\] picorv32_core.cpuregs\[14\]\[16\]
+ picorv32_core.cpuregs\[15\]\[16\] net747 net714 VGND VGND VPWR VPWR _03893_ sky130_fd_sc_hd__mux4_1
X_07735_ picorv32_core.cpuregs\[0\]\[12\] picorv32_core.cpuregs\[1\]\[12\] picorv32_core.cpuregs\[2\]\[12\]
+ picorv32_core.cpuregs\[3\]\[12\] net737 net704 VGND VGND VPWR VPWR _03828_ sky130_fd_sc_hd__mux4_1
XTAP_TAPCELL_ROW_36_830 VGND VPWR sky130_fd_sc_hd__tapvpwrvgnd_1
X_09405_ picorv32_core.cpuregs\[20\]\[10\] picorv32_core.cpuregs\[21\]\[10\] picorv32_core.cpuregs\[22\]\[10\]
+ picorv32_core.cpuregs\[23\]\[10\] net873 net840 VGND VGND VPWR VPWR _04594_ sky130_fd_sc_hd__mux4_1
X_07666_ _03750_ _03751_ net692 VGND VGND VPWR VPWR _03763_ sky130_fd_sc_hd__mux2_1
XFILLER_111_57 VGND VGND VPWR VPWR sky130_fd_sc_hd__decap_4
X_06617_ net2293 _02891_ net996 VGND VGND VPWR VPWR _02893_ sky130_fd_sc_hd__o21ai_1
XFILLER_80_484 VGND VGND VPWR VPWR sky130_fd_sc_hd__fill_1
X_07597_ picorv32_core.cpuregs\[12\]\[5\] picorv32_core.cpuregs\[13\]\[5\] picorv32_core.cpuregs\[14\]\[5\]
+ picorv32_core.cpuregs\[15\]\[5\] net733 net700 VGND VGND VPWR VPWR _03697_ sky130_fd_sc_hd__mux4_1
X_06548_ picorv32_core.count_instr\[29\] picorv32_core.count_instr\[28\] picorv32_core.count_instr\[27\]
+ _02844_ VGND VGND VPWR VPWR _02849_ sky130_fd_sc_hd__and4_1
XFILLER_52_197 VGND VGND VPWR VPWR sky130_fd_sc_hd__decap_4
XFILLER_40_348 VGND VGND VPWR VPWR sky130_fd_sc_hd__decap_3
X_09336_ net806 net548 _04527_ net469 VGND VGND VPWR VPWR _04528_ sky130_fd_sc_hd__o211a_1
XFILLER_139_726 VGND VGND VPWR VPWR sky130_fd_sc_hd__fill_2
X_09267_ picorv32_core.cpuregs\[16\]\[4\] picorv32_core.cpuregs\[17\]\[4\] picorv32_core.cpuregs\[18\]\[4\]
+ picorv32_core.cpuregs\[19\]\[4\] net888 net853 VGND VGND VPWR VPWR _04462_ sky130_fd_sc_hd__mux4_1
X_08218_ net2283 net475 _04187_ _04208_ VGND VGND VPWR VPWR _00464_ sky130_fd_sc_hd__a22o_1
Xpicorv32_axi_1102 VGND VGND VPWR VPWR picorv32_axi_1102/HI trace_data[29] sky130_fd_sc_hd__conb_1
Xclkbuf_leaf_141_clk clknet_4_0_0_clk VGND VGND VPWR VPWR clknet_leaf_141_clk sky130_fd_sc_hd__clkbuf_8
X_06479_ picorv32_core.count_instr\[4\] picorv32_core.count_instr\[3\] picorv32_core.count_instr\[2\]
+ _02801_ VGND VGND VPWR VPWR _02805_ sky130_fd_sc_hd__and4_1
XFILLER_107_601 VGND VGND VPWR VPWR sky130_fd_sc_hd__decap_6
X_09198_ net913 net812 net540 VGND VGND VPWR VPWR _04396_ sky130_fd_sc_hd__and3_1
XFILLER_119_483 VGND VGND VPWR VPWR sky130_fd_sc_hd__decap_6
XFILLER_107_645 VGND VGND VPWR VPWR sky130_fd_sc_hd__fill_2
XFILLER_106_100 VGND VGND VPWR VPWR sky130_fd_sc_hd__decap_3
X_08149_ net1178 _02600_ _04173_ _04176_ VGND VGND VPWR VPWR _00431_ sky130_fd_sc_hd__a22o_1
X_11160_ clknet_leaf_26_clk _01011_ VGND VGND VPWR VPWR picorv32_core.cpuregs\[7\]\[14\]
+ sky130_fd_sc_hd__dfxtp_1
XFILLER_20_65 VPWR VGND VPWR VGND sky130_ef_sc_hd__decap_12
X_10111_ net1131 VGND VGND VPWR VPWR _00961_ sky130_fd_sc_hd__clkbuf_1
XFILLER_136_65 VPWR VGND VPWR VGND sky130_ef_sc_hd__decap_12
XTAP_TAPCELL_ROW_112_1932 VGND VPWR sky130_fd_sc_hd__tapvpwrvgnd_1
X_11091_ clknet_leaf_0_clk _00942_ VGND VGND VPWR VPWR picorv32_core.cpuregs\[0\]\[9\]
+ sky130_fd_sc_hd__dfxtp_1
XFILLER_96_58 VGND VGND VPWR VPWR sky130_fd_sc_hd__fill_1
X_10042_ net1523 _02677_ net305 VGND VGND VPWR VPWR _01517_ sky130_fd_sc_hd__mux2_1
XFILLER_102_350 VGND VGND VPWR VPWR sky130_fd_sc_hd__decap_3
Xhold41 picorv32_core.cpuregs\[0\]\[19\] VGND VGND VPWR VPWR net1150 sky130_fd_sc_hd__dlygate4sd3_1
XTAP_TAPCELL_ROW_54_1094 VGND VPWR sky130_fd_sc_hd__tapvpwrvgnd_1
XTAP_TAPCELL_ROW_54_1083 VGND VPWR sky130_fd_sc_hd__tapvpwrvgnd_1
Xhold30 picorv32_core.decoded_rd\[2\] VGND VGND VPWR VPWR net1139 sky130_fd_sc_hd__dlygate4sd3_1
Xhold74 net122 VGND VGND VPWR VPWR net1183 sky130_fd_sc_hd__dlygate4sd3_1
XFILLER_76_757 VGND VGND VPWR VPWR sky130_fd_sc_hd__fill_2
Xhold52 picorv32_core.instr_or VGND VGND VPWR VPWR net1161 sky130_fd_sc_hd__dlygate4sd3_1
Xhold63 net115 VGND VGND VPWR VPWR net1172 sky130_fd_sc_hd__dlygate4sd3_1
XFILLER_76_779 VGND VGND VPWR VPWR sky130_fd_sc_hd__decap_8
Xhold96 picorv32_core.cpuregs\[7\]\[15\] VGND VGND VPWR VPWR net1205 sky130_fd_sc_hd__dlygate4sd3_1
Xhold85 picorv32_core.instr_fence VGND VGND VPWR VPWR net1194 sky130_fd_sc_hd__dlygate4sd3_1
XFILLER_17_813 VGND VGND VPWR VPWR sky130_fd_sc_hd__fill_1
XFILLER_28_150 VGND VGND VPWR VPWR sky130_fd_sc_hd__decap_4
XFILLER_29_673 VGND VGND VPWR VPWR sky130_fd_sc_hd__decap_3
X_10944_ clknet_leaf_34_clk _00795_ VGND VGND VPWR VPWR picorv32_core.cpuregs\[19\]\[22\]
+ sky130_fd_sc_hd__dfxtp_1
X_10875_ clknet_leaf_30_clk _00726_ VGND VGND VPWR VPWR picorv32_core.cpuregs\[16\]\[19\]
+ sky130_fd_sc_hd__dfxtp_1
XTAP_TAPCELL_ROW_14_502 VGND VPWR sky130_fd_sc_hd__tapvpwrvgnd_1
XTAP_TAPCELL_ROW_14_513 VGND VPWR sky130_fd_sc_hd__tapvpwrvgnd_1
XFILLER_44_698 VGND VGND VPWR VPWR sky130_fd_sc_hd__fill_2
XFILLER_8_533 VGND VGND VPWR VPWR sky130_fd_sc_hd__decap_4
Xclkbuf_leaf_132_clk clknet_4_2_0_clk VGND VGND VPWR VPWR clknet_leaf_132_clk sky130_fd_sc_hd__clkbuf_8
XFILLER_138_781 VPWR VGND VPWR VGND sky130_ef_sc_hd__decap_12
XANTENNA_5 _02660_ VGND VGND VPWR VPWR sky130_fd_sc_hd__diode_2
X_11427_ clknet_leaf_3_clk _01263_ VGND VGND VPWR VPWR picorv32_core.cpuregs\[1\]\[10\]
+ sky130_fd_sc_hd__dfxtp_1
X_11358_ clknet_leaf_2_clk _01199_ VGND VGND VPWR VPWR picorv32_core.cpuregs\[18\]\[10\]
+ sky130_fd_sc_hd__dfxtp_1
XFILLER_113_626 VGND VGND VPWR VPWR sky130_fd_sc_hd__fill_1
X_10309_ clknet_leaf_76_clk _00228_ VGND VGND VPWR VPWR picorv32_core.reg_pc\[30\]
+ sky130_fd_sc_hd__dfxtp_1
XFILLER_112_136 VGND VGND VPWR VPWR sky130_fd_sc_hd__decap_4
XFILLER_79_551 VGND VGND VPWR VPWR sky130_fd_sc_hd__decap_8
X_11289_ clknet_leaf_6_clk _01137_ VGND VGND VPWR VPWR picorv32_core.cpuregs\[3\]\[12\]
+ sky130_fd_sc_hd__dfxtp_1
XFILLER_94_510 VGND VGND VPWR VPWR sky130_fd_sc_hd__decap_4
XFILLER_79_573 VGND VGND VPWR VPWR sky130_fd_sc_hd__decap_4
XFILLER_67_702 VGND VGND VPWR VPWR sky130_fd_sc_hd__decap_3
XFILLER_66_201 VGND VGND VPWR VPWR sky130_fd_sc_hd__fill_1
XFILLER_94_521 VGND VGND VPWR VPWR sky130_fd_sc_hd__fill_2
XFILLER_86_80 VGND VGND VPWR VPWR sky130_fd_sc_hd__decap_4
XFILLER_67_746 VGND VGND VPWR VPWR sky130_fd_sc_hd__fill_2
XFILLER_13_3 VPWR VGND VPWR VGND sky130_ef_sc_hd__decap_12
X_05850_ net807 net962 net606 _02326_ VGND VGND VPWR VPWR _02327_ sky130_fd_sc_hd__o22a_1
X_07520_ net2285 _03634_ net463 VGND VGND VPWR VPWR _00350_ sky130_fd_sc_hd__mux2_1
XTAP_TAPCELL_ROW_85_1533 VGND VPWR sky130_fd_sc_hd__tapvpwrvgnd_1
XFILLER_82_749 VGND VGND VPWR VPWR sky130_fd_sc_hd__fill_2
X_05781_ net819 net968 net567 net506 _02263_ VGND VGND VPWR VPWR _02264_ sky130_fd_sc_hd__a311o_1
XTAP_TAPCELL_ROW_85_1544 VGND VPWR sky130_fd_sc_hd__tapvpwrvgnd_1
X_07451_ net1909 _03588_ net460 VGND VGND VPWR VPWR _00327_ sky130_fd_sc_hd__mux2_1
XFILLER_35_676 VGND VGND VPWR VPWR sky130_fd_sc_hd__fill_1
X_07382_ _03417_ _03418_ VGND VGND VPWR VPWR _03522_ sky130_fd_sc_hd__nor2_1
X_06402_ _02664_ _02795_ VGND VGND VPWR VPWR _02796_ sky130_fd_sc_hd__or2_4
X_06333_ picorv32_core.reg_out\[19\] picorv32_core.alu_out_q\[19\] net952 VGND VGND
+ VPWR VPWR _02740_ sky130_fd_sc_hd__mux2_1
X_09121_ net1443 net497 net328 VGND VGND VPWR VPWR _01287_ sky130_fd_sc_hd__mux2_1
Xclkbuf_leaf_123_clk clknet_4_9_0_clk VGND VGND VPWR VPWR clknet_leaf_123_clk sky130_fd_sc_hd__clkbuf_8
XFILLER_129_781 VGND VGND VPWR VPWR sky130_fd_sc_hd__decap_3
X_09052_ _04325_ _04346_ VGND VGND VPWR VPWR _04349_ sky130_fd_sc_hd__nor2_2
X_06264_ picorv32_core.reg_pc\[5\] _02679_ VGND VGND VPWR VPWR _02685_ sky130_fd_sc_hd__and2_1
X_08003_ picorv32_core.cpuregs\[4\]\[27\] picorv32_core.cpuregs\[5\]\[27\] picorv32_core.cpuregs\[6\]\[27\]
+ picorv32_core.cpuregs\[7\]\[27\] net756 net723 VGND VGND VPWR VPWR _04081_ sky130_fd_sc_hd__mux4_1
X_05215_ net21 net821 VGND VGND VPWR VPWR _01730_ sky130_fd_sc_hd__nand2b_1
Xhold500 picorv32_core.cpuregs\[5\]\[11\] VGND VGND VPWR VPWR net1609 sky130_fd_sc_hd__dlygate4sd3_1
X_06195_ picorv32_core.cpuregs\[0\]\[3\] picorv32_core.cpuregs\[1\]\[3\] picorv32_core.cpuregs\[2\]\[3\]
+ picorv32_core.cpuregs\[3\]\[3\] net743 net710 VGND VGND VPWR VPWR _02626_ sky130_fd_sc_hd__mux4_1
Xhold511 picorv32_core.cpuregs\[20\]\[1\] VGND VGND VPWR VPWR net1620 sky130_fd_sc_hd__dlygate4sd3_1
XTAP_TAPCELL_ROW_96_1695 VGND VPWR sky130_fd_sc_hd__tapvpwrvgnd_1
Xhold533 picorv32_core.cpuregs\[5\]\[15\] VGND VGND VPWR VPWR net1642 sky130_fd_sc_hd__dlygate4sd3_1
Xhold544 picorv32_core.cpuregs\[6\]\[9\] VGND VGND VPWR VPWR net1653 sky130_fd_sc_hd__dlygate4sd3_1
Xhold522 picorv32_core.cpuregs\[30\]\[7\] VGND VGND VPWR VPWR net1631 sky130_fd_sc_hd__dlygate4sd3_1
X_05146_ net980 _01671_ VGND VGND VPWR VPWR _01674_ sky130_fd_sc_hd__nand2_1
Xhold588 picorv32_core.cpuregs\[20\]\[25\] VGND VGND VPWR VPWR net1697 sky130_fd_sc_hd__dlygate4sd3_1
Xhold577 picorv32_core.cpuregs\[25\]\[28\] VGND VGND VPWR VPWR net1686 sky130_fd_sc_hd__dlygate4sd3_1
XFILLER_116_475 VGND VGND VPWR VPWR sky130_fd_sc_hd__fill_1
XFILLER_104_626 VGND VGND VPWR VPWR sky130_fd_sc_hd__fill_2
Xhold566 picorv32_core.cpuregs\[3\]\[17\] VGND VGND VPWR VPWR net1675 sky130_fd_sc_hd__dlygate4sd3_1
Xmax_cap263 _03502_ VGND VGND VPWR VPWR net263 sky130_fd_sc_hd__clkbuf_1
Xhold555 picorv32_core.cpuregs\[13\]\[0\] VGND VGND VPWR VPWR net1664 sky130_fd_sc_hd__dlygate4sd3_1
XFILLER_131_434 VGND VGND VPWR VPWR sky130_fd_sc_hd__decap_3
Xhold599 picorv32_core.cpuregs\[6\]\[27\] VGND VGND VPWR VPWR net1708 sky130_fd_sc_hd__dlygate4sd3_1
XFILLER_106_35 VGND VGND VPWR VPWR sky130_fd_sc_hd__fill_1
X_05077_ net188 VGND VGND VPWR VPWR _01612_ sky130_fd_sc_hd__inv_2
X_09954_ net1291 net272 net316 VGND VGND VPWR VPWR _01432_ sky130_fd_sc_hd__mux2_1
X_09885_ net2034 net236 net326 VGND VGND VPWR VPWR _01373_ sky130_fd_sc_hd__mux2_1
XFILLER_103_169 VGND VGND VPWR VPWR sky130_fd_sc_hd__decap_3
X_08905_ net257 net1638 net360 VGND VGND VPWR VPWR _01079_ sky130_fd_sc_hd__mux2_1
Xhold1200 picorv32_core.mem_rdata_q\[17\] VGND VGND VPWR VPWR net2309 sky130_fd_sc_hd__dlygate4sd3_1
XFILLER_58_713 VGND VGND VPWR VPWR sky130_fd_sc_hd__decap_4
Xhold1211 net128 VGND VGND VPWR VPWR net2320 sky130_fd_sc_hd__dlygate4sd3_1
Xhold1222 picorv32_core.count_instr\[56\] VGND VGND VPWR VPWR net2331 sky130_fd_sc_hd__dlygate4sd3_1
X_08836_ net1205 net270 net367 VGND VGND VPWR VPWR _01012_ sky130_fd_sc_hd__mux2_1
Xhold1233 picorv32_core.decoded_imm_j\[12\] VGND VGND VPWR VPWR net2342 sky130_fd_sc_hd__dlygate4sd3_1
XTAP_TAPCELL_ROW_127_2150 VGND VPWR sky130_fd_sc_hd__tapvpwrvgnd_1
XFILLER_73_727 VGND VGND VPWR VPWR sky130_fd_sc_hd__fill_1
Xhold1244 picorv32_core.count_cycle\[43\] VGND VGND VPWR VPWR net2353 sky130_fd_sc_hd__dlygate4sd3_1
Xhold1255 picorv32_core.count_instr\[42\] VGND VGND VPWR VPWR net2364 sky130_fd_sc_hd__dlygate4sd3_1
X_05979_ net787 net181 net609 VGND VGND VPWR VPWR _02446_ sky130_fd_sc_hd__o21a_1
X_08767_ net278 net1891 net374 VGND VGND VPWR VPWR _00914_ sky130_fd_sc_hd__mux2_1
X_07718_ net629 _03811_ VGND VGND VPWR VPWR _03812_ sky130_fd_sc_hd__or2_1
XFILLER_14_805 VGND VGND VPWR VPWR sky130_fd_sc_hd__decap_6
X_08698_ net2023 net296 net382 VGND VGND VPWR VPWR _00847_ sky130_fd_sc_hd__mux2_1
XTAP_TAPCELL_ROW_0_285 VGND VPWR sky130_fd_sc_hd__tapvpwrvgnd_1
XTAP_TAPCELL_ROW_0_296 VGND VPWR sky130_fd_sc_hd__tapvpwrvgnd_1
X_07649_ net681 _03746_ net623 VGND VGND VPWR VPWR _03747_ sky130_fd_sc_hd__a21o_1
X_10660_ clknet_leaf_37_clk _00514_ VGND VGND VPWR VPWR picorv32_core.cpuregs\[20\]\[28\]
+ sky130_fd_sc_hd__dfxtp_1
XFILLER_15_54 VGND VGND VPWR VPWR sky130_fd_sc_hd__fill_2
XFILLER_40_134 VGND VGND VPWR VPWR sky130_fd_sc_hd__fill_1
X_09319_ net835 _04511_ VGND VGND VPWR VPWR _04512_ sky130_fd_sc_hd__or2_1
X_10591_ clknet_leaf_84_clk _00445_ VGND VGND VPWR VPWR picorv32_core.instr_slti sky130_fd_sc_hd__dfxtp_1
Xclkbuf_leaf_114_clk clknet_4_8_0_clk VGND VGND VPWR VPWR clknet_leaf_114_clk sky130_fd_sc_hd__clkbuf_8
XFILLER_141_209 VPWR VGND VPWR VGND sky130_ef_sc_hd__decap_12
XTAP_TAPCELL_ROW_56_1123 VGND VPWR sky130_fd_sc_hd__tapvpwrvgnd_1
XTAP_TAPCELL_ROW_56_1112 VGND VPWR sky130_fd_sc_hd__tapvpwrvgnd_1
X_11212_ clknet_leaf_135_clk _01063_ VGND VGND VPWR VPWR picorv32_core.cpuregs\[5\]\[2\]
+ sky130_fd_sc_hd__dfxtp_1
Xoutput42 net42 VGND VGND VPWR VPWR mem_axi_araddr[13] sky130_fd_sc_hd__buf_2
Xoutput53 net53 VGND VGND VPWR VPWR mem_axi_araddr[24] sky130_fd_sc_hd__buf_2
X_11143_ clknet_leaf_69_clk _00994_ VGND VGND VPWR VPWR picorv32_core.cpuregs\[8\]\[29\]
+ sky130_fd_sc_hd__dfxtp_1
Xoutput75 net75 VGND VGND VPWR VPWR mem_axi_awaddr[14] sky130_fd_sc_hd__buf_2
Xoutput64 net64 VGND VGND VPWR VPWR mem_axi_araddr[5] sky130_fd_sc_hd__buf_2
XFILLER_1_753 VPWR VGND VPWR VGND sky130_ef_sc_hd__decap_12
Xoutput86 net86 VGND VGND VPWR VPWR mem_axi_awaddr[25] sky130_fd_sc_hd__buf_2
X_11074_ clknet_leaf_33_clk _00925_ VGND VGND VPWR VPWR picorv32_core.cpuregs\[10\]\[24\]
+ sky130_fd_sc_hd__dfxtp_1
Xoutput97 net97 VGND VGND VPWR VPWR mem_axi_awaddr[6] sky130_fd_sc_hd__buf_2
X_10025_ net1295 net254 net310 VGND VGND VPWR VPWR _01501_ sky130_fd_sc_hd__mux2_1
XFILLER_1_797 VPWR VGND VPWR VGND sky130_ef_sc_hd__decap_12
XFILLER_48_212 VGND VGND VPWR VPWR sky130_fd_sc_hd__fill_2
XFILLER_49_779 VGND VGND VPWR VPWR sky130_fd_sc_hd__decap_4
XFILLER_29_470 VGND VGND VPWR VPWR sky130_fd_sc_hd__fill_1
XFILLER_72_793 VGND VGND VPWR VPWR sky130_fd_sc_hd__decap_6
XTAP_TAPCELL_ROW_67_1274 VGND VPWR sky130_fd_sc_hd__tapvpwrvgnd_1
X_10927_ clknet_leaf_138_clk _00778_ VGND VGND VPWR VPWR picorv32_core.cpuregs\[19\]\[5\]
+ sky130_fd_sc_hd__dfxtp_1
XFILLER_72_60 VGND VGND VPWR VPWR sky130_fd_sc_hd__decap_3
XTAP_TAPCELL_ROW_27_693 VGND VPWR sky130_fd_sc_hd__tapvpwrvgnd_1
XTAP_TAPCELL_ROW_80_1463 VGND VPWR sky130_fd_sc_hd__tapvpwrvgnd_1
X_10858_ clknet_leaf_134_clk _00709_ VGND VGND VPWR VPWR picorv32_core.cpuregs\[16\]\[2\]
+ sky130_fd_sc_hd__dfxtp_1
X_10789_ clknet_leaf_63_clk _00640_ VGND VGND VPWR VPWR picorv32_core.cpuregs\[14\]\[30\]
+ sky130_fd_sc_hd__dfxtp_1
Xclkbuf_leaf_105_clk clknet_4_10_0_clk VGND VGND VPWR VPWR clknet_leaf_105_clk sky130_fd_sc_hd__clkbuf_8
XFILLER_140_231 VGND VGND VPWR VPWR sky130_fd_sc_hd__decap_4
Xfanout309 _05041_ VGND VGND VPWR VPWR net309 sky130_fd_sc_hd__clkbuf_4
XFILLER_141_776 VGND VGND VPWR VPWR sky130_fd_sc_hd__decap_4
X_06951_ _03143_ _03154_ VGND VGND VPWR VPWR _03166_ sky130_fd_sc_hd__nand2_1
X_09670_ net780 net542 VGND VGND VPWR VPWR _04847_ sky130_fd_sc_hd__or2_1
XFILLER_95_830 VGND VGND VPWR VPWR sky130_fd_sc_hd__fill_2
X_05902_ net960 net959 net958 net175 VGND VGND VPWR VPWR _02374_ sky130_fd_sc_hd__or4_2
XFILLER_94_362 VGND VGND VPWR VPWR sky130_fd_sc_hd__fill_2
X_06882_ _02927_ _03087_ _01703_ VGND VGND VPWR VPWR _03103_ sky130_fd_sc_hd__o21ai_1
X_08621_ _04325_ _04327_ VGND VGND VPWR VPWR _04334_ sky130_fd_sc_hd__nor2_2
XFILLER_94_373 VGND VGND VPWR VPWR sky130_fd_sc_hd__fill_2
XFILLER_67_598 VGND VGND VPWR VPWR sky130_fd_sc_hd__fill_2
X_05833_ net809 _02310_ VGND VGND VPWR VPWR _02311_ sky130_fd_sc_hd__and2_1
XFILLER_82_557 VGND VGND VPWR VPWR sky130_fd_sc_hd__decap_3
XPHY_EDGE_ROW_59_Left_201 VGND VGND VPWR VPWR sky130_fd_sc_hd__decap_3
X_05764_ picorv32_core.instr_xor picorv32_core.instr_xori VGND VGND VPWR VPWR _02248_
+ sky130_fd_sc_hd__nor2_2
XFILLER_54_237 VGND VGND VPWR VPWR sky130_fd_sc_hd__decap_6
X_08552_ net492 net1703 net399 VGND VGND VPWR VPWR _00677_ sky130_fd_sc_hd__mux2_1
XFILLER_35_440 VGND VGND VPWR VPWR sky130_fd_sc_hd__fill_1
X_07503_ picorv32_core.reg_out\[21\] picorv32_core.reg_next_pc\[21\] net558 VGND VGND
+ VPWR VPWR _03623_ sky130_fd_sc_hd__mux2_1
X_08483_ net1981 net493 net407 VGND VGND VPWR VPWR _00613_ sky130_fd_sc_hd__mux2_1
XTAP_TAPCELL_ROW_122_2080 VGND VPWR sky130_fd_sc_hd__tapvpwrvgnd_1
X_05695_ net779 net186 VGND VGND VPWR VPWR _02179_ sky130_fd_sc_hd__or2_1
X_07434_ picorv32_core.decoded_imm_j\[15\] _03573_ picorv32_core.is_lui_auipc_jal
+ VGND VGND VPWR VPWR _03574_ sky130_fd_sc_hd__o21ba_4
XFILLER_22_145 VGND VGND VPWR VPWR sky130_fd_sc_hd__fill_1
X_07365_ net783 picorv32_core.decoded_imm\[19\] VGND VGND VPWR VPWR _03505_ sky130_fd_sc_hd__nand2_1
X_09104_ net257 net2198 net334 VGND VGND VPWR VPWR _01271_ sky130_fd_sc_hd__mux2_1
XTAP_TAPCELL_ROW_98_1724 VGND VPWR sky130_fd_sc_hd__tapvpwrvgnd_1
X_06316_ _02725_ _02726_ VGND VGND VPWR VPWR _02727_ sky130_fd_sc_hd__nor2_1
X_07296_ _03434_ _03435_ VGND VGND VPWR VPWR _03436_ sky130_fd_sc_hd__nor2_1
X_09035_ net269 net2027 net342 VGND VGND VPWR VPWR _01204_ sky130_fd_sc_hd__mux2_1
XPHY_EDGE_ROW_68_Left_210 VGND VGND VPWR VPWR sky130_fd_sc_hd__decap_3
X_06247_ _02671_ picorv32_core.reg_pc\[1\] net563 VGND VGND VPWR VPWR _02672_ sky130_fd_sc_hd__mux2_2
Xhold352 picorv32_core.cpuregs\[3\]\[29\] VGND VGND VPWR VPWR net1461 sky130_fd_sc_hd__dlygate4sd3_1
XFILLER_132_732 VPWR VGND VPWR VGND sky130_ef_sc_hd__decap_12
Xhold330 picorv32_core.cpuregs\[22\]\[24\] VGND VGND VPWR VPWR net1439 sky130_fd_sc_hd__dlygate4sd3_1
Xhold341 picorv32_core.cpuregs\[25\]\[3\] VGND VGND VPWR VPWR net1450 sky130_fd_sc_hd__dlygate4sd3_1
X_06178_ picorv32_core.decoded_imm_j\[1\] picorv32_core.decoded_imm_j\[2\] picorv32_core.decoded_imm_j\[11\]
+ VGND VGND VPWR VPWR _02610_ sky130_fd_sc_hd__or3_1
Xhold385 picorv32_core.cpuregs\[5\]\[23\] VGND VGND VPWR VPWR net1494 sky130_fd_sc_hd__dlygate4sd3_1
XFILLER_117_78 VGND VGND VPWR VPWR sky130_fd_sc_hd__fill_1
XFILLER_104_445 VPWR VGND VPWR VGND sky130_ef_sc_hd__decap_12
X_05129_ picorv32_core.instr_fence picorv32_core.instr_and picorv32_core.instr_srli
+ picorv32_core.instr_jalr VGND VGND VPWR VPWR _01660_ sky130_fd_sc_hd__or4_1
Xhold363 picorv32_core.cpuregs\[15\]\[4\] VGND VGND VPWR VPWR net1472 sky130_fd_sc_hd__dlygate4sd3_1
Xhold374 picorv32_core.cpuregs\[21\]\[0\] VGND VGND VPWR VPWR net1483 sky130_fd_sc_hd__dlygate4sd3_1
Xhold396 picorv32_core.cpuregs\[30\]\[11\] VGND VGND VPWR VPWR net1505 sky130_fd_sc_hd__dlygate4sd3_1
Xfanout832 net833 VGND VGND VPWR VPWR net832 sky130_fd_sc_hd__buf_4
XFILLER_77_329 VGND VGND VPWR VPWR sky130_fd_sc_hd__fill_1
Xfanout821 net822 VGND VGND VPWR VPWR net821 sky130_fd_sc_hd__clkbuf_2
Xfanout843 net850 VGND VGND VPWR VPWR net843 sky130_fd_sc_hd__clkbuf_4
X_09937_ picorv32_core.is_slli_srli_srai picorv32_core.decoded_imm_j\[1\] _05037_
+ net914 VGND VGND VPWR VPWR _05038_ sky130_fd_sc_hd__a211o_1
Xfanout810 net169 VGND VGND VPWR VPWR net810 sky130_fd_sc_hd__buf_2
XFILLER_131_297 VGND VGND VPWR VPWR sky130_fd_sc_hd__fill_2
Xfanout865 net866 VGND VGND VPWR VPWR net865 sky130_fd_sc_hd__clkbuf_2
XTAP_TAPCELL_ROW_51_1042 VGND VPWR sky130_fd_sc_hd__tapvpwrvgnd_1
Xfanout854 _00006_ VGND VGND VPWR VPWR net854 sky130_fd_sc_hd__buf_2
Xfanout876 net883 VGND VGND VPWR VPWR net876 sky130_fd_sc_hd__buf_4
Xhold1030 picorv32_core.cpuregs\[1\]\[25\] VGND VGND VPWR VPWR net2139 sky130_fd_sc_hd__dlygate4sd3_1
Xhold1041 picorv32_core.cpuregs\[16\]\[28\] VGND VGND VPWR VPWR net2150 sky130_fd_sc_hd__dlygate4sd3_1
XFILLER_133_55 VGND VGND VPWR VPWR sky130_fd_sc_hd__fill_1
Xfanout898 net899 VGND VGND VPWR VPWR net898 sky130_fd_sc_hd__buf_4
XTAP_TAPCELL_ROW_5_377 VGND VPWR sky130_fd_sc_hd__tapvpwrvgnd_1
X_09868_ net1540 net445 net324 VGND VGND VPWR VPWR _01356_ sky130_fd_sc_hd__mux2_1
Xfanout887 net888 VGND VGND VPWR VPWR net887 sky130_fd_sc_hd__clkbuf_4
XFILLER_46_705 VPWR VGND VPWR VGND sky130_ef_sc_hd__decap_12
Xhold1074 picorv32_core.cpuregs\[8\]\[25\] VGND VGND VPWR VPWR net2183 sky130_fd_sc_hd__dlygate4sd3_1
Xhold1063 picorv32_core.cpuregs\[21\]\[21\] VGND VGND VPWR VPWR net2172 sky130_fd_sc_hd__dlygate4sd3_1
Xhold1085 picorv32_core.cpuregs\[25\]\[20\] VGND VGND VPWR VPWR net2194 sky130_fd_sc_hd__dlygate4sd3_1
XFILLER_100_673 VGND VGND VPWR VPWR sky130_fd_sc_hd__decap_3
X_09799_ net473 _04969_ VGND VGND VPWR VPWR _04970_ sky130_fd_sc_hd__nand2_1
X_08819_ net947 net948 net949 VGND VGND VPWR VPWR _04340_ sky130_fd_sc_hd__or3b_1
Xhold1052 picorv32_core.cpuregs\[18\]\[11\] VGND VGND VPWR VPWR net2161 sky130_fd_sc_hd__dlygate4sd3_1
XTAP_TAPCELL_ROW_107_1853 VGND VPWR sky130_fd_sc_hd__tapvpwrvgnd_1
X_11830_ net63 VGND VGND VPWR VPWR net95 sky130_fd_sc_hd__clkbuf_1
Xhold1096 picorv32_core.cpuregs\[23\]\[4\] VGND VGND VPWR VPWR net2205 sky130_fd_sc_hd__dlygate4sd3_1
XTAP_TAPCELL_ROW_44_939 VGND VPWR sky130_fd_sc_hd__tapvpwrvgnd_1
X_10712_ clknet_leaf_26_clk _00563_ VGND VGND VPWR VPWR net118 sky130_fd_sc_hd__dfxtp_1
XFILLER_54_793 VGND VGND VPWR VPWR sky130_fd_sc_hd__decap_8
XTAP_TAPCELL_ROW_24_652 VGND VPWR sky130_fd_sc_hd__tapvpwrvgnd_1
X_11692_ clknet_leaf_1_clk _01523_ VGND VGND VPWR VPWR picorv32_core.cpuregs\[27\]\[9\]
+ sky130_fd_sc_hd__dfxtp_1
X_10643_ clknet_leaf_2_clk _00497_ VGND VGND VPWR VPWR picorv32_core.cpuregs\[20\]\[11\]
+ sky130_fd_sc_hd__dfxtp_1
XFILLER_139_364 VGND VGND VPWR VPWR sky130_fd_sc_hd__fill_2
X_10574_ clknet_leaf_60_clk _00428_ VGND VGND VPWR VPWR picorv32_core.cpuregs\[25\]\[30\]
+ sky130_fd_sc_hd__dfxtp_1
XFILLER_42_63 VGND VGND VPWR VPWR sky130_fd_sc_hd__fill_1
XFILLER_127_526 VGND VGND VPWR VPWR sky130_fd_sc_hd__decap_4
XFILLER_135_570 VGND VGND VPWR VPWR sky130_fd_sc_hd__fill_2
XFILLER_123_721 VGND VGND VPWR VPWR sky130_fd_sc_hd__decap_6
XFILLER_135_592 VGND VGND VPWR VPWR sky130_fd_sc_hd__decap_3
XFILLER_123_765 VPWR VGND VPWR VGND sky130_ef_sc_hd__decap_12
XFILLER_68_307 VGND VGND VPWR VPWR sky130_fd_sc_hd__fill_1
X_11126_ clknet_leaf_10_clk _00977_ VGND VGND VPWR VPWR picorv32_core.cpuregs\[8\]\[12\]
+ sky130_fd_sc_hd__dfxtp_1
XFILLER_110_437 VPWR VGND VPWR VGND sky130_ef_sc_hd__decap_12
XFILLER_3_57 VPWR VGND VPWR VGND sky130_ef_sc_hd__decap_12
XTAP_TAPCELL_ROW_69_1303 VGND VPWR sky130_fd_sc_hd__tapvpwrvgnd_1
X_11057_ clknet_leaf_130_clk _00908_ VGND VGND VPWR VPWR picorv32_core.cpuregs\[10\]\[7\]
+ sky130_fd_sc_hd__dfxtp_1
XFILLER_64_513 VGND VGND VPWR VPWR sky130_fd_sc_hd__fill_1
X_10008_ net1364 net497 net308 VGND VGND VPWR VPWR _01484_ sky130_fd_sc_hd__mux2_1
X_05480_ net911 net303 _01972_ _01976_ VGND VGND VPWR VPWR _01977_ sky130_fd_sc_hd__a31o_1
X_07150_ picorv32_core.count_cycle\[28\] _03324_ net977 VGND VGND VPWR VPWR _03326_
+ sky130_fd_sc_hd__a21oi_1
X_06101_ net768 net192 net608 VGND VGND VPWR VPWR _02558_ sky130_fd_sc_hd__o21a_1
X_07081_ picorv32_core.count_cycle\[0\] picorv32_core.count_cycle\[1\] picorv32_core.count_cycle\[2\]
+ VGND VGND VPWR VPWR _03283_ sky130_fd_sc_hd__and3_1
XFILLER_8_193 VGND VGND VPWR VPWR sky130_fd_sc_hd__decap_3
XFILLER_8_182 VGND VGND VPWR VPWR sky130_fd_sc_hd__decap_3
X_06032_ _02179_ _02493_ _02494_ _02492_ VGND VGND VPWR VPWR picorv32_core.alu_out\[21\]
+ sky130_fd_sc_hd__a211o_1
XTAP_TAPCELL_ROW_93_1654 VGND VPWR sky130_fd_sc_hd__tapvpwrvgnd_1
X_07983_ picorv32_core.cpuregs\[24\]\[26\] picorv32_core.cpuregs\[25\]\[26\] picorv32_core.cpuregs\[26\]\[26\]
+ picorv32_core.cpuregs\[27\]\[26\] net760 net727 VGND VGND VPWR VPWR _04062_ sky130_fd_sc_hd__mux4_1
X_09722_ picorv32_core.cpuregs\[12\]\[24\] picorv32_core.cpuregs\[13\]\[24\] picorv32_core.cpuregs\[14\]\[24\]
+ picorv32_core.cpuregs\[15\]\[24\] net894 net860 VGND VGND VPWR VPWR _04897_ sky130_fd_sc_hd__mux4_1
XFILLER_47_19 VGND VGND VPWR VPWR sky130_fd_sc_hd__decap_3
X_06934_ net667 picorv32_core.reg_next_pc\[19\] _02931_ net490 VGND VGND VPWR VPWR
+ _03151_ sky130_fd_sc_hd__a22o_1
X_09653_ picorv32_core.cpuregs\[24\]\[21\] picorv32_core.cpuregs\[25\]\[21\] picorv32_core.cpuregs\[26\]\[21\]
+ picorv32_core.cpuregs\[27\]\[21\] net899 net865 VGND VGND VPWR VPWR _04831_ sky130_fd_sc_hd__mux4_1
X_06865_ _02925_ _02926_ _03062_ VGND VGND VPWR VPWR _03087_ sky130_fd_sc_hd__and3_1
XTAP_TAPCELL_ROW_2_336 VGND VPWR sky130_fd_sc_hd__tapvpwrvgnd_1
X_08604_ net249 net1871 net396 VGND VGND VPWR VPWR _00727_ sky130_fd_sc_hd__mux2_1
X_09584_ picorv32_core.cpuregs\[24\]\[18\] picorv32_core.cpuregs\[25\]\[18\] picorv32_core.cpuregs\[26\]\[18\]
+ picorv32_core.cpuregs\[27\]\[18\] net893 net859 VGND VGND VPWR VPWR _04765_ sky130_fd_sc_hd__mux4_1
X_05816_ net964 _02294_ VGND VGND VPWR VPWR _02295_ sky130_fd_sc_hd__xnor2_1
XPHY_EDGE_ROW_118_Right_118 VGND VGND VPWR VPWR sky130_fd_sc_hd__decap_3
X_08535_ net1980 net247 net404 VGND VGND VPWR VPWR _00662_ sky130_fd_sc_hd__mux2_1
XFILLER_82_365 VGND VGND VPWR VPWR sky130_fd_sc_hd__decap_8
X_06796_ picorv32_core.decoded_imm_j\[9\] _02921_ VGND VGND VPWR VPWR _03023_ sky130_fd_sc_hd__xnor2_1
XTAP_TAPCELL_ROW_120_2039 VGND VPWR sky130_fd_sc_hd__tapvpwrvgnd_1
X_05747_ net787 _01609_ _02230_ net789 VGND VGND VPWR VPWR _02231_ sky130_fd_sc_hd__o22a_1
XFILLER_51_741 VGND VGND VPWR VPWR sky130_fd_sc_hd__fill_1
X_05678_ _02160_ _02161_ _02159_ VGND VGND VPWR VPWR _02162_ sky130_fd_sc_hd__a21o_1
X_08466_ picorv32_core.mem_rdata_q\[11\] _04282_ VGND VGND VPWR VPWR _04314_ sky130_fd_sc_hd__and2_1
X_07417_ net833 _03556_ VGND VGND VPWR VPWR _03557_ sky130_fd_sc_hd__nor2_1
XTAP_TAPCELL_ROW_102_1783 VGND VPWR sky130_fd_sc_hd__tapvpwrvgnd_1
XFILLER_11_649 VGND VGND VPWR VPWR sky130_fd_sc_hd__decap_3
XTAP_TAPCELL_ROW_21_611 VGND VPWR sky130_fd_sc_hd__tapvpwrvgnd_1
X_08397_ _01714_ _04271_ _04270_ VGND VGND VPWR VPWR _04275_ sky130_fd_sc_hd__a21oi_1
X_07348_ _03428_ _03487_ VGND VGND VPWR VPWR _03488_ sky130_fd_sc_hd__nand2_1
XFILLER_109_526 VGND VGND VPWR VPWR sky130_fd_sc_hd__fill_1
XTAP_TAPCELL_ROW_135_2260 VGND VPWR sky130_fd_sc_hd__tapvpwrvgnd_1
X_07279_ net781 picorv32_core.decoded_imm\[20\] VGND VGND VPWR VPWR _03419_ sky130_fd_sc_hd__nand2_1
XFILLER_12_77 VGND VGND VPWR VPWR sky130_fd_sc_hd__decap_6
XFILLER_128_77 VGND VGND VPWR VPWR sky130_fd_sc_hd__decap_6
XFILLER_124_529 VGND VGND VPWR VPWR sky130_fd_sc_hd__decap_3
XFILLER_124_518 VGND VGND VPWR VPWR sky130_fd_sc_hd__fill_1
X_09018_ net206 net1859 net347 VGND VGND VPWR VPWR _01188_ sky130_fd_sc_hd__mux2_1
XFILLER_117_570 VGND VGND VPWR VPWR sky130_fd_sc_hd__decap_3
X_10290_ clknet_leaf_90_clk _00209_ VGND VGND VPWR VPWR picorv32_core.reg_pc\[11\]
+ sky130_fd_sc_hd__dfxtp_1
XFILLER_2_303 VGND VGND VPWR VPWR sky130_fd_sc_hd__fill_1
Xhold160 picorv32_core.cpuregs\[9\]\[15\] VGND VGND VPWR VPWR net1269 sky130_fd_sc_hd__dlygate4sd3_1
Xhold171 picorv32_core.cpuregs\[14\]\[4\] VGND VGND VPWR VPWR net1280 sky130_fd_sc_hd__dlygate4sd3_1
XFILLER_105_776 VGND VGND VPWR VPWR sky130_fd_sc_hd__fill_1
XFILLER_78_616 VGND VGND VPWR VPWR sky130_fd_sc_hd__decap_4
Xhold193 picorv32_core.cpuregs\[23\]\[15\] VGND VGND VPWR VPWR net1302 sky130_fd_sc_hd__dlygate4sd3_1
Xhold182 picorv32_core.cpuregs\[23\]\[14\] VGND VGND VPWR VPWR net1291 sky130_fd_sc_hd__dlygate4sd3_1
Xfanout640 net641 VGND VGND VPWR VPWR net640 sky130_fd_sc_hd__clkbuf_4
XFILLER_120_757 VPWR VGND VPWR VGND sky130_ef_sc_hd__decap_12
Xfanout651 _01617_ VGND VGND VPWR VPWR net651 sky130_fd_sc_hd__buf_4
XFILLER_78_649 VGND VGND VPWR VPWR sky130_fd_sc_hd__fill_1
Xfanout684 net685 VGND VGND VPWR VPWR net684 sky130_fd_sc_hd__clkbuf_4
XFILLER_93_608 VGND VGND VPWR VPWR sky130_fd_sc_hd__decap_8
Xfanout662 _01616_ VGND VGND VPWR VPWR net662 sky130_fd_sc_hd__buf_4
Xfanout673 net674 VGND VGND VPWR VPWR net673 sky130_fd_sc_hd__buf_2
Xfanout695 net697 VGND VGND VPWR VPWR net695 sky130_fd_sc_hd__clkbuf_4
XFILLER_92_118 VGND VGND VPWR VPWR sky130_fd_sc_hd__fill_1
XFILLER_86_693 VGND VGND VPWR VPWR sky130_fd_sc_hd__fill_1
XTAP_TAPCELL_ROW_29_722 VGND VPWR sky130_fd_sc_hd__tapvpwrvgnd_1
XFILLER_100_492 VPWR VGND VPWR VGND sky130_ef_sc_hd__decap_12
XFILLER_85_192 VGND VGND VPWR VPWR sky130_fd_sc_hd__fill_1
XFILLER_85_181 VGND VGND VPWR VPWR sky130_fd_sc_hd__fill_2
XFILLER_73_321 VGND VGND VPWR VPWR sky130_fd_sc_hd__decap_3
XFILLER_46_546 VGND VGND VPWR VPWR sky130_fd_sc_hd__fill_1
XTAP_TAPCELL_ROW_64_1233 VGND VPWR sky130_fd_sc_hd__tapvpwrvgnd_1
XFILLER_14_410 VGND VGND VPWR VPWR sky130_fd_sc_hd__fill_1
XFILLER_14_421 VGND VGND VPWR VPWR sky130_fd_sc_hd__decap_4
X_11675_ clknet_leaf_39_clk _01506_ VGND VGND VPWR VPWR picorv32_core.cpuregs\[26\]\[24\]
+ sky130_fd_sc_hd__dfxtp_1
XFILLER_128_813 VPWR VGND VPWR VGND sky130_ef_sc_hd__decap_12
X_10626_ clknet_leaf_88_clk _00480_ VGND VGND VPWR VPWR picorv32_core.decoded_imm_j\[10\]
+ sky130_fd_sc_hd__dfxtp_1
XFILLER_10_671 VGND VGND VPWR VPWR sky130_fd_sc_hd__fill_1
X_10557_ clknet_leaf_12_clk _00411_ VGND VGND VPWR VPWR picorv32_core.cpuregs\[25\]\[13\]
+ sky130_fd_sc_hd__dfxtp_1
XFILLER_6_642 VGND VGND VPWR VPWR sky130_fd_sc_hd__fill_2
X_10488_ clknet_leaf_17_clk _00374_ VGND VGND VPWR VPWR net178 sky130_fd_sc_hd__dfxtp_2
XFILLER_111_702 VGND VGND VPWR VPWR sky130_fd_sc_hd__fill_2
XFILLER_96_413 VGND VGND VPWR VPWR sky130_fd_sc_hd__decap_6
XTAP_TAPCELL_ROW_75_1395 VGND VPWR sky130_fd_sc_hd__tapvpwrvgnd_1
X_11109_ clknet_leaf_42_clk _00960_ VGND VGND VPWR VPWR picorv32_core.cpuregs\[0\]\[27\]
+ sky130_fd_sc_hd__dfxtp_1
XFILLER_1_391 VGND VGND VPWR VPWR sky130_fd_sc_hd__fill_1
XFILLER_92_641 VGND VGND VPWR VPWR sky130_fd_sc_hd__decap_3
X_06650_ picorv32_core.reg_pc\[2\] net551 _02914_ net514 VGND VGND VPWR VPWR _00200_
+ sky130_fd_sc_hd__a22o_1
X_05601_ net579 _02087_ _02088_ net767 net917 VGND VGND VPWR VPWR _02089_ sky130_fd_sc_hd__a32o_1
XFILLER_64_365 VGND VGND VPWR VPWR sky130_fd_sc_hd__fill_2
X_06581_ net2287 _02868_ net986 VGND VGND VPWR VPWR _02870_ sky130_fd_sc_hd__o21ai_1
XFILLER_17_281 VGND VGND VPWR VPWR sky130_fd_sc_hd__decap_4
XFILLER_18_793 VPWR VGND VPWR VGND sky130_ef_sc_hd__decap_12
X_05532_ picorv32_core.count_cycle\[23\] net600 VGND VGND VPWR VPWR _02025_ sky130_fd_sc_hd__or2_1
X_08320_ net2291 _02600_ _04176_ _04230_ VGND VGND VPWR VPWR _00539_ sky130_fd_sc_hd__a22o_1
X_05463_ picorv32_core.count_instr\[50\] net938 net942 picorv32_core.count_instr\[18\]
+ VGND VGND VPWR VPWR _01961_ sky130_fd_sc_hd__a22o_1
X_08251_ picorv32_core.mem_rdata_q\[29\] net25 net520 VGND VGND VPWR VPWR _00770_
+ sky130_fd_sc_hd__mux2_1
XFILLER_33_785 VPWR VGND VPWR VGND sky130_ef_sc_hd__decap_12
X_07202_ _03358_ net991 _03357_ VGND VGND VPWR VPWR _00308_ sky130_fd_sc_hd__and3b_1
X_05394_ _01822_ _01895_ _01896_ _01817_ VGND VGND VPWR VPWR _01897_ sky130_fd_sc_hd__a31o_1
X_08182_ net2245 net522 _04196_ net2098 VGND VGND VPWR VPWR _00441_ sky130_fd_sc_hd__a22o_1
XFILLER_134_805 VGND VGND VPWR VPWR sky130_fd_sc_hd__decap_6
X_07133_ _03314_ _03315_ VGND VGND VPWR VPWR _00282_ sky130_fd_sc_hd__nor2_1
XFILLER_118_389 VGND VGND VPWR VPWR sky130_fd_sc_hd__fill_2
X_07064_ _01701_ _03269_ VGND VGND VPWR VPWR _03270_ sky130_fd_sc_hd__nor2_1
XPHY_EDGE_ROW_12_Right_12 VGND VGND VPWR VPWR sky130_fd_sc_hd__decap_3
X_06015_ _02474_ _02476_ _02477_ _02478_ VGND VGND VPWR VPWR _02479_ sky130_fd_sc_hd__nand4_1
XTAP_TAPCELL_ROW_7_406 VGND VPWR sky130_fd_sc_hd__tapvpwrvgnd_1
XFILLER_114_573 VGND VGND VPWR VPWR sky130_fd_sc_hd__decap_8
XFILLER_102_713 VGND VGND VPWR VPWR sky130_fd_sc_hd__fill_1
XTAP_TAPCELL_ROW_130_2190 VGND VPWR sky130_fd_sc_hd__tapvpwrvgnd_1
X_07966_ picorv32_core.cpuregs\[28\]\[25\] picorv32_core.cpuregs\[29\]\[25\] picorv32_core.cpuregs\[30\]\[25\]
+ picorv32_core.cpuregs\[31\]\[25\] net761 net728 VGND VGND VPWR VPWR _04046_ sky130_fd_sc_hd__mux4_1
X_09705_ _04874_ _04875_ _04877_ _04876_ net659 net646 VGND VGND VPWR VPWR _04881_
+ sky130_fd_sc_hd__mux4_1
X_06917_ _02929_ _02930_ _03111_ VGND VGND VPWR VPWR _03135_ sky130_fd_sc_hd__and3_1
XFILLER_56_811 VGND VGND VPWR VPWR sky130_fd_sc_hd__fill_1
X_07897_ picorv32_core.cpuregs\[4\]\[21\] picorv32_core.cpuregs\[5\]\[21\] picorv32_core.cpuregs\[6\]\[21\]
+ picorv32_core.cpuregs\[7\]\[21\] net755 net722 VGND VGND VPWR VPWR _03981_ sky130_fd_sc_hd__mux4_1
X_09636_ _04806_ _04807_ _04813_ _04814_ net659 net646 VGND VGND VPWR VPWR _04815_
+ sky130_fd_sc_hd__mux4_1
XFILLER_55_321 VGND VGND VPWR VPWR sky130_fd_sc_hd__fill_1
Xclkbuf_leaf_94_clk clknet_4_9_0_clk VGND VGND VPWR VPWR clknet_leaf_94_clk sky130_fd_sc_hd__clkbuf_8
X_06848_ _03046_ _03058_ VGND VGND VPWR VPWR _03071_ sky130_fd_sc_hd__nand2b_1
XPHY_EDGE_ROW_21_Right_21 VGND VGND VPWR VPWR sky130_fd_sc_hd__decap_3
XTAP_TAPCELL_ROW_104_1812 VGND VPWR sky130_fd_sc_hd__tapvpwrvgnd_1
X_09567_ net838 _04748_ VGND VGND VPWR VPWR _04749_ sky130_fd_sc_hd__or2_1
XFILLER_71_836 VGND VGND VPWR VPWR sky130_fd_sc_hd__fill_1
X_06779_ _02919_ _02994_ VGND VGND VPWR VPWR _03008_ sky130_fd_sc_hd__nor2_1
XFILLER_90_27 VGND VGND VPWR VPWR sky130_fd_sc_hd__fill_1
X_09498_ picorv32_core.cpuregs\[24\]\[14\] picorv32_core.cpuregs\[25\]\[14\] picorv32_core.cpuregs\[26\]\[14\]
+ picorv32_core.cpuregs\[27\]\[14\] net880 net847 VGND VGND VPWR VPWR _04683_ sky130_fd_sc_hd__mux4_1
X_08518_ net1500 net493 net403 VGND VGND VPWR VPWR _00645_ sky130_fd_sc_hd__mux2_1
XFILLER_23_240 VGND VGND VPWR VPWR sky130_fd_sc_hd__fill_1
X_08449_ net680 picorv32_core.decoded_imm_j\[12\] net615 net930 VGND VGND VPWR VPWR
+ _04305_ sky130_fd_sc_hd__a22o_1
XTAP_TAPCELL_ROW_34_791 VGND VPWR sky130_fd_sc_hd__tapvpwrvgnd_1
XFILLER_128_3 VPWR VGND VPWR VGND sky130_ef_sc_hd__decap_12
X_11460_ clknet_leaf_12_clk _01296_ VGND VGND VPWR VPWR picorv32_core.cpuregs\[24\]\[11\]
+ sky130_fd_sc_hd__dfxtp_1
X_11391_ clknet_leaf_141_clk _01227_ VGND VGND VPWR VPWR picorv32_core.cpuregs\[31\]\[6\]
+ sky130_fd_sc_hd__dfxtp_1
XPHY_EDGE_ROW_30_Right_30 VGND VGND VPWR VPWR sky130_fd_sc_hd__decap_3
X_10411_ clknet_leaf_123_clk _01573_ VGND VGND VPWR VPWR picorv32_core.reg_out\[4\]
+ sky130_fd_sc_hd__dfxtp_1
XFILLER_109_389 VGND VGND VPWR VPWR sky130_fd_sc_hd__decap_3
X_10342_ clknet_leaf_107_clk _00261_ VGND VGND VPWR VPWR picorv32_core.count_cycle\[0\]
+ sky130_fd_sc_hd__dfxtp_1
XTAP_TAPCELL_ROW_115_1974 VGND VPWR sky130_fd_sc_hd__tapvpwrvgnd_1
X_10273_ clknet_leaf_78_clk _00192_ VGND VGND VPWR VPWR picorv32_core.count_instr\[57\]
+ sky130_fd_sc_hd__dfxtp_1
XFILLER_2_133 VGND VGND VPWR VPWR sky130_fd_sc_hd__decap_6
XFILLER_78_413 VGND VGND VPWR VPWR sky130_fd_sc_hd__decap_3
XFILLER_2_177 VPWR VGND VPWR VGND sky130_ef_sc_hd__decap_12
Xfanout481 _03574_ VGND VGND VPWR VPWR net481 sky130_fd_sc_hd__buf_4
XFILLER_93_416 VGND VGND VPWR VPWR sky130_fd_sc_hd__decap_8
Xfanout470 net471 VGND VGND VPWR VPWR net470 sky130_fd_sc_hd__buf_2
XFILLER_59_671 VGND VGND VPWR VPWR sky130_fd_sc_hd__fill_1
Xfanout492 net493 VGND VGND VPWR VPWR net492 sky130_fd_sc_hd__clkbuf_2
XFILLER_47_800 VGND VGND VPWR VPWR sky130_fd_sc_hd__fill_1
XFILLER_93_449 VGND VGND VPWR VPWR sky130_fd_sc_hd__decap_3
Xclkbuf_leaf_85_clk clknet_4_14_0_clk VGND VGND VPWR VPWR clknet_leaf_85_clk sky130_fd_sc_hd__clkbuf_8
XFILLER_0_69 VPWR VGND VPWR VGND sky130_ef_sc_hd__decap_12
XFILLER_34_516 VGND VGND VPWR VPWR sky130_fd_sc_hd__decap_6
XFILLER_46_365 VGND VGND VPWR VPWR sky130_fd_sc_hd__fill_1
XFILLER_64_50 VGND VGND VPWR VPWR sky130_fd_sc_hd__decap_6
XFILLER_61_335 VGND VGND VPWR VPWR sky130_fd_sc_hd__fill_1
XPHY_EDGE_ROW_14_Left_156 VGND VGND VPWR VPWR sky130_fd_sc_hd__decap_3
XFILLER_15_741 VPWR VGND VPWR VGND sky130_ef_sc_hd__decap_12
XFILLER_14_251 VGND VGND VPWR VPWR sky130_fd_sc_hd__fill_1
XFILLER_15_785 VPWR VGND VPWR VGND sky130_ef_sc_hd__decap_12
XFILLER_42_560 VGND VGND VPWR VPWR sky130_fd_sc_hd__fill_1
X_11658_ clknet_leaf_131_clk _01489_ VGND VGND VPWR VPWR picorv32_core.cpuregs\[26\]\[7\]
+ sky130_fd_sc_hd__dfxtp_1
XFILLER_116_805 VGND VGND VPWR VPWR sky130_fd_sc_hd__decap_6
X_10609_ clknet_leaf_93_clk _00463_ VGND VGND VPWR VPWR picorv32_core.instr_xor sky130_fd_sc_hd__dfxtp_1
XTAP_TAPCELL_ROW_12_474 VGND VPWR sky130_fd_sc_hd__tapvpwrvgnd_1
XTAP_TAPCELL_ROW_12_485 VGND VPWR sky130_fd_sc_hd__tapvpwrvgnd_1
X_11589_ clknet_leaf_133_clk _01420_ VGND VGND VPWR VPWR picorv32_core.cpuregs\[23\]\[2\]
+ sky130_fd_sc_hd__dfxtp_1
Xhold907 picorv32_core.cpuregs\[13\]\[23\] VGND VGND VPWR VPWR net2016 sky130_fd_sc_hd__dlygate4sd3_1
Xhold918 picorv32_core.cpuregs\[18\]\[15\] VGND VGND VPWR VPWR net2027 sky130_fd_sc_hd__dlygate4sd3_1
XTAP_TAPCELL_ROW_77_1424 VGND VPWR sky130_fd_sc_hd__tapvpwrvgnd_1
Xhold929 picorv32_core.cpuregs\[16\]\[31\] VGND VGND VPWR VPWR net2038 sky130_fd_sc_hd__dlygate4sd3_1
XFILLER_130_318 VGND VGND VPWR VPWR sky130_fd_sc_hd__decap_4
XFILLER_130_307 VGND VGND VPWR VPWR sky130_fd_sc_hd__fill_1
XTAP_TAPCELL_ROW_90_1613 VGND VPWR sky130_fd_sc_hd__tapvpwrvgnd_1
XPHY_EDGE_ROW_23_Left_165 VGND VGND VPWR VPWR sky130_fd_sc_hd__decap_3
XFILLER_43_3 VPWR VGND VPWR VGND sky130_ef_sc_hd__decap_12
XFILLER_69_424 VGND VGND VPWR VPWR sky130_fd_sc_hd__decap_3
X_07820_ picorv32_core.cpuregs\[24\]\[17\] picorv32_core.cpuregs\[25\]\[17\] picorv32_core.cpuregs\[26\]\[17\]
+ picorv32_core.cpuregs\[27\]\[17\] net747 net714 VGND VGND VPWR VPWR _03908_ sky130_fd_sc_hd__mux4_1
XFILLER_69_446 VGND VGND VPWR VPWR sky130_fd_sc_hd__fill_2
X_07751_ picorv32_core.cpuregs\[24\]\[13\] picorv32_core.cpuregs\[25\]\[13\] picorv32_core.cpuregs\[26\]\[13\]
+ picorv32_core.cpuregs\[27\]\[13\] net739 net706 VGND VGND VPWR VPWR _03843_ sky130_fd_sc_hd__mux4_1
X_06702_ picorv32_core.reg_pc\[28\] net553 _02940_ net516 VGND VGND VPWR VPWR _00226_
+ sky130_fd_sc_hd__a22o_1
Xclkbuf_leaf_76_clk clknet_4_15_0_clk VGND VGND VPWR VPWR clknet_leaf_76_clk sky130_fd_sc_hd__clkbuf_8
XTAP_TAPCELL_ROW_88_1586 VGND VPWR sky130_fd_sc_hd__tapvpwrvgnd_1
XTAP_TAPCELL_ROW_88_1575 VGND VPWR sky130_fd_sc_hd__tapvpwrvgnd_1
X_07682_ net627 _03768_ net681 VGND VGND VPWR VPWR _03778_ sky130_fd_sc_hd__o21a_1
X_06633_ picorv32_core.count_instr\[59\] _02900_ picorv32_core.count_instr\[60\] VGND
+ VGND VPWR VPWR _02903_ sky130_fd_sc_hd__a21o_1
XFILLER_92_493 VGND VGND VPWR VPWR sky130_fd_sc_hd__fill_2
XFILLER_64_195 VGND VGND VPWR VPWR sky130_fd_sc_hd__fill_1
X_09421_ net800 net281 VGND VGND VPWR VPWR _04609_ sky130_fd_sc_hd__and2_1
XPHY_EDGE_ROW_32_Left_174 VGND VGND VPWR VPWR sky130_fd_sc_hd__decap_3
X_09352_ picorv32_core.reg_pc\[7\] net536 _04543_ net482 VGND VGND VPWR VPWR _04544_
+ sky130_fd_sc_hd__a211o_1
X_06564_ picorv32_core.count_instr\[35\] picorv32_core.count_instr\[34\] picorv32_core.count_instr\[33\]
+ _02854_ VGND VGND VPWR VPWR _02859_ sky130_fd_sc_hd__and4_1
XFILLER_100_15 VPWR VGND VPWR VGND sky130_ef_sc_hd__decap_12
X_05515_ _01994_ _01997_ _02007_ VGND VGND VPWR VPWR _02009_ sky130_fd_sc_hd__a21o_1
X_08303_ net1125 _00752_ net437 VGND VGND VPWR VPWR _00522_ sky130_fd_sc_hd__mux2_1
X_06495_ picorv32_core.count_instr\[10\] picorv32_core.count_instr\[9\] picorv32_core.count_instr\[8\]
+ _02810_ VGND VGND VPWR VPWR _02815_ sky130_fd_sc_hd__and4_1
X_09283_ picorv32_core.reg_pc\[4\] net536 _04477_ net479 net482 VGND VGND VPWR VPWR
+ _04478_ sky130_fd_sc_hd__a221o_1
XFILLER_138_429 VGND VGND VPWR VPWR sky130_fd_sc_hd__fill_2
XTAP_TAPCELL_ROW_119_2030 VGND VPWR sky130_fd_sc_hd__tapvpwrvgnd_1
X_05446_ picorv32_core.reg_pc\[16\] picorv32_core.decoded_imm\[16\] _01934_ _01944_
+ VGND VGND VPWR VPWR _01945_ sky130_fd_sc_hd__a211o_1
X_08234_ _04218_ _04219_ net944 net523 VGND VGND VPWR VPWR _00470_ sky130_fd_sc_hd__a2bb2o_1
XFILLER_21_777 VGND VGND VPWR VPWR sky130_fd_sc_hd__decap_6
XTAP_TAPCELL_ROW_31_750 VGND VPWR sky130_fd_sc_hd__tapvpwrvgnd_1
XTAP_TAPCELL_ROW_31_761 VGND VPWR sky130_fd_sc_hd__tapvpwrvgnd_1
X_08165_ net930 picorv32_core.mem_rdata_q\[13\] net929 VGND VGND VPWR VPWR _04188_
+ sky130_fd_sc_hd__and3b_1
X_05377_ _01879_ _01880_ VGND VGND VPWR VPWR _01881_ sky130_fd_sc_hd__nand2_1
XFILLER_134_602 VGND VGND VPWR VPWR sky130_fd_sc_hd__decap_4
XFILLER_106_304 VGND VGND VPWR VPWR sky130_fd_sc_hd__decap_4
X_07116_ net2249 _03303_ net993 VGND VGND VPWR VPWR _03305_ sky130_fd_sc_hd__o21ai_1
XFILLER_133_101 VGND VGND VPWR VPWR sky130_fd_sc_hd__decap_3
XFILLER_118_197 VGND VGND VPWR VPWR sky130_fd_sc_hd__decap_3
XFILLER_109_68 VGND VGND VPWR VPWR sky130_fd_sc_hd__fill_2
XFILLER_69_28 VGND VGND VPWR VPWR sky130_fd_sc_hd__decap_4
Xclkload80 clknet_leaf_112_clk VGND VGND VPWR VPWR clkload80/Y sky130_fd_sc_hd__clkinv_4
X_08096_ net921 net665 _01708_ net950 net982 VGND VGND VPWR VPWR _00393_ sky130_fd_sc_hd__o221a_1
XPHY_EDGE_ROW_41_Left_183 VGND VGND VPWR VPWR sky130_fd_sc_hd__decap_3
X_07047_ _03232_ _03234_ _03244_ _03253_ _03233_ VGND VGND VPWR VPWR _03254_ sky130_fd_sc_hd__a311o_1
Xclkload91 clknet_leaf_92_clk VGND VGND VPWR VPWR clkload91/Y sky130_fd_sc_hd__clkinv_2
XFILLER_0_615 VGND VGND VPWR VPWR sky130_fd_sc_hd__fill_1
XFILLER_0_637 VGND VGND VPWR VPWR sky130_fd_sc_hd__decap_3
XFILLER_88_777 VGND VGND VPWR VPWR sky130_fd_sc_hd__fill_1
XTAP_TAPCELL_ROW_110_1893 VGND VPWR sky130_fd_sc_hd__tapvpwrvgnd_1
XFILLER_102_587 VGND VGND VPWR VPWR sky130_fd_sc_hd__fill_1
XFILLER_75_427 VGND VGND VPWR VPWR sky130_fd_sc_hd__decap_3
XFILLER_75_405 VPWR VGND VPWR VGND sky130_ef_sc_hd__decap_12
X_08998_ net293 net1750 net344 VGND VGND VPWR VPWR _01168_ sky130_fd_sc_hd__mux2_1
Xclkbuf_leaf_67_clk clknet_4_13_0_clk VGND VGND VPWR VPWR clknet_leaf_67_clk sky130_fd_sc_hd__clkbuf_8
X_07949_ picorv32_core.cpuregs\[24\]\[24\] picorv32_core.cpuregs\[25\]\[24\] picorv32_core.cpuregs\[26\]\[24\]
+ picorv32_core.cpuregs\[27\]\[24\] net753 net720 VGND VGND VPWR VPWR _04030_ sky130_fd_sc_hd__mux4_1
XPHY_EDGE_ROW_50_Left_192 VGND VGND VPWR VPWR sky130_fd_sc_hd__decap_3
X_10960_ clknet_leaf_142_clk _00811_ VGND VGND VPWR VPWR picorv32_core.cpuregs\[13\]\[6\]
+ sky130_fd_sc_hd__dfxtp_1
XFILLER_18_65 VPWR VGND VPWR VGND sky130_ef_sc_hd__decap_12
XFILLER_28_354 VGND VGND VPWR VPWR sky130_fd_sc_hd__fill_1
XTAP_TAPCELL_ROW_39_872 VGND VPWR sky130_fd_sc_hd__tapvpwrvgnd_1
XTAP_TAPCELL_ROW_48_1003 VGND VPWR sky130_fd_sc_hd__tapvpwrvgnd_1
X_09619_ net832 _04796_ _04798_ net480 VGND VGND VPWR VPWR _04799_ sky130_fd_sc_hd__o211a_1
XFILLER_71_633 VGND VGND VPWR VPWR sky130_fd_sc_hd__fill_2
X_10891_ clknet_leaf_99_clk _00742_ VGND VGND VPWR VPWR picorv32_core.mem_rdata_q\[1\]
+ sky130_fd_sc_hd__dfxtp_1
XFILLER_16_549 VGND VGND VPWR VPWR sky130_fd_sc_hd__decap_3
XFILLER_43_357 VPWR VGND VPWR VGND sky130_ef_sc_hd__decap_12
XFILLER_24_593 VGND VGND VPWR VPWR sky130_fd_sc_hd__decap_3
XFILLER_129_429 VGND VGND VPWR VPWR sky130_fd_sc_hd__decap_3
X_11512_ clknet_leaf_57_clk _01348_ VGND VGND VPWR VPWR net162 sky130_fd_sc_hd__dfxtp_1
X_11443_ clknet_leaf_64_clk _01279_ VGND VGND VPWR VPWR picorv32_core.cpuregs\[1\]\[26\]
+ sky130_fd_sc_hd__dfxtp_1
XFILLER_50_85 VGND VGND VPWR VPWR sky130_fd_sc_hd__decap_3
XFILLER_7_258 VGND VGND VPWR VPWR sky130_fd_sc_hd__fill_1
X_11374_ clknet_leaf_45_clk _01215_ VGND VGND VPWR VPWR picorv32_core.cpuregs\[18\]\[26\]
+ sky130_fd_sc_hd__dfxtp_1
XTAP_TAPCELL_ROW_59_1165 VGND VPWR sky130_fd_sc_hd__tapvpwrvgnd_1
XTAP_TAPCELL_ROW_59_1154 VGND VPWR sky130_fd_sc_hd__tapvpwrvgnd_1
X_10325_ clknet_leaf_88_clk _00244_ VGND VGND VPWR VPWR picorv32_core.reg_next_pc\[15\]
+ sky130_fd_sc_hd__dfxtp_1
XFILLER_105_370 VGND VGND VPWR VPWR sky130_fd_sc_hd__fill_1
XFILLER_79_722 VGND VGND VPWR VPWR sky130_fd_sc_hd__decap_6
XTAP_TAPCELL_ROW_72_1343 VGND VPWR sky130_fd_sc_hd__tapvpwrvgnd_1
X_10256_ clknet_leaf_101_clk _00175_ VGND VGND VPWR VPWR picorv32_core.count_instr\[40\]
+ sky130_fd_sc_hd__dfxtp_1
XTAP_TAPCELL_ROW_72_1354 VGND VPWR sky130_fd_sc_hd__tapvpwrvgnd_1
XFILLER_120_362 VGND VGND VPWR VPWR sky130_fd_sc_hd__fill_2
X_10187_ clknet_leaf_117_clk _00106_ VGND VGND VPWR VPWR picorv32_core.cpuregs\[9\]\[3\]
+ sky130_fd_sc_hd__dfxtp_1
Xclkbuf_leaf_58_clk clknet_4_12_0_clk VGND VGND VPWR VPWR clknet_leaf_58_clk sky130_fd_sc_hd__clkbuf_8
Xclkbuf_4_11_0_clk clknet_0_clk VGND VGND VPWR VPWR clknet_4_11_0_clk sky130_fd_sc_hd__clkbuf_8
XTAP_TAPCELL_ROW_17_555 VGND VPWR sky130_fd_sc_hd__tapvpwrvgnd_1
XFILLER_34_368 VGND VGND VPWR VPWR sky130_fd_sc_hd__fill_1
XFILLER_91_70 VGND VGND VPWR VPWR sky130_fd_sc_hd__fill_1
X_05300_ _01806_ _01807_ VGND VGND VPWR VPWR _01809_ sky130_fd_sc_hd__nor2_1
X_06280_ _02696_ _02697_ net563 VGND VGND VPWR VPWR _02698_ sky130_fd_sc_hd__mux2_2
X_05231_ picorv32_core.reg_pc\[1\] picorv32_core.decoded_imm\[1\] _01743_ _01744_
+ VGND VGND VPWR VPWR _01745_ sky130_fd_sc_hd__a22o_1
XFILLER_128_451 VGND VGND VPWR VPWR sky130_fd_sc_hd__decap_4
Xhold715 picorv32_core.cpuregs\[4\]\[25\] VGND VGND VPWR VPWR net1824 sky130_fd_sc_hd__dlygate4sd3_1
Xhold704 picorv32_core.cpuregs\[2\]\[13\] VGND VGND VPWR VPWR net1813 sky130_fd_sc_hd__dlygate4sd3_1
Xhold726 picorv32_core.cpuregs\[18\]\[1\] VGND VGND VPWR VPWR net1835 sky130_fd_sc_hd__dlygate4sd3_1
X_05162_ picorv32_core.reg_sh\[3\] picorv32_core.reg_sh\[2\] VGND VGND VPWR VPWR _01687_
+ sky130_fd_sc_hd__or2_1
Xhold737 picorv32_core.cpuregs\[20\]\[11\] VGND VGND VPWR VPWR net1846 sky130_fd_sc_hd__dlygate4sd3_1
X_09970_ net1444 net212 net319 VGND VGND VPWR VPWR _01448_ sky130_fd_sc_hd__mux2_1
Xhold748 picorv32_core.cpuregs\[28\]\[6\] VGND VGND VPWR VPWR net1857 sky130_fd_sc_hd__dlygate4sd3_1
X_05093_ net36 net3 VGND VGND VPWR VPWR _01625_ sky130_fd_sc_hd__nor2_1
Xhold759 picorv32_core.cpuregs\[25\]\[8\] VGND VGND VPWR VPWR net1868 sky130_fd_sc_hd__dlygate4sd3_1
XFILLER_131_638 VGND VGND VPWR VPWR sky130_fd_sc_hd__decap_6
X_08921_ net500 net1759 net357 VGND VGND VPWR VPWR _01094_ sky130_fd_sc_hd__mux2_1
X_08852_ net2155 net207 net368 VGND VGND VPWR VPWR _01028_ sky130_fd_sc_hd__mux2_1
X_07803_ picorv32_core.cpuregs\[0\]\[16\] picorv32_core.cpuregs\[1\]\[16\] picorv32_core.cpuregs\[2\]\[16\]
+ picorv32_core.cpuregs\[3\]\[16\] net748 net715 VGND VGND VPWR VPWR _03892_ sky130_fd_sc_hd__mux4_1
X_08783_ net213 net2072 net376 VGND VGND VPWR VPWR _00930_ sky130_fd_sc_hd__mux2_1
Xclkbuf_leaf_49_clk clknet_4_7_0_clk VGND VGND VPWR VPWR clknet_leaf_49_clk sky130_fd_sc_hd__clkbuf_8
XFILLER_84_224 VGND VGND VPWR VPWR sky130_fd_sc_hd__fill_1
X_05995_ net183 _02459_ VGND VGND VPWR VPWR _02460_ sky130_fd_sc_hd__xnor2_1
XFILLER_57_449 VGND VGND VPWR VPWR sky130_fd_sc_hd__decap_6
XFILLER_72_419 VGND VGND VPWR VPWR sky130_fd_sc_hd__fill_1
X_07734_ net629 _03826_ VGND VGND VPWR VPWR _03827_ sky130_fd_sc_hd__or2_1
XFILLER_65_471 VGND VGND VPWR VPWR sky130_fd_sc_hd__fill_2
XFILLER_25_302 VGND VGND VPWR VPWR sky130_fd_sc_hd__decap_3
XTAP_TAPCELL_ROW_36_820 VGND VPWR sky130_fd_sc_hd__tapvpwrvgnd_1
X_07665_ _03753_ _03760_ _03761_ net617 net687 VGND VGND VPWR VPWR _03762_ sky130_fd_sc_hd__a221o_1
X_06616_ picorv32_core.count_instr\[54\] _02887_ _02890_ VGND VGND VPWR VPWR _02892_
+ sky130_fd_sc_hd__and3_1
XFILLER_80_452 VGND VGND VPWR VPWR sky130_fd_sc_hd__fill_2
X_09404_ net610 _04590_ _04591_ _04592_ net486 VGND VGND VPWR VPWR _04593_ sky130_fd_sc_hd__a2111o_1
XTAP_TAPCELL_ROW_36_831 VGND VPWR sky130_fd_sc_hd__tapvpwrvgnd_1
X_07596_ net965 net594 _03695_ _03696_ VGND VGND VPWR VPWR _00364_ sky130_fd_sc_hd__a22o_1
X_06547_ _02848_ net997 _02847_ VGND VGND VPWR VPWR _00163_ sky130_fd_sc_hd__and3b_1
XFILLER_33_390 VGND VGND VPWR VPWR sky130_fd_sc_hd__fill_2
X_09335_ net810 net541 VGND VGND VPWR VPWR _04527_ sky130_fd_sc_hd__or2_1
X_09266_ _04458_ _04459_ _04460_ net853 net837 VGND VGND VPWR VPWR _04461_ sky130_fd_sc_hd__o221a_1
X_06478_ _02804_ net982 _02803_ VGND VGND VPWR VPWR _00138_ sky130_fd_sc_hd__and3b_1
Xpicorv32_axi_1103 VGND VGND VPWR VPWR picorv32_axi_1103/HI trace_data[30] sky130_fd_sc_hd__conb_1
X_05429_ _01880_ _01890_ _01891_ VGND VGND VPWR VPWR _01929_ sky130_fd_sc_hd__o21ai_1
X_08217_ picorv32_core.instr_xor net475 _04186_ _04208_ VGND VGND VPWR VPWR _00463_
+ sky130_fd_sc_hd__a22o_1
XFILLER_5_729 VPWR VGND VPWR VGND sky130_ef_sc_hd__decap_12
X_09197_ net823 net818 net541 VGND VGND VPWR VPWR _04395_ sky130_fd_sc_hd__mux2_1
X_08148_ _00746_ _00745_ _04174_ VGND VGND VPWR VPWR _04176_ sky130_fd_sc_hd__and3b_1
X_08079_ picorv32_core.cpuregs\[12\]\[31\] picorv32_core.cpuregs\[13\]\[31\] picorv32_core.cpuregs\[14\]\[31\]
+ picorv32_core.cpuregs\[15\]\[31\] net760 net727 VGND VGND VPWR VPWR _04153_ sky130_fd_sc_hd__mux4_1
XFILLER_20_77 VGND VGND VPWR VPWR sky130_fd_sc_hd__decap_6
XFILLER_136_77 VGND VGND VPWR VPWR sky130_fd_sc_hd__decap_6
X_10110_ net1132 VGND VGND VPWR VPWR _00960_ sky130_fd_sc_hd__clkbuf_1
XTAP_TAPCELL_ROW_112_1933 VGND VPWR sky130_fd_sc_hd__tapvpwrvgnd_1
XTAP_TAPCELL_ROW_112_1922 VGND VPWR sky130_fd_sc_hd__tapvpwrvgnd_1
XFILLER_96_15 VPWR VGND VPWR VGND sky130_ef_sc_hd__decap_12
X_11090_ clknet_leaf_130_clk _00941_ VGND VGND VPWR VPWR picorv32_core.cpuregs\[0\]\[8\]
+ sky130_fd_sc_hd__dfxtp_1
XFILLER_88_552 VPWR VGND VPWR VGND sky130_ef_sc_hd__decap_12
XFILLER_0_434 VGND VGND VPWR VPWR sky130_fd_sc_hd__decap_6
X_10041_ net1427 net497 net304 VGND VGND VPWR VPWR _01516_ sky130_fd_sc_hd__mux2_1
XFILLER_76_725 VGND VGND VPWR VPWR sky130_fd_sc_hd__decap_4
Xhold20 picorv32_core.cpuregs\[0\]\[13\] VGND VGND VPWR VPWR net1129 sky130_fd_sc_hd__dlygate4sd3_1
XTAP_TAPCELL_ROW_54_1095 VGND VPWR sky130_fd_sc_hd__tapvpwrvgnd_1
XTAP_TAPCELL_ROW_54_1084 VGND VPWR sky130_fd_sc_hd__tapvpwrvgnd_1
Xhold31 picorv32_core.cpuregs\[0\]\[7\] VGND VGND VPWR VPWR net1140 sky130_fd_sc_hd__dlygate4sd3_1
XFILLER_75_246 VGND VGND VPWR VPWR sky130_fd_sc_hd__fill_1
Xhold53 net107 VGND VGND VPWR VPWR net1162 sky130_fd_sc_hd__dlygate4sd3_1
Xhold64 picorv32_core.mem_rdata_q\[11\] VGND VGND VPWR VPWR net1173 sky130_fd_sc_hd__dlygate4sd3_1
Xhold42 picorv32_core.mem_wordsize\[0\] VGND VGND VPWR VPWR net1151 sky130_fd_sc_hd__dlygate4sd3_1
Xhold97 picorv32_core.count_cycle\[18\] VGND VGND VPWR VPWR net1206 sky130_fd_sc_hd__dlygate4sd3_1
Xhold75 net129 VGND VGND VPWR VPWR net1184 sky130_fd_sc_hd__dlygate4sd3_1
Xhold86 picorv32_core.reg_next_pc\[2\] VGND VGND VPWR VPWR net1195 sky130_fd_sc_hd__dlygate4sd3_1
X_10943_ clknet_leaf_49_clk _00794_ VGND VGND VPWR VPWR picorv32_core.cpuregs\[19\]\[21\]
+ sky130_fd_sc_hd__dfxtp_1
XFILLER_91_739 VGND VGND VPWR VPWR sky130_fd_sc_hd__fill_1
XFILLER_43_132 VGND VGND VPWR VPWR sky130_fd_sc_hd__fill_2
X_10874_ clknet_leaf_51_clk _00725_ VGND VGND VPWR VPWR picorv32_core.cpuregs\[16\]\[18\]
+ sky130_fd_sc_hd__dfxtp_1
XTAP_TAPCELL_ROW_14_503 VGND VPWR sky130_fd_sc_hd__tapvpwrvgnd_1
XFILLER_16_379 VGND VGND VPWR VPWR sky130_fd_sc_hd__fill_1
XTAP_TAPCELL_ROW_14_514 VGND VPWR sky130_fd_sc_hd__tapvpwrvgnd_1
XFILLER_61_95 VGND VGND VPWR VPWR sky130_fd_sc_hd__fill_1
XFILLER_61_73 VGND VGND VPWR VPWR sky130_fd_sc_hd__fill_1
XFILLER_138_793 VPWR VGND VPWR VGND sky130_ef_sc_hd__decap_12
XANTENNA_6 _02667_ VGND VGND VPWR VPWR sky130_fd_sc_hd__diode_2
X_11426_ clknet_leaf_144_clk _01262_ VGND VGND VPWR VPWR picorv32_core.cpuregs\[1\]\[9\]
+ sky130_fd_sc_hd__dfxtp_1
X_11357_ clknet_leaf_144_clk _01198_ VGND VGND VPWR VPWR picorv32_core.cpuregs\[18\]\[9\]
+ sky130_fd_sc_hd__dfxtp_1
X_10308_ clknet_leaf_76_clk _00227_ VGND VGND VPWR VPWR picorv32_core.reg_pc\[29\]
+ sky130_fd_sc_hd__dfxtp_1
X_11288_ clknet_leaf_4_clk _01136_ VGND VGND VPWR VPWR picorv32_core.cpuregs\[3\]\[11\]
+ sky130_fd_sc_hd__dfxtp_1
X_10239_ clknet_leaf_79_clk _00158_ VGND VGND VPWR VPWR picorv32_core.count_instr\[23\]
+ sky130_fd_sc_hd__dfxtp_1
XFILLER_67_725 VGND VGND VPWR VPWR sky130_fd_sc_hd__decap_3
XFILLER_94_544 VGND VGND VPWR VPWR sky130_fd_sc_hd__fill_2
XFILLER_39_427 VGND VGND VPWR VPWR sky130_fd_sc_hd__fill_1
X_05780_ net819 net968 net606 VGND VGND VPWR VPWR _02263_ sky130_fd_sc_hd__o21a_1
XFILLER_47_482 VGND VGND VPWR VPWR sky130_fd_sc_hd__fill_1
XTAP_TAPCELL_ROW_85_1534 VGND VPWR sky130_fd_sc_hd__tapvpwrvgnd_1
XFILLER_34_121 VGND VGND VPWR VPWR sky130_fd_sc_hd__fill_1
X_07450_ net816 _03587_ net532 VGND VGND VPWR VPWR _03588_ sky130_fd_sc_hd__mux2_1
X_07381_ _03416_ _03419_ _03520_ _03418_ VGND VGND VPWR VPWR _03521_ sky130_fd_sc_hd__a211o_1
XFILLER_50_636 VGND VGND VPWR VPWR sky130_fd_sc_hd__fill_2
X_06401_ picorv32_core.latched_rd\[1\] _02665_ picorv32_core.latched_rd\[0\] VGND
+ VGND VPWR VPWR _02795_ sky130_fd_sc_hd__or3b_2
X_06332_ net2123 net258 net435 VGND VGND VPWR VPWR _00057_ sky130_fd_sc_hd__mux2_1
X_09120_ net1460 net501 net329 VGND VGND VPWR VPWR _01286_ sky130_fd_sc_hd__mux2_1
X_09051_ net208 net1893 net343 VGND VGND VPWR VPWR _01220_ sky130_fd_sc_hd__mux2_1
X_08002_ net697 _04079_ VGND VGND VPWR VPWR _04080_ sky130_fd_sc_hd__or2_1
XPHY_EDGE_ROW_6_Right_6 VGND VGND VPWR VPWR sky130_fd_sc_hd__decap_3
X_06263_ picorv32_core.reg_pc\[5\] _02679_ VGND VGND VPWR VPWR _02684_ sky130_fd_sc_hd__nor2_1
XFILLER_116_421 VGND VGND VPWR VPWR sky130_fd_sc_hd__decap_3
X_06194_ picorv32_core.cpuregs\[4\]\[3\] picorv32_core.cpuregs\[5\]\[3\] picorv32_core.cpuregs\[6\]\[3\]
+ picorv32_core.cpuregs\[7\]\[3\] net743 net710 VGND VGND VPWR VPWR _02625_ sky130_fd_sc_hd__mux4_1
Xhold501 picorv32_core.cpuregs\[17\]\[6\] VGND VGND VPWR VPWR net1610 sky130_fd_sc_hd__dlygate4sd3_1
X_05214_ net914 net823 picorv32_core.decoded_imm\[0\] net920 _01729_ VGND VGND VPWR
+ VPWR _01547_ sky130_fd_sc_hd__a221o_1
Xhold512 picorv32_core.cpuregs\[24\]\[27\] VGND VGND VPWR VPWR net1621 sky130_fd_sc_hd__dlygate4sd3_1
Xhold545 picorv32_core.cpuregs\[13\]\[22\] VGND VGND VPWR VPWR net1654 sky130_fd_sc_hd__dlygate4sd3_1
XTAP_TAPCELL_ROW_96_1696 VGND VPWR sky130_fd_sc_hd__tapvpwrvgnd_1
Xhold534 picorv32_core.cpuregs\[12\]\[3\] VGND VGND VPWR VPWR net1643 sky130_fd_sc_hd__dlygate4sd3_1
Xhold523 picorv32_core.cpuregs\[2\]\[4\] VGND VGND VPWR VPWR net1632 sky130_fd_sc_hd__dlygate4sd3_1
X_05145_ net1151 _01645_ _01673_ VGND VGND VPWR VPWR _00017_ sky130_fd_sc_hd__a21o_1
Xhold567 picorv32_core.cpuregs\[13\]\[28\] VGND VGND VPWR VPWR net1676 sky130_fd_sc_hd__dlygate4sd3_1
Xhold556 picorv32_core.cpuregs\[11\]\[25\] VGND VGND VPWR VPWR net1665 sky130_fd_sc_hd__dlygate4sd3_1
Xhold578 picorv32_core.cpuregs\[17\]\[2\] VGND VGND VPWR VPWR net1687 sky130_fd_sc_hd__dlygate4sd3_1
XFILLER_131_446 VGND VGND VPWR VPWR sky130_fd_sc_hd__fill_2
Xhold589 picorv32_core.cpuregs\[8\]\[24\] VGND VGND VPWR VPWR net1698 sky130_fd_sc_hd__dlygate4sd3_1
XFILLER_103_137 VGND VGND VPWR VPWR sky130_fd_sc_hd__decap_4
X_05076_ net186 VGND VGND VPWR VPWR _01611_ sky130_fd_sc_hd__inv_2
X_09953_ net1849 net276 net317 VGND VGND VPWR VPWR _01431_ sky130_fd_sc_hd__mux2_1
X_09884_ net1598 net242 net326 VGND VGND VPWR VPWR _01372_ sky130_fd_sc_hd__mux2_1
X_08904_ net259 net1593 net360 VGND VGND VPWR VPWR _01078_ sky130_fd_sc_hd__mux2_1
Xhold1212 picorv32_core.count_instr\[19\] VGND VGND VPWR VPWR net2321 sky130_fd_sc_hd__dlygate4sd3_1
X_08835_ net1441 net272 net367 VGND VGND VPWR VPWR _01011_ sky130_fd_sc_hd__mux2_1
Xhold1223 picorv32_core.decoded_imm_j\[13\] VGND VGND VPWR VPWR net2332 sky130_fd_sc_hd__dlygate4sd3_1
Xhold1234 picorv32_core.decoded_imm\[12\] VGND VGND VPWR VPWR net2343 sky130_fd_sc_hd__dlygate4sd3_1
Xhold1201 picorv32_core.mem_rdata_q\[6\] VGND VGND VPWR VPWR net2310 sky130_fd_sc_hd__dlygate4sd3_1
XTAP_TAPCELL_ROW_127_2151 VGND VPWR sky130_fd_sc_hd__tapvpwrvgnd_1
XTAP_TAPCELL_ROW_127_2140 VGND VPWR sky130_fd_sc_hd__tapvpwrvgnd_1
Xhold1256 picorv32_core.count_cycle\[58\] VGND VGND VPWR VPWR net2365 sky130_fd_sc_hd__dlygate4sd3_1
Xhold1245 picorv32_core.decoded_imm\[22\] VGND VGND VPWR VPWR net2354 sky130_fd_sc_hd__dlygate4sd3_1
X_08766_ net288 net2154 net374 VGND VGND VPWR VPWR _00913_ sky130_fd_sc_hd__mux2_1
XFILLER_85_588 VGND VGND VPWR VPWR sky130_fd_sc_hd__fill_2
X_05978_ _02150_ net573 VGND VGND VPWR VPWR _02445_ sky130_fd_sc_hd__nor2_1
X_07717_ picorv32_core.cpuregs\[12\]\[11\] picorv32_core.cpuregs\[13\]\[11\] picorv32_core.cpuregs\[14\]\[11\]
+ picorv32_core.cpuregs\[15\]\[11\] net738 net705 VGND VGND VPWR VPWR _03811_ sky130_fd_sc_hd__mux4_1
XFILLER_38_460 VPWR VGND VPWR VGND sky130_ef_sc_hd__decap_12
XTAP_TAPCELL_ROW_140_2340 VGND VPWR sky130_fd_sc_hd__tapvpwrvgnd_1
X_08697_ net1704 net300 net382 VGND VGND VPWR VPWR _00846_ sky130_fd_sc_hd__mux2_1
XFILLER_26_655 VGND VGND VPWR VPWR sky130_fd_sc_hd__fill_1
XFILLER_81_783 VGND VGND VPWR VPWR sky130_fd_sc_hd__fill_1
XFILLER_53_463 VGND VGND VPWR VPWR sky130_fd_sc_hd__fill_1
XTAP_TAPCELL_ROW_0_286 VGND VPWR sky130_fd_sc_hd__tapvpwrvgnd_1
XTAP_TAPCELL_ROW_0_297 VGND VPWR sky130_fd_sc_hd__tapvpwrvgnd_1
XFILLER_25_165 VGND VGND VPWR VPWR sky130_fd_sc_hd__decap_3
X_07648_ _03734_ _03735_ net628 VGND VGND VPWR VPWR _03746_ sky130_fd_sc_hd__mux2_1
X_07579_ _03681_ _03682_ net633 VGND VGND VPWR VPWR _03683_ sky130_fd_sc_hd__mux2_1
XFILLER_41_647 VGND VGND VPWR VPWR sky130_fd_sc_hd__decap_3
X_09318_ picorv32_core.cpuregs\[24\]\[6\] picorv32_core.cpuregs\[25\]\[6\] picorv32_core.cpuregs\[26\]\[6\]
+ picorv32_core.cpuregs\[27\]\[6\] net874 net841 VGND VGND VPWR VPWR _04511_ sky130_fd_sc_hd__mux4_1
X_10590_ clknet_leaf_97_clk _00444_ VGND VGND VPWR VPWR picorv32_core.instr_addi sky130_fd_sc_hd__dfxtp_1
X_09249_ _04438_ _04440_ _04443_ _04444_ net649 VGND VGND VPWR VPWR _04445_ sky130_fd_sc_hd__o221a_1
XFILLER_126_218 VGND VGND VPWR VPWR sky130_fd_sc_hd__decap_4
XFILLER_119_281 VGND VGND VPWR VPWR sky130_fd_sc_hd__fill_2
XFILLER_110_3 VPWR VGND VPWR VGND sky130_ef_sc_hd__decap_12
XFILLER_135_741 VPWR VGND VPWR VGND sky130_ef_sc_hd__decap_12
XTAP_TAPCELL_ROW_56_1113 VGND VPWR sky130_fd_sc_hd__tapvpwrvgnd_1
X_11211_ clknet_leaf_110_clk _01062_ VGND VGND VPWR VPWR picorv32_core.cpuregs\[5\]\[1\]
+ sky130_fd_sc_hd__dfxtp_1
XFILLER_135_785 VPWR VGND VPWR VGND sky130_ef_sc_hd__decap_12
X_11142_ clknet_leaf_38_clk _00993_ VGND VGND VPWR VPWR picorv32_core.cpuregs\[8\]\[28\]
+ sky130_fd_sc_hd__dfxtp_1
XFILLER_122_402 VGND VGND VPWR VPWR sky130_fd_sc_hd__decap_3
XFILLER_107_476 VGND VGND VPWR VPWR sky130_fd_sc_hd__decap_8
Xoutput43 net43 VGND VGND VPWR VPWR mem_axi_araddr[14] sky130_fd_sc_hd__buf_2
XTAP_TAPCELL_ROW_56_1124 VGND VPWR sky130_fd_sc_hd__tapvpwrvgnd_1
Xoutput54 net54 VGND VGND VPWR VPWR mem_axi_araddr[25] sky130_fd_sc_hd__buf_2
Xoutput76 net76 VGND VGND VPWR VPWR mem_axi_awaddr[15] sky130_fd_sc_hd__buf_2
XFILLER_1_721 VGND VGND VPWR VPWR sky130_fd_sc_hd__decap_6
Xoutput65 net65 VGND VGND VPWR VPWR mem_axi_araddr[6] sky130_fd_sc_hd__buf_2
X_11073_ clknet_leaf_41_clk _00924_ VGND VGND VPWR VPWR picorv32_core.cpuregs\[10\]\[23\]
+ sky130_fd_sc_hd__dfxtp_1
Xoutput87 net87 VGND VGND VPWR VPWR mem_axi_awaddr[26] sky130_fd_sc_hd__buf_2
XFILLER_103_671 VGND VGND VPWR VPWR sky130_fd_sc_hd__fill_1
XFILLER_0_253 VPWR VGND VPWR VGND sky130_ef_sc_hd__decap_12
Xoutput98 net98 VGND VGND VPWR VPWR mem_axi_awaddr[7] sky130_fd_sc_hd__buf_2
XFILLER_1_765 VPWR VGND VPWR VGND sky130_ef_sc_hd__decap_12
XFILLER_103_682 VGND VGND VPWR VPWR sky130_fd_sc_hd__decap_6
XFILLER_88_382 VPWR VGND VPWR VGND sky130_ef_sc_hd__decap_12
X_10024_ net1239 net255 net310 VGND VGND VPWR VPWR _01500_ sky130_fd_sc_hd__mux2_1
XFILLER_76_533 VPWR VGND VPWR VGND sky130_ef_sc_hd__decap_12
XFILLER_49_747 VGND VGND VPWR VPWR sky130_fd_sc_hd__fill_1
XFILLER_91_503 VGND VGND VPWR VPWR sky130_fd_sc_hd__fill_1
XFILLER_76_577 VGND VGND VPWR VPWR sky130_fd_sc_hd__fill_2
XFILLER_91_514 VGND VGND VPWR VPWR sky130_fd_sc_hd__decap_8
XTAP_TAPCELL_ROW_67_1275 VGND VPWR sky130_fd_sc_hd__tapvpwrvgnd_1
X_10926_ clknet_leaf_113_clk _00777_ VGND VGND VPWR VPWR picorv32_core.cpuregs\[19\]\[4\]
+ sky130_fd_sc_hd__dfxtp_1
X_10857_ clknet_leaf_114_clk _00708_ VGND VGND VPWR VPWR picorv32_core.cpuregs\[16\]\[1\]
+ sky130_fd_sc_hd__dfxtp_1
XTAP_TAPCELL_ROW_27_694 VGND VPWR sky130_fd_sc_hd__tapvpwrvgnd_1
XFILLER_31_113 VGND VGND VPWR VPWR sky130_fd_sc_hd__fill_2
XFILLER_32_625 VGND VGND VPWR VPWR sky130_fd_sc_hd__fill_2
XFILLER_72_94 VGND VGND VPWR VPWR sky130_fd_sc_hd__decap_4
X_10788_ clknet_leaf_69_clk _00639_ VGND VGND VPWR VPWR picorv32_core.cpuregs\[14\]\[29\]
+ sky130_fd_sc_hd__dfxtp_1
XTAP_TAPCELL_ROW_80_1464 VGND VPWR sky130_fd_sc_hd__tapvpwrvgnd_1
XPHY_EDGE_ROW_59_Right_59 VGND VGND VPWR VPWR sky130_fd_sc_hd__decap_3
XFILLER_9_821 VPWR VGND VPWR VGND sky130_ef_sc_hd__decap_12
X_11409_ clknet_leaf_33_clk _01245_ VGND VGND VPWR VPWR picorv32_core.cpuregs\[31\]\[24\]
+ sky130_fd_sc_hd__dfxtp_1
XFILLER_141_755 VGND VGND VPWR VPWR sky130_fd_sc_hd__fill_1
X_06950_ _03163_ _03164_ VGND VGND VPWR VPWR _03165_ sky130_fd_sc_hd__nor2_1
XFILLER_79_393 VGND VGND VPWR VPWR sky130_fd_sc_hd__decap_8
X_06881_ _02927_ _03087_ VGND VGND VPWR VPWR _03102_ sky130_fd_sc_hd__and2_1
XPHY_EDGE_ROW_68_Right_68 VGND VGND VPWR VPWR sky130_fd_sc_hd__decap_3
X_05901_ net509 _02372_ _02373_ _02364_ VGND VGND VPWR VPWR picorv32_core.alu_out\[11\]
+ sky130_fd_sc_hd__a31o_1
XFILLER_94_352 VGND VGND VPWR VPWR sky130_fd_sc_hd__fill_1
X_08620_ _04331_ _04333_ VGND VGND VPWR VPWR _00740_ sky130_fd_sc_hd__and2_1
X_05832_ picorv32_core.mem_la_wdata\[6\] _02309_ VGND VGND VPWR VPWR _02310_ sky130_fd_sc_hd__xnor2_1
X_05763_ _02246_ _02245_ _02243_ VGND VGND VPWR VPWR _02247_ sky130_fd_sc_hd__or3b_4
X_08551_ net495 net1687 net398 VGND VGND VPWR VPWR _00676_ sky130_fd_sc_hd__mux2_1
XPHY_EDGE_ROW_6_Left_148 VGND VGND VPWR VPWR sky130_fd_sc_hd__decap_3
X_07502_ net2307 _03622_ net462 VGND VGND VPWR VPWR _00344_ sky130_fd_sc_hd__mux2_1
X_05694_ net779 net186 VGND VGND VPWR VPWR _02178_ sky130_fd_sc_hd__nand2_1
X_08482_ net1579 net496 net406 VGND VGND VPWR VPWR _00612_ sky130_fd_sc_hd__mux2_1
XFILLER_35_463 VPWR VGND VPWR VGND sky130_ef_sc_hd__decap_12
XTAP_TAPCELL_ROW_46_970 VGND VPWR sky130_fd_sc_hd__tapvpwrvgnd_1
XTAP_TAPCELL_ROW_122_2081 VGND VPWR sky130_fd_sc_hd__tapvpwrvgnd_1
XTAP_TAPCELL_ROW_122_2070 VGND VPWR sky130_fd_sc_hd__tapvpwrvgnd_1
X_07433_ picorv32_core.decoded_imm_j\[16\] picorv32_core.decoded_imm_j\[17\] picorv32_core.decoded_imm_j\[18\]
+ picorv32_core.decoded_imm_j\[19\] VGND VGND VPWR VPWR _03573_ sky130_fd_sc_hd__or4_1
XPHY_EDGE_ROW_77_Right_77 VGND VGND VPWR VPWR sky130_fd_sc_hd__decap_3
XFILLER_11_809 VPWR VGND VPWR VGND sky130_ef_sc_hd__decap_12
X_09103_ net259 net1451 net334 VGND VGND VPWR VPWR _01270_ sky130_fd_sc_hd__mux2_1
X_07364_ net783 picorv32_core.decoded_imm\[19\] VGND VGND VPWR VPWR _03504_ sky130_fd_sc_hd__and2_1
XTAP_TAPCELL_ROW_98_1725 VGND VPWR sky130_fd_sc_hd__tapvpwrvgnd_1
X_06315_ picorv32_core.reg_pc\[15\] picorv32_core.reg_pc\[14\] _02718_ VGND VGND VPWR
+ VPWR _02726_ sky130_fd_sc_hd__and3_1
X_07295_ net799 picorv32_core.decoded_imm\[11\] VGND VGND VPWR VPWR _03435_ sky130_fd_sc_hd__nor2_1
X_09034_ net274 net1844 net340 VGND VGND VPWR VPWR _01203_ sky130_fd_sc_hd__mux2_1
X_06246_ picorv32_core.reg_out\[1\] picorv32_core.alu_out_q\[1\] net950 VGND VGND
+ VPWR VPWR _02671_ sky130_fd_sc_hd__mux2_1
XFILLER_117_741 VPWR VGND VPWR VGND sky130_ef_sc_hd__decap_12
Xhold320 picorv32_core.cpuregs\[8\]\[4\] VGND VGND VPWR VPWR net1429 sky130_fd_sc_hd__dlygate4sd3_1
Xhold331 picorv32_core.cpuregs\[2\]\[29\] VGND VGND VPWR VPWR net1440 sky130_fd_sc_hd__dlygate4sd3_1
XFILLER_117_785 VPWR VGND VPWR VGND sky130_ef_sc_hd__decap_12
Xhold342 picorv32_core.cpuregs\[1\]\[17\] VGND VGND VPWR VPWR net1451 sky130_fd_sc_hd__dlygate4sd3_1
X_06177_ net623 _02608_ net683 VGND VGND VPWR VPWR _02609_ sky130_fd_sc_hd__a21oi_1
Xhold353 picorv32_core.cpuregs\[27\]\[8\] VGND VGND VPWR VPWR net1462 sky130_fd_sc_hd__dlygate4sd3_1
XFILLER_132_744 VPWR VGND VPWR VGND sky130_ef_sc_hd__decap_12
Xhold375 picorv32_core.cpuregs\[21\]\[14\] VGND VGND VPWR VPWR net1484 sky130_fd_sc_hd__dlygate4sd3_1
Xfanout800 net143 VGND VGND VPWR VPWR net800 sky130_fd_sc_hd__clkbuf_4
X_05128_ _01655_ _01656_ _01657_ _01658_ VGND VGND VPWR VPWR _01659_ sky130_fd_sc_hd__or4_1
Xhold364 picorv32_core.cpuregs\[17\]\[8\] VGND VGND VPWR VPWR net1473 sky130_fd_sc_hd__dlygate4sd3_1
Xhold386 picorv32_core.cpuregs\[15\]\[8\] VGND VGND VPWR VPWR net1495 sky130_fd_sc_hd__dlygate4sd3_1
Xfanout833 net834 VGND VGND VPWR VPWR net833 sky130_fd_sc_hd__buf_4
XFILLER_104_457 VGND VGND VPWR VPWR sky130_fd_sc_hd__decap_8
XPHY_EDGE_ROW_86_Right_86 VGND VGND VPWR VPWR sky130_fd_sc_hd__decap_3
X_05059_ picorv32_core.mem_rdata_q\[13\] VGND VGND VPWR VPWR _01594_ sky130_fd_sc_hd__inv_2
Xhold397 picorv32_core.cpuregs\[28\]\[14\] VGND VGND VPWR VPWR net1506 sky130_fd_sc_hd__dlygate4sd3_1
X_09936_ picorv32_core.is_slli_srli_srai _03689_ VGND VGND VPWR VPWR _05037_ sky130_fd_sc_hd__nor2_1
Xfanout822 net152 VGND VGND VPWR VPWR net822 sky130_fd_sc_hd__buf_2
Xfanout811 net168 VGND VGND VPWR VPWR net811 sky130_fd_sc_hd__buf_2
XFILLER_98_691 VGND VGND VPWR VPWR sky130_fd_sc_hd__decap_3
XFILLER_86_831 VGND VGND VPWR VPWR sky130_fd_sc_hd__fill_2
Xfanout866 net872 VGND VGND VPWR VPWR net866 sky130_fd_sc_hd__buf_2
Xfanout855 net857 VGND VGND VPWR VPWR net855 sky130_fd_sc_hd__clkbuf_4
XTAP_TAPCELL_ROW_51_1043 VGND VPWR sky130_fd_sc_hd__tapvpwrvgnd_1
Xfanout844 net850 VGND VGND VPWR VPWR net844 sky130_fd_sc_hd__clkbuf_2
Xhold1042 picorv32_core.cpuregs\[17\]\[26\] VGND VGND VPWR VPWR net2151 sky130_fd_sc_hd__dlygate4sd3_1
Xfanout899 net900 VGND VGND VPWR VPWR net899 sky130_fd_sc_hd__buf_2
XFILLER_58_566 VPWR VGND VPWR VGND sky130_ef_sc_hd__decap_12
Xhold1020 picorv32_core.cpuregs\[8\]\[13\] VGND VGND VPWR VPWR net2129 sky130_fd_sc_hd__dlygate4sd3_1
Xhold1031 picorv32_core.cpuregs\[12\]\[5\] VGND VGND VPWR VPWR net2140 sky130_fd_sc_hd__dlygate4sd3_1
XTAP_TAPCELL_ROW_5_378 VGND VPWR sky130_fd_sc_hd__tapvpwrvgnd_1
X_09867_ net1760 net449 net324 VGND VGND VPWR VPWR _01355_ sky130_fd_sc_hd__mux2_1
Xfanout888 net907 VGND VGND VPWR VPWR net888 sky130_fd_sc_hd__buf_2
Xfanout877 net883 VGND VGND VPWR VPWR net877 sky130_fd_sc_hd__clkbuf_2
XFILLER_46_717 VPWR VGND VPWR VGND sky130_ef_sc_hd__decap_12
Xhold1053 picorv32_core.cpuregs\[15\]\[23\] VGND VGND VPWR VPWR net2162 sky130_fd_sc_hd__dlygate4sd3_1
X_08818_ net206 net2010 net373 VGND VGND VPWR VPWR _00996_ sky130_fd_sc_hd__mux2_1
Xhold1064 picorv32_core.cpuregs\[10\]\[19\] VGND VGND VPWR VPWR net2173 sky130_fd_sc_hd__dlygate4sd3_1
XFILLER_85_385 VGND VGND VPWR VPWR sky130_fd_sc_hd__fill_1
X_09798_ picorv32_core.instr_sra picorv32_core.instr_srai net548 _04947_ VGND VGND
+ VPWR VPWR _04969_ sky130_fd_sc_hd__o31a_1
XFILLER_18_419 VGND VGND VPWR VPWR sky130_fd_sc_hd__fill_1
Xhold1075 picorv32_core.cpuregs\[8\]\[7\] VGND VGND VPWR VPWR net2184 sky130_fd_sc_hd__dlygate4sd3_1
Xhold1086 picorv32_core.cpuregs\[25\]\[27\] VGND VGND VPWR VPWR net2195 sky130_fd_sc_hd__dlygate4sd3_1
X_08749_ net1218 net217 net380 VGND VGND VPWR VPWR _00897_ sky130_fd_sc_hd__mux2_1
Xhold1097 picorv32_core.cpuregs\[4\]\[16\] VGND VGND VPWR VPWR net2206 sky130_fd_sc_hd__dlygate4sd3_1
XFILLER_93_49 VGND VGND VPWR VPWR sky130_fd_sc_hd__decap_6
XFILLER_39_791 VGND VGND VPWR VPWR sky130_fd_sc_hd__fill_1
XTAP_TAPCELL_ROW_107_1854 VGND VPWR sky130_fd_sc_hd__tapvpwrvgnd_1
XFILLER_60_219 VGND VGND VPWR VPWR sky130_fd_sc_hd__fill_1
XPHY_EDGE_ROW_95_Right_95 VGND VGND VPWR VPWR sky130_fd_sc_hd__decap_3
X_10711_ clknet_leaf_27_clk _00562_ VGND VGND VPWR VPWR net117 sky130_fd_sc_hd__dfxtp_1
XFILLER_13_113 VGND VGND VPWR VPWR sky130_fd_sc_hd__decap_3
XFILLER_13_135 VGND VGND VPWR VPWR sky130_fd_sc_hd__fill_1
XTAP_TAPCELL_ROW_24_653 VGND VPWR sky130_fd_sc_hd__tapvpwrvgnd_1
X_11691_ clknet_leaf_129_clk _01522_ VGND VGND VPWR VPWR picorv32_core.cpuregs\[27\]\[8\]
+ sky130_fd_sc_hd__dfxtp_1
X_10642_ clknet_leaf_2_clk _00496_ VGND VGND VPWR VPWR picorv32_core.cpuregs\[20\]\[10\]
+ sky130_fd_sc_hd__dfxtp_1
X_10573_ clknet_leaf_75_clk _00427_ VGND VGND VPWR VPWR picorv32_core.cpuregs\[25\]\[29\]
+ sky130_fd_sc_hd__dfxtp_1
XFILLER_6_813 VPWR VGND VPWR VGND sky130_ef_sc_hd__decap_12
XFILLER_5_334 VGND VGND VPWR VPWR sky130_fd_sc_hd__fill_2
XFILLER_123_777 VGND VGND VPWR VPWR sky130_fd_sc_hd__decap_6
X_11125_ clknet_leaf_11_clk _00976_ VGND VGND VPWR VPWR picorv32_core.cpuregs\[8\]\[11\]
+ sky130_fd_sc_hd__dfxtp_1
XFILLER_110_449 VGND VGND VPWR VPWR sky130_fd_sc_hd__fill_1
XFILLER_89_680 VGND VGND VPWR VPWR sky130_fd_sc_hd__fill_2
X_11056_ clknet_leaf_141_clk _00907_ VGND VGND VPWR VPWR picorv32_core.cpuregs\[10\]\[6\]
+ sky130_fd_sc_hd__dfxtp_1
XFILLER_3_69 VPWR VGND VPWR VGND sky130_ef_sc_hd__decap_12
XFILLER_95_149 VGND VGND VPWR VPWR sky130_fd_sc_hd__decap_4
X_10007_ net1404 net501 net309 VGND VGND VPWR VPWR _01483_ sky130_fd_sc_hd__mux2_1
XFILLER_92_823 VGND VGND VPWR VPWR sky130_fd_sc_hd__fill_1
XTAP_TAPCELL_ROW_69_1304 VGND VPWR sky130_fd_sc_hd__tapvpwrvgnd_1
XFILLER_67_94 VGND VGND VPWR VPWR sky130_fd_sc_hd__fill_2
XFILLER_64_558 VGND VGND VPWR VPWR sky130_fd_sc_hd__fill_2
XFILLER_91_399 VGND VGND VPWR VPWR sky130_fd_sc_hd__fill_1
XFILLER_60_720 VGND VGND VPWR VPWR sky130_fd_sc_hd__fill_2
X_10909_ clknet_leaf_84_clk _00760_ VGND VGND VPWR VPWR picorv32_core.mem_rdata_q\[19\]
+ sky130_fd_sc_hd__dfxtp_1
XFILLER_60_764 VGND VGND VPWR VPWR sky130_fd_sc_hd__decap_4
XFILLER_20_606 VGND VGND VPWR VPWR sky130_fd_sc_hd__fill_1
XFILLER_32_477 VPWR VGND VPWR VGND sky130_ef_sc_hd__decap_12
X_06100_ _02555_ _02556_ VGND VGND VPWR VPWR _02557_ sky130_fd_sc_hd__nor2_1
X_07080_ picorv32_core.count_cycle\[0\] picorv32_core.count_cycle\[1\] picorv32_core.count_cycle\[2\]
+ VGND VGND VPWR VPWR _03282_ sky130_fd_sc_hd__a21o_1
X_06031_ net779 net186 net569 VGND VGND VPWR VPWR _02494_ sky130_fd_sc_hd__and3_1
XFILLER_114_755 VGND VGND VPWR VPWR sky130_fd_sc_hd__fill_1
XTAP_TAPCELL_ROW_93_1655 VGND VPWR sky130_fd_sc_hd__tapvpwrvgnd_1
X_07982_ picorv32_core.cpuregs\[28\]\[26\] picorv32_core.cpuregs\[29\]\[26\] picorv32_core.cpuregs\[30\]\[26\]
+ picorv32_core.cpuregs\[31\]\[26\] net760 net727 VGND VGND VPWR VPWR _04061_ sky130_fd_sc_hd__mux4_1
XFILLER_87_617 VPWR VGND VPWR VGND sky130_ef_sc_hd__decap_12
X_09721_ picorv32_core.cpuregs\[8\]\[24\] picorv32_core.cpuregs\[9\]\[24\] picorv32_core.cpuregs\[10\]\[24\]
+ picorv32_core.cpuregs\[11\]\[24\] net894 net860 VGND VGND VPWR VPWR _04896_ sky130_fd_sc_hd__mux4_1
XFILLER_113_287 VGND VGND VPWR VPWR sky130_fd_sc_hd__fill_1
XFILLER_101_416 VGND VGND VPWR VPWR sky130_fd_sc_hd__decap_6
X_06933_ net677 _03149_ _03148_ net589 VGND VGND VPWR VPWR _03150_ sky130_fd_sc_hd__o211a_1
XFILLER_87_639 VGND VGND VPWR VPWR sky130_fd_sc_hd__fill_2
XFILLER_68_820 VGND VGND VPWR VPWR sky130_fd_sc_hd__fill_2
XFILLER_95_661 VGND VGND VPWR VPWR sky130_fd_sc_hd__decap_8
XFILLER_83_801 VGND VGND VPWR VPWR sky130_fd_sc_hd__fill_2
XTAP_TAPCELL_ROW_124_2110 VGND VPWR sky130_fd_sc_hd__tapvpwrvgnd_1
X_09652_ picorv32_core.cpuregs\[28\]\[21\] picorv32_core.cpuregs\[29\]\[21\] picorv32_core.cpuregs\[30\]\[21\]
+ picorv32_core.cpuregs\[31\]\[21\] net897 net863 VGND VGND VPWR VPWR _04830_ sky130_fd_sc_hd__mux4_1
XFILLER_103_15 VPWR VGND VPWR VGND sky130_ef_sc_hd__decap_12
XFILLER_83_834 VGND VGND VPWR VPWR sky130_fd_sc_hd__decap_3
X_06864_ _03084_ _03085_ VGND VGND VPWR VPWR _03086_ sky130_fd_sc_hd__or2_1
XFILLER_55_503 VGND VGND VPWR VPWR sky130_fd_sc_hd__fill_1
XTAP_TAPCELL_ROW_2_337 VGND VPWR sky130_fd_sc_hd__tapvpwrvgnd_1
X_08603_ net252 net2204 net396 VGND VGND VPWR VPWR _00726_ sky130_fd_sc_hd__mux2_1
X_09583_ net611 _04758_ _04759_ _04763_ VGND VGND VPWR VPWR _04764_ sky130_fd_sc_hd__a31o_1
XFILLER_55_547 VPWR VGND VPWR VGND sky130_ef_sc_hd__decap_12
X_06795_ net980 _03022_ VGND VGND VPWR VPWR _00237_ sky130_fd_sc_hd__and2_1
X_05815_ net965 _02285_ net669 VGND VGND VPWR VPWR _02294_ sky130_fd_sc_hd__o21a_1
X_08534_ net1319 net251 net404 VGND VGND VPWR VPWR _00661_ sky130_fd_sc_hd__mux2_1
X_05746_ net956 _02150_ VGND VGND VPWR VPWR _02230_ sky130_fd_sc_hd__nand2_1
XFILLER_55_569 VGND VGND VPWR VPWR sky130_fd_sc_hd__fill_1
X_05677_ net769 net191 VGND VGND VPWR VPWR _02161_ sky130_fd_sc_hd__nand2_1
X_08465_ picorv32_core.decoded_imm\[5\] net527 _04313_ VGND VGND VPWR VPWR _00605_
+ sky130_fd_sc_hd__o21a_1
X_07416_ net660 _03555_ _03554_ VGND VGND VPWR VPWR _03556_ sky130_fd_sc_hd__a21oi_1
XTAP_TAPCELL_ROW_21_612 VGND VPWR sky130_fd_sc_hd__tapvpwrvgnd_1
X_08396_ net2063 net461 _04274_ _03583_ VGND VGND VPWR VPWR _00575_ sky130_fd_sc_hd__o22a_1
XTAP_TAPCELL_ROW_102_1784 VGND VPWR sky130_fd_sc_hd__tapvpwrvgnd_1
X_07347_ _03432_ _03486_ _03430_ VGND VGND VPWR VPWR _03487_ sky130_fd_sc_hd__o21ai_1
XFILLER_6_109 VPWR VGND VPWR VGND sky130_ef_sc_hd__decap_12
XFILLER_136_357 VGND VGND VPWR VPWR sky130_fd_sc_hd__decap_3
XTAP_TAPCELL_ROW_135_2261 VGND VPWR sky130_fd_sc_hd__tapvpwrvgnd_1
X_09017_ net210 net1781 net347 VGND VGND VPWR VPWR _01187_ sky130_fd_sc_hd__mux2_1
X_07278_ net779 picorv32_core.decoded_imm\[21\] VGND VGND VPWR VPWR _03418_ sky130_fd_sc_hd__nor2_1
XFILLER_12_89 VGND VGND VPWR VPWR sky130_fd_sc_hd__fill_1
X_06229_ net624 _02654_ _02658_ VGND VGND VPWR VPWR _02659_ sky130_fd_sc_hd__a21oi_1
Xhold150 picorv32_core.cpuregs\[7\]\[20\] VGND VGND VPWR VPWR net1259 sky130_fd_sc_hd__dlygate4sd3_1
Xhold161 picorv32_core.cpuregs\[19\]\[3\] VGND VGND VPWR VPWR net1270 sky130_fd_sc_hd__dlygate4sd3_1
XFILLER_5_6 VPWR VGND VPWR VGND sky130_ef_sc_hd__decap_12
XFILLER_132_563 VGND VGND VPWR VPWR sky130_fd_sc_hd__fill_1
Xhold183 picorv32_core.cpuregs\[11\]\[27\] VGND VGND VPWR VPWR net1292 sky130_fd_sc_hd__dlygate4sd3_1
Xhold194 picorv32_core.cpuregs\[14\]\[25\] VGND VGND VPWR VPWR net1303 sky130_fd_sc_hd__dlygate4sd3_1
Xhold172 picorv32_core.cpuregs\[23\]\[19\] VGND VGND VPWR VPWR net1281 sky130_fd_sc_hd__dlygate4sd3_1
Xfanout630 net631 VGND VGND VPWR VPWR net630 sky130_fd_sc_hd__buf_4
Xfanout641 _01619_ VGND VGND VPWR VPWR net641 sky130_fd_sc_hd__clkbuf_8
XFILLER_120_769 VPWR VGND VPWR VGND sky130_ef_sc_hd__decap_12
X_09919_ net251 net1894 net322 VGND VGND VPWR VPWR _01403_ sky130_fd_sc_hd__mux2_1
Xfanout685 net686 VGND VGND VPWR VPWR net685 sky130_fd_sc_hd__buf_4
Xfanout663 net664 VGND VGND VPWR VPWR net663 sky130_fd_sc_hd__clkbuf_4
Xfanout674 net675 VGND VGND VPWR VPWR net674 sky130_fd_sc_hd__buf_2
Xfanout652 net655 VGND VGND VPWR VPWR net652 sky130_fd_sc_hd__buf_4
XFILLER_100_460 VGND VGND VPWR VPWR sky130_fd_sc_hd__fill_2
Xfanout696 net697 VGND VGND VPWR VPWR net696 sky130_fd_sc_hd__clkbuf_4
XTAP_TAPCELL_ROW_29_723 VGND VPWR sky130_fd_sc_hd__tapvpwrvgnd_1
XFILLER_37_53 VGND VGND VPWR VPWR sky130_fd_sc_hd__decap_3
XTAP_TAPCELL_ROW_64_1234 VGND VPWR sky130_fd_sc_hd__tapvpwrvgnd_1
X_11674_ clknet_leaf_49_clk _01505_ VGND VGND VPWR VPWR picorv32_core.cpuregs\[26\]\[23\]
+ sky130_fd_sc_hd__dfxtp_1
X_10625_ clknet_leaf_92_clk _00479_ VGND VGND VPWR VPWR picorv32_core.decoded_imm_j\[9\]
+ sky130_fd_sc_hd__dfxtp_1
XFILLER_139_162 VGND VGND VPWR VPWR sky130_fd_sc_hd__decap_6
XFILLER_128_825 VPWR VGND VPWR VGND sky130_ef_sc_hd__decap_12
X_10556_ clknet_leaf_9_clk _00410_ VGND VGND VPWR VPWR picorv32_core.cpuregs\[25\]\[12\]
+ sky130_fd_sc_hd__dfxtp_1
XFILLER_108_571 VGND VGND VPWR VPWR sky130_fd_sc_hd__fill_1
X_10487_ clknet_leaf_16_clk _00373_ VGND VGND VPWR VPWR net177 sky130_fd_sc_hd__dfxtp_4
XTAP_TAPCELL_ROW_75_1396 VGND VPWR sky130_fd_sc_hd__tapvpwrvgnd_1
X_11108_ clknet_leaf_64_clk _00959_ VGND VGND VPWR VPWR picorv32_core.cpuregs\[0\]\[26\]
+ sky130_fd_sc_hd__dfxtp_1
XPHY_EDGE_ROW_87_Left_229 VGND VGND VPWR VPWR sky130_fd_sc_hd__decap_3
X_11039_ clknet_leaf_50_clk _00890_ VGND VGND VPWR VPWR picorv32_core.cpuregs\[11\]\[21\]
+ sky130_fd_sc_hd__dfxtp_1
XFILLER_49_363 VGND VGND VPWR VPWR sky130_fd_sc_hd__decap_6
XFILLER_37_503 VGND VGND VPWR VPWR sky130_fd_sc_hd__fill_1
X_05600_ picorv32_core.count_cycle\[28\] net600 VGND VGND VPWR VPWR _02088_ sky130_fd_sc_hd__or2_1
XFILLER_37_569 VGND VGND VPWR VPWR sky130_fd_sc_hd__decap_8
X_06580_ picorv32_core.count_instr\[41\] picorv32_core.count_instr\[40\] picorv32_core.count_instr\[39\]
+ _02864_ VGND VGND VPWR VPWR _02869_ sky130_fd_sc_hd__and4_1
XFILLER_52_528 VGND VGND VPWR VPWR sky130_fd_sc_hd__fill_1
XPHY_EDGE_ROW_96_Left_238 VGND VGND VPWR VPWR sky130_fd_sc_hd__decap_3
X_05531_ net945 picorv32_core.count_cycle\[55\] net603 _02023_ VGND VGND VPWR VPWR
+ _02024_ sky130_fd_sc_hd__a211o_1
X_05462_ net13 net583 net574 VGND VGND VPWR VPWR _01960_ sky130_fd_sc_hd__a21o_1
X_08250_ net2318 _00769_ net441 VGND VGND VPWR VPWR _00478_ sky130_fd_sc_hd__mux2_1
XFILLER_33_797 VPWR VGND VPWR VGND sky130_ef_sc_hd__decap_12
X_07201_ picorv32_core.count_cycle\[46\] picorv32_core.count_cycle\[47\] _03354_ VGND
+ VGND VPWR VPWR _03358_ sky130_fd_sc_hd__and3_1
X_08181_ net523 _04195_ VGND VGND VPWR VPWR _04196_ sky130_fd_sc_hd__nor2_1
X_07132_ net2235 _03313_ net994 VGND VGND VPWR VPWR _03315_ sky130_fd_sc_hd__o21ai_1
X_05393_ net926 _01783_ net585 VGND VGND VPWR VPWR _01896_ sky130_fd_sc_hd__a21o_1
XFILLER_118_357 VGND VGND VPWR VPWR sky130_fd_sc_hd__fill_1
X_07063_ net677 _03263_ _03264_ _03268_ VGND VGND VPWR VPWR _03269_ sky130_fd_sc_hd__o31a_1
Xoutput200 net200 VGND VGND VPWR VPWR pcpi_rs2[5] sky130_fd_sc_hd__buf_2
XFILLER_114_530 VGND VGND VPWR VPWR sky130_fd_sc_hd__fill_2
X_06014_ _02443_ _02428_ _02434_ _02475_ VGND VGND VPWR VPWR _02478_ sky130_fd_sc_hd__nand4b_1
XFILLER_58_19 VGND VGND VPWR VPWR sky130_fd_sc_hd__fill_1
XTAP_TAPCELL_ROW_7_407 VGND VPWR sky130_fd_sc_hd__tapvpwrvgnd_1
XTAP_TAPCELL_ROW_130_2191 VGND VPWR sky130_fd_sc_hd__tapvpwrvgnd_1
XFILLER_141_393 VGND VGND VPWR VPWR sky130_fd_sc_hd__decap_3
X_07965_ picorv32_core.cpuregs\[8\]\[25\] picorv32_core.cpuregs\[9\]\[25\] picorv32_core.cpuregs\[10\]\[25\]
+ picorv32_core.cpuregs\[11\]\[25\] net762 net729 VGND VGND VPWR VPWR _04045_ sky130_fd_sc_hd__mux4_1
XFILLER_102_769 VGND VGND VPWR VPWR sky130_fd_sc_hd__fill_2
X_09704_ _04872_ _04873_ _04878_ _04879_ net658 net647 VGND VGND VPWR VPWR _04880_
+ sky130_fd_sc_hd__mux4_1
XFILLER_114_47 VGND VGND VPWR VPWR sky130_fd_sc_hd__decap_4
XFILLER_101_279 VGND VGND VPWR VPWR sky130_fd_sc_hd__fill_1
X_06916_ _03120_ _03124_ _03132_ net664 VGND VGND VPWR VPWR _03134_ sky130_fd_sc_hd__a31o_1
X_07896_ picorv32_core.cpuregs\[24\]\[21\] picorv32_core.cpuregs\[25\]\[21\] picorv32_core.cpuregs\[26\]\[21\]
+ picorv32_core.cpuregs\[27\]\[21\] net755 net722 VGND VGND VPWR VPWR _03980_ sky130_fd_sc_hd__mux4_1
X_09635_ picorv32_core.cpuregs\[0\]\[20\] picorv32_core.cpuregs\[1\]\[20\] picorv32_core.cpuregs\[2\]\[20\]
+ picorv32_core.cpuregs\[3\]\[20\] net895 net861 VGND VGND VPWR VPWR _04814_ sky130_fd_sc_hd__mux4_1
XFILLER_74_29 VPWR VGND VPWR VGND sky130_ef_sc_hd__decap_12
XFILLER_55_333 VGND VGND VPWR VPWR sky130_fd_sc_hd__decap_3
X_06847_ _03048_ _03057_ _03058_ VGND VGND VPWR VPWR _03070_ sky130_fd_sc_hd__and3_1
XFILLER_55_366 VGND VGND VPWR VPWR sky130_fd_sc_hd__decap_3
XFILLER_16_709 VPWR VGND VPWR VGND sky130_ef_sc_hd__decap_12
XTAP_TAPCELL_ROW_104_1813 VGND VPWR sky130_fd_sc_hd__tapvpwrvgnd_1
X_09566_ picorv32_core.cpuregs\[16\]\[17\] picorv32_core.cpuregs\[17\]\[17\] picorv32_core.cpuregs\[18\]\[17\]
+ picorv32_core.cpuregs\[19\]\[17\] net889 net855 VGND VGND VPWR VPWR _04748_ sky130_fd_sc_hd__mux4_1
XFILLER_24_731 VPWR VGND VPWR VGND sky130_ef_sc_hd__decap_12
X_06778_ _02918_ _02919_ _02983_ VGND VGND VPWR VPWR _03007_ sky130_fd_sc_hd__and3_1
X_09497_ picorv32_core.cpuregs\[16\]\[14\] picorv32_core.cpuregs\[17\]\[14\] picorv32_core.cpuregs\[18\]\[14\]
+ picorv32_core.cpuregs\[19\]\[14\] net880 net847 VGND VGND VPWR VPWR _04682_ sky130_fd_sc_hd__mux4_1
X_08517_ net1554 net495 net402 VGND VGND VPWR VPWR _00644_ sky130_fd_sc_hd__mux2_1
X_05729_ net809 _02122_ net963 VGND VGND VPWR VPWR _02213_ sky130_fd_sc_hd__or3b_1
X_08448_ net2359 net531 _04284_ _04304_ VGND VGND VPWR VPWR _00597_ sky130_fd_sc_hd__o22a_1
XFILLER_23_55 VGND VGND VPWR VPWR sky130_fd_sc_hd__fill_1
XTAP_TAPCELL_ROW_34_792 VGND VPWR sky130_fd_sc_hd__tapvpwrvgnd_1
XFILLER_139_55 VGND VGND VPWR VPWR sky130_fd_sc_hd__fill_1
X_08379_ net1177 net454 _04264_ VGND VGND VPWR VPWR _00568_ sky130_fd_sc_hd__o21a_1
XFILLER_23_66 VGND VGND VPWR VPWR sky130_fd_sc_hd__decap_4
X_10410_ clknet_leaf_121_clk _01572_ VGND VGND VPWR VPWR picorv32_core.reg_out\[3\]
+ sky130_fd_sc_hd__dfxtp_1
XFILLER_136_121 VGND VGND VPWR VPWR sky130_fd_sc_hd__fill_2
XFILLER_109_335 VGND VGND VPWR VPWR sky130_fd_sc_hd__fill_1
XFILLER_99_15 VPWR VGND VPWR VGND sky130_ef_sc_hd__decap_12
X_11390_ clknet_leaf_138_clk _01226_ VGND VGND VPWR VPWR picorv32_core.cpuregs\[31\]\[5\]
+ sky130_fd_sc_hd__dfxtp_1
X_10341_ clknet_leaf_75_clk _00260_ VGND VGND VPWR VPWR picorv32_core.reg_next_pc\[31\]
+ sky130_fd_sc_hd__dfxtp_1
X_10272_ clknet_leaf_78_clk _00191_ VGND VGND VPWR VPWR picorv32_core.count_instr\[56\]
+ sky130_fd_sc_hd__dfxtp_1
XTAP_TAPCELL_ROW_115_1975 VGND VPWR sky130_fd_sc_hd__tapvpwrvgnd_1
XFILLER_105_552 VGND VGND VPWR VPWR sky130_fd_sc_hd__fill_1
XFILLER_3_3 VPWR VGND VPWR VGND sky130_ef_sc_hd__decap_12
XFILLER_2_189 VGND VGND VPWR VPWR sky130_fd_sc_hd__decap_6
XFILLER_120_533 VGND VGND VPWR VPWR sky130_fd_sc_hd__fill_1
Xfanout471 _01705_ VGND VGND VPWR VPWR net471 sky130_fd_sc_hd__buf_2
Xfanout493 _02677_ VGND VGND VPWR VPWR net493 sky130_fd_sc_hd__clkbuf_2
Xfanout482 _03392_ VGND VGND VPWR VPWR net482 sky130_fd_sc_hd__clkbuf_4
Xfanout460 net464 VGND VGND VPWR VPWR net460 sky130_fd_sc_hd__buf_4
XFILLER_74_675 VGND VGND VPWR VPWR sky130_fd_sc_hd__fill_1
XFILLER_19_569 VGND VGND VPWR VPWR sky130_fd_sc_hd__fill_1
XFILLER_15_720 VGND VGND VPWR VPWR sky130_fd_sc_hd__decap_8
XFILLER_15_753 VPWR VGND VPWR VGND sky130_ef_sc_hd__decap_12
XFILLER_15_797 VPWR VGND VPWR VGND sky130_ef_sc_hd__decap_12
XFILLER_9_57 VPWR VGND VPWR VGND sky130_ef_sc_hd__decap_12
X_11657_ clknet_leaf_141_clk _01488_ VGND VGND VPWR VPWR picorv32_core.cpuregs\[26\]\[6\]
+ sky130_fd_sc_hd__dfxtp_1
XFILLER_127_132 VGND VGND VPWR VPWR sky130_fd_sc_hd__decap_3
X_10608_ clknet_leaf_92_clk _00462_ VGND VGND VPWR VPWR picorv32_core.instr_sltu sky130_fd_sc_hd__dfxtp_1
XTAP_TAPCELL_ROW_12_475 VGND VPWR sky130_fd_sc_hd__tapvpwrvgnd_1
XTAP_TAPCELL_ROW_12_486 VGND VPWR sky130_fd_sc_hd__tapvpwrvgnd_1
X_11588_ clknet_leaf_113_clk _01419_ VGND VGND VPWR VPWR picorv32_core.cpuregs\[23\]\[1\]
+ sky130_fd_sc_hd__dfxtp_1
XFILLER_128_699 VGND VGND VPWR VPWR sky130_fd_sc_hd__fill_1
Xhold908 picorv32_core.cpuregs\[21\]\[31\] VGND VGND VPWR VPWR net2017 sky130_fd_sc_hd__dlygate4sd3_1
Xhold919 picorv32_core.cpuregs\[28\]\[20\] VGND VGND VPWR VPWR net2028 sky130_fd_sc_hd__dlygate4sd3_1
X_10539_ clknet_leaf_47_clk picorv32_core.alu_out\[27\] VGND VGND VPWR VPWR picorv32_core.alu_out_q\[27\]
+ sky130_fd_sc_hd__dfxtp_1
XTAP_TAPCELL_ROW_77_1425 VGND VPWR sky130_fd_sc_hd__tapvpwrvgnd_1
XFILLER_131_809 VPWR VGND VPWR VGND sky130_ef_sc_hd__decap_12
XTAP_TAPCELL_ROW_90_1614 VGND VPWR sky130_fd_sc_hd__tapvpwrvgnd_1
XTAP_TAPCELL_ROW_90_1603 VGND VPWR sky130_fd_sc_hd__tapvpwrvgnd_1
X_07750_ picorv32_core.cpuregs\[28\]\[13\] picorv32_core.cpuregs\[29\]\[13\] picorv32_core.cpuregs\[30\]\[13\]
+ picorv32_core.cpuregs\[31\]\[13\] net739 net706 VGND VGND VPWR VPWR _03842_ sky130_fd_sc_hd__mux4_1
X_06701_ _02779_ picorv32_core.reg_next_pc\[28\] net560 VGND VGND VPWR VPWR _02940_
+ sky130_fd_sc_hd__mux2_2
XFILLER_77_480 VGND VGND VPWR VPWR sky130_fd_sc_hd__fill_2
XTAP_TAPCELL_ROW_88_1576 VGND VPWR sky130_fd_sc_hd__tapvpwrvgnd_1
X_07681_ picorv32_core.cpuregs\[8\]\[9\] picorv32_core.cpuregs\[9\]\[9\] picorv32_core.cpuregs\[10\]\[9\]
+ picorv32_core.cpuregs\[11\]\[9\] net741 net708 VGND VGND VPWR VPWR _03777_ sky130_fd_sc_hd__mux4_1
X_06632_ net2352 _02900_ _02902_ VGND VGND VPWR VPWR _00194_ sky130_fd_sc_hd__o21a_1
XTAP_TAPCELL_ROW_88_1587 VGND VPWR sky130_fd_sc_hd__tapvpwrvgnd_1
XFILLER_80_612 VPWR VGND VPWR VGND sky130_ef_sc_hd__decap_12
XFILLER_64_185 VGND VGND VPWR VPWR sky130_fd_sc_hd__fill_1
X_09420_ net283 _04593_ _04608_ _04589_ VGND VGND VPWR VPWR _01329_ sky130_fd_sc_hd__a31o_1
XFILLER_52_325 VGND VGND VPWR VPWR sky130_fd_sc_hd__decap_4
X_09351_ net830 _04539_ _04542_ net478 VGND VGND VPWR VPWR _04543_ sky130_fd_sc_hd__o211a_1
X_06563_ _02858_ net985 _02857_ VGND VGND VPWR VPWR _00169_ sky130_fd_sc_hd__and3b_1
XFILLER_100_27 VGND VGND VPWR VPWR sky130_fd_sc_hd__fill_1
X_05514_ _01979_ _01995_ _01994_ VGND VGND VPWR VPWR _02008_ sky130_fd_sc_hd__o21a_1
X_09282_ _04467_ _04468_ _04476_ net831 VGND VGND VPWR VPWR _04477_ sky130_fd_sc_hd__a22o_1
X_08302_ net1173 net6 net519 VGND VGND VPWR VPWR _00752_ sky130_fd_sc_hd__mux2_1
X_08233_ picorv32_core.mem_rdata_q\[24\] _01593_ net524 _04201_ VGND VGND VPWR VPWR
+ _04219_ sky130_fd_sc_hd__or4_1
X_06494_ _02814_ net986 _02813_ VGND VGND VPWR VPWR _00144_ sky130_fd_sc_hd__and3b_1
XFILLER_138_419 VGND VGND VPWR VPWR sky130_fd_sc_hd__fill_1
XTAP_TAPCELL_ROW_119_2031 VGND VPWR sky130_fd_sc_hd__tapvpwrvgnd_1
X_05445_ _01942_ _01943_ VGND VGND VPWR VPWR _01944_ sky130_fd_sc_hd__nor2_1
XTAP_TAPCELL_ROW_31_751 VGND VPWR sky130_fd_sc_hd__tapvpwrvgnd_1
XFILLER_119_644 VGND VGND VPWR VPWR sky130_fd_sc_hd__decap_4
X_05376_ picorv32_core.reg_pc\[12\] picorv32_core.decoded_imm\[12\] VGND VGND VPWR
+ VPWR _01880_ sky130_fd_sc_hd__nand2_1
X_08164_ net2278 net476 _04185_ _04187_ VGND VGND VPWR VPWR _00435_ sky130_fd_sc_hd__a22o_1
XTAP_TAPCELL_ROW_132_2220 VGND VPWR sky130_fd_sc_hd__tapvpwrvgnd_1
X_07115_ picorv32_core.count_cycle\[13\] picorv32_core.count_cycle\[14\] picorv32_core.count_cycle\[15\]
+ _03299_ VGND VGND VPWR VPWR _03304_ sky130_fd_sc_hd__and4_1
X_08095_ picorv32_core.latched_store _04166_ _04167_ _04163_ net981 VGND VGND VPWR
+ VPWR _00392_ sky130_fd_sc_hd__o221a_1
X_07046_ _02939_ _02940_ net932 VGND VGND VPWR VPWR _03253_ sky130_fd_sc_hd__o21a_1
Xclkload70 clknet_leaf_55_clk VGND VGND VPWR VPWR clkload70/Y sky130_fd_sc_hd__clkinv_8
XFILLER_88_701 VGND VGND VPWR VPWR sky130_fd_sc_hd__decap_6
Xclkload92 clknet_leaf_93_clk VGND VGND VPWR VPWR clkload92/Y sky130_fd_sc_hd__inv_6
Xclkload81 clknet_leaf_113_clk VGND VGND VPWR VPWR clkload81/X sky130_fd_sc_hd__clkbuf_4
XFILLER_121_319 VGND VGND VPWR VPWR sky130_fd_sc_hd__fill_1
XFILLER_0_605 VGND VGND VPWR VPWR sky130_fd_sc_hd__decap_6
XFILLER_125_57 VPWR VGND VPWR VGND sky130_ef_sc_hd__decap_12
XFILLER_102_533 VGND VGND VPWR VPWR sky130_fd_sc_hd__decap_3
XTAP_TAPCELL_ROW_110_1894 VGND VPWR sky130_fd_sc_hd__tapvpwrvgnd_1
XFILLER_75_417 VGND VGND VPWR VPWR sky130_fd_sc_hd__decap_4
X_08997_ net297 net2057 net345 VGND VGND VPWR VPWR _01167_ sky130_fd_sc_hd__mux2_1
X_07948_ picorv32_core.cpuregs\[28\]\[24\] picorv32_core.cpuregs\[29\]\[24\] picorv32_core.cpuregs\[30\]\[24\]
+ picorv32_core.cpuregs\[31\]\[24\] net753 net720 VGND VGND VPWR VPWR _04029_ sky130_fd_sc_hd__mux4_1
X_07879_ picorv32_core.cpuregs\[0\]\[20\] picorv32_core.cpuregs\[1\]\[20\] picorv32_core.cpuregs\[2\]\[20\]
+ picorv32_core.cpuregs\[3\]\[20\] net753 net720 VGND VGND VPWR VPWR _03964_ sky130_fd_sc_hd__mux4_1
XFILLER_56_653 VGND VGND VPWR VPWR sky130_fd_sc_hd__fill_2
XTAP_TAPCELL_ROW_48_1004 VGND VPWR sky130_fd_sc_hd__tapvpwrvgnd_1
XFILLER_18_77 VGND VGND VPWR VPWR sky130_fd_sc_hd__decap_6
X_09618_ net650 _04797_ VGND VGND VPWR VPWR _04798_ sky130_fd_sc_hd__or2_1
X_10890_ clknet_leaf_99_clk _00741_ VGND VGND VPWR VPWR picorv32_core.mem_rdata_q\[0\]
+ sky130_fd_sc_hd__dfxtp_1
XTAP_TAPCELL_ROW_39_873 VGND VPWR sky130_fd_sc_hd__tapvpwrvgnd_1
X_09549_ _04723_ _04730_ _04731_ net645 net650 VGND VGND VPWR VPWR _04732_ sky130_fd_sc_hd__a221o_1
XFILLER_70_166 VGND VGND VPWR VPWR sky130_fd_sc_hd__fill_1
XFILLER_43_369 VGND VGND VPWR VPWR sky130_fd_sc_hd__decap_8
XFILLER_140_3 VPWR VGND VPWR VGND sky130_ef_sc_hd__decap_12
X_11511_ clknet_leaf_61_clk _01347_ VGND VGND VPWR VPWR net161 sky130_fd_sc_hd__dfxtp_1
X_11442_ clknet_leaf_71_clk _01278_ VGND VGND VPWR VPWR picorv32_core.cpuregs\[1\]\[25\]
+ sky130_fd_sc_hd__dfxtp_1
XFILLER_137_474 VGND VGND VPWR VPWR sky130_fd_sc_hd__fill_1
X_11373_ clknet_leaf_66_clk _01214_ VGND VGND VPWR VPWR picorv32_core.cpuregs\[18\]\[25\]
+ sky130_fd_sc_hd__dfxtp_1
X_10324_ clknet_leaf_89_clk _00243_ VGND VGND VPWR VPWR picorv32_core.reg_next_pc\[14\]
+ sky130_fd_sc_hd__dfxtp_1
XTAP_TAPCELL_ROW_59_1166 VGND VPWR sky130_fd_sc_hd__tapvpwrvgnd_1
XTAP_TAPCELL_ROW_59_1155 VGND VPWR sky130_fd_sc_hd__tapvpwrvgnd_1
XFILLER_124_135 VGND VGND VPWR VPWR sky130_fd_sc_hd__decap_4
XTAP_TAPCELL_ROW_72_1344 VGND VPWR sky130_fd_sc_hd__tapvpwrvgnd_1
X_10255_ clknet_leaf_101_clk _00174_ VGND VGND VPWR VPWR picorv32_core.count_instr\[39\]
+ sky130_fd_sc_hd__dfxtp_1
XFILLER_132_190 VGND VGND VPWR VPWR sky130_fd_sc_hd__decap_6
XFILLER_105_393 VGND VGND VPWR VPWR sky130_fd_sc_hd__fill_1
XTAP_TAPCELL_ROW_72_1355 VGND VPWR sky130_fd_sc_hd__tapvpwrvgnd_1
X_10186_ clknet_leaf_136_clk _00105_ VGND VGND VPWR VPWR picorv32_core.cpuregs\[9\]\[2\]
+ sky130_fd_sc_hd__dfxtp_1
XFILLER_39_609 VGND VGND VPWR VPWR sky130_fd_sc_hd__decap_6
XFILLER_93_225 VGND VGND VPWR VPWR sky130_fd_sc_hd__decap_4
Xfanout290 net293 VGND VGND VPWR VPWR net290 sky130_fd_sc_hd__clkbuf_2
XFILLER_75_61 VGND VGND VPWR VPWR sky130_fd_sc_hd__fill_1
XFILLER_75_50 VGND VGND VPWR VPWR sky130_fd_sc_hd__decap_6
XFILLER_46_141 VGND VGND VPWR VPWR sky130_fd_sc_hd__decap_4
XFILLER_19_377 VGND VGND VPWR VPWR sky130_fd_sc_hd__fill_2
XFILLER_62_645 VGND VGND VPWR VPWR sky130_fd_sc_hd__fill_2
XTAP_TAPCELL_ROW_17_545 VGND VPWR sky130_fd_sc_hd__tapvpwrvgnd_1
XFILLER_62_678 VGND VGND VPWR VPWR sky130_fd_sc_hd__decap_6
XTAP_TAPCELL_ROW_17_556 VGND VPWR sky130_fd_sc_hd__tapvpwrvgnd_1
X_11709_ clknet_leaf_47_clk _01540_ VGND VGND VPWR VPWR picorv32_core.cpuregs\[27\]\[26\]
+ sky130_fd_sc_hd__dfxtp_1
XFILLER_30_542 VGND VGND VPWR VPWR sky130_fd_sc_hd__fill_2
X_05230_ picorv32_core.reg_pc\[2\] picorv32_core.decoded_imm\[2\] VGND VGND VPWR VPWR
+ _01744_ sky130_fd_sc_hd__or2_1
X_05161_ net925 _01645_ _01686_ VGND VGND VPWR VPWR _00019_ sky130_fd_sc_hd__a21o_1
Xhold727 picorv32_core.cpuregs\[25\]\[29\] VGND VGND VPWR VPWR net1836 sky130_fd_sc_hd__dlygate4sd3_1
XFILLER_115_113 VGND VGND VPWR VPWR sky130_fd_sc_hd__fill_2
Xhold716 picorv32_core.cpuregs\[5\]\[3\] VGND VGND VPWR VPWR net1825 sky130_fd_sc_hd__dlygate4sd3_1
Xhold705 picorv32_core.cpuregs\[28\]\[11\] VGND VGND VPWR VPWR net1814 sky130_fd_sc_hd__dlygate4sd3_1
XFILLER_115_157 VGND VGND VPWR VPWR sky130_fd_sc_hd__fill_2
X_05092_ picorv32_core.mem_state\[0\] picorv32_core.mem_state\[1\] VGND VGND VPWR
+ VPWR _01624_ sky130_fd_sc_hd__nand2_1
Xhold738 picorv32_core.cpuregs\[2\]\[10\] VGND VGND VPWR VPWR net1847 sky130_fd_sc_hd__dlygate4sd3_1
Xhold749 picorv32_core.cpuregs\[17\]\[7\] VGND VGND VPWR VPWR net1858 sky130_fd_sc_hd__dlygate4sd3_1
X_08920_ net505 net1917 net357 VGND VGND VPWR VPWR _01093_ sky130_fd_sc_hd__mux2_1
X_08851_ net1715 net211 net368 VGND VGND VPWR VPWR _01027_ sky130_fd_sc_hd__mux2_1
XFILLER_112_831 VGND VGND VPWR VPWR sky130_fd_sc_hd__fill_2
X_07802_ picorv32_core.cpuregs\[4\]\[16\] picorv32_core.cpuregs\[5\]\[16\] picorv32_core.cpuregs\[6\]\[16\]
+ picorv32_core.cpuregs\[7\]\[16\] net749 net716 VGND VGND VPWR VPWR _03891_ sky130_fd_sc_hd__mux4_1
X_08782_ net217 net1569 net376 VGND VGND VPWR VPWR _00929_ sky130_fd_sc_hd__mux2_1
XFILLER_97_597 VGND VGND VPWR VPWR sky130_fd_sc_hd__decap_8
X_05994_ net671 _02458_ VGND VGND VPWR VPWR _02459_ sky130_fd_sc_hd__and2_1
X_07733_ picorv32_core.cpuregs\[4\]\[12\] picorv32_core.cpuregs\[5\]\[12\] picorv32_core.cpuregs\[6\]\[12\]
+ picorv32_core.cpuregs\[7\]\[12\] net737 net704 VGND VGND VPWR VPWR _03826_ sky130_fd_sc_hd__mux4_1
XTAP_TAPCELL_ROW_36_821 VGND VPWR sky130_fd_sc_hd__tapvpwrvgnd_1
XFILLER_38_697 VGND VGND VPWR VPWR sky130_fd_sc_hd__decap_3
X_07664_ _03755_ _03756_ net628 VGND VGND VPWR VPWR _03761_ sky130_fd_sc_hd__mux2_1
XFILLER_111_15 VGND VGND VPWR VPWR sky130_fd_sc_hd__decap_8
X_06615_ _01585_ _02889_ _02891_ net978 VGND VGND VPWR VPWR _00188_ sky130_fd_sc_hd__a211oi_1
X_09403_ net793 net548 _04527_ net474 VGND VGND VPWR VPWR _04592_ sky130_fd_sc_hd__o211a_1
XFILLER_53_656 VGND VGND VPWR VPWR sky130_fd_sc_hd__fill_2
XTAP_TAPCELL_ROW_36_832 VGND VPWR sky130_fd_sc_hd__tapvpwrvgnd_1
XFILLER_80_475 VGND VGND VPWR VPWR sky130_fd_sc_hd__fill_1
X_07595_ picorv32_core.decoded_imm\[4\] _01682_ net510 VGND VGND VPWR VPWR _03696_
+ sky130_fd_sc_hd__o21a_1
XFILLER_139_706 VPWR VGND VPWR VGND sky130_ef_sc_hd__decap_12
X_06546_ picorv32_core.count_instr\[28\] picorv32_core.count_instr\[27\] _02844_ VGND
+ VGND VPWR VPWR _02848_ sky130_fd_sc_hd__and3_1
X_09334_ net815 net540 _04525_ net474 VGND VGND VPWR VPWR _04526_ sky130_fd_sc_hd__o211a_1
XFILLER_138_216 VGND VGND VPWR VPWR sky130_fd_sc_hd__fill_2
X_09265_ picorv32_core.cpuregs\[20\]\[4\] picorv32_core.cpuregs\[21\]\[4\] net886
+ VGND VGND VPWR VPWR _04460_ sky130_fd_sc_hd__mux2_1
X_06477_ picorv32_core.count_instr\[3\] picorv32_core.count_instr\[2\] _02801_ VGND
+ VGND VPWR VPWR _02804_ sky130_fd_sc_hd__and3_1
X_05428_ _01927_ VGND VGND VPWR VPWR _01928_ sky130_fd_sc_hd__inv_2
X_08216_ net1787 net476 _04200_ _04208_ VGND VGND VPWR VPWR _00462_ sky130_fd_sc_hd__a22o_1
Xpicorv32_axi_1104 VGND VGND VPWR VPWR picorv32_axi_1104/HI trace_data[31] sky130_fd_sc_hd__conb_1
X_09196_ _04378_ _04383_ _04388_ _04393_ net649 net644 VGND VGND VPWR VPWR _04394_
+ sky130_fd_sc_hd__mux4_1
X_08147_ net2233 _02600_ _04173_ _04175_ VGND VGND VPWR VPWR _00430_ sky130_fd_sc_hd__a22o_1
X_05359_ _01861_ _01862_ VGND VGND VPWR VPWR _01864_ sky130_fd_sc_hd__or2_1
X_08078_ _00002_ _04151_ VGND VGND VPWR VPWR _04152_ sky130_fd_sc_hd__or2_1
XTAP_TAPCELL_ROW_112_1934 VGND VPWR sky130_fd_sc_hd__tapvpwrvgnd_1
XTAP_TAPCELL_ROW_112_1923 VGND VPWR sky130_fd_sc_hd__tapvpwrvgnd_1
X_07029_ _02938_ _02939_ _03219_ VGND VGND VPWR VPWR _03238_ sky130_fd_sc_hd__and3_1
XFILLER_0_413 VGND VGND VPWR VPWR sky130_fd_sc_hd__decap_3
XFILLER_96_27 VGND VGND VPWR VPWR sky130_fd_sc_hd__fill_1
X_10040_ net1860 net501 net305 VGND VGND VPWR VPWR _01515_ sky130_fd_sc_hd__mux2_1
XFILLER_88_564 VGND VGND VPWR VPWR sky130_fd_sc_hd__decap_6
XTAP_TAPCELL_ROW_54_1085 VGND VPWR sky130_fd_sc_hd__tapvpwrvgnd_1
Xhold32 picorv32_core.cpuregs\[0\]\[11\] VGND VGND VPWR VPWR net1141 sky130_fd_sc_hd__dlygate4sd3_1
Xhold10 picorv32_core.cpuregs\[0\]\[3\] VGND VGND VPWR VPWR net1119 sky130_fd_sc_hd__dlygate4sd3_1
Xhold21 picorv32_core.cpuregs\[0\]\[9\] VGND VGND VPWR VPWR net1130 sky130_fd_sc_hd__dlygate4sd3_1
Xhold43 net114 VGND VGND VPWR VPWR net1152 sky130_fd_sc_hd__dlygate4sd3_1
Xhold54 net134 VGND VGND VPWR VPWR net1163 sky130_fd_sc_hd__dlygate4sd3_1
Xhold65 picorv32_core.instr_add VGND VGND VPWR VPWR net1174 sky130_fd_sc_hd__dlygate4sd3_1
Xhold98 picorv32_core.cpuregs\[22\]\[22\] VGND VGND VPWR VPWR net1207 sky130_fd_sc_hd__dlygate4sd3_1
Xhold76 net127 VGND VGND VPWR VPWR net1185 sky130_fd_sc_hd__dlygate4sd3_1
XFILLER_75_269 VGND VGND VPWR VPWR sky130_fd_sc_hd__fill_1
Xhold87 picorv32_core.mem_rdata_q\[8\] VGND VGND VPWR VPWR net1196 sky130_fd_sc_hd__dlygate4sd3_1
X_10942_ clknet_leaf_40_clk _00793_ VGND VGND VPWR VPWR picorv32_core.cpuregs\[19\]\[20\]
+ sky130_fd_sc_hd__dfxtp_1
XFILLER_90_206 VGND VGND VPWR VPWR sky130_fd_sc_hd__decap_4
XFILLER_44_601 VGND VGND VPWR VPWR sky130_fd_sc_hd__decap_6
XFILLER_45_31 VGND VGND VPWR VPWR sky130_fd_sc_hd__fill_1
XFILLER_71_420 VGND VGND VPWR VPWR sky130_fd_sc_hd__fill_2
X_10873_ clknet_leaf_26_clk _00724_ VGND VGND VPWR VPWR picorv32_core.cpuregs\[16\]\[17\]
+ sky130_fd_sc_hd__dfxtp_1
XTAP_TAPCELL_ROW_14_504 VGND VPWR sky130_fd_sc_hd__tapvpwrvgnd_1
XFILLER_16_369 VGND VGND VPWR VPWR sky130_fd_sc_hd__fill_1
XFILLER_32_829 VGND VGND VPWR VPWR sky130_fd_sc_hd__decap_4
XTAP_TAPCELL_ROW_14_515 VGND VPWR sky130_fd_sc_hd__tapvpwrvgnd_1
XFILLER_129_205 VGND VGND VPWR VPWR sky130_fd_sc_hd__fill_1
XFILLER_61_52 VGND VGND VPWR VPWR sky130_fd_sc_hd__decap_4
XFILLER_12_542 VGND VGND VPWR VPWR sky130_fd_sc_hd__decap_4
XANTENNA_7 _02690_ VGND VGND VPWR VPWR sky130_fd_sc_hd__diode_2
X_11425_ clknet_leaf_1_clk _01261_ VGND VGND VPWR VPWR picorv32_core.cpuregs\[1\]\[8\]
+ sky130_fd_sc_hd__dfxtp_1
X_11356_ clknet_leaf_12_clk _01197_ VGND VGND VPWR VPWR picorv32_core.cpuregs\[18\]\[8\]
+ sky130_fd_sc_hd__dfxtp_1
X_10307_ clknet_leaf_69_clk _00226_ VGND VGND VPWR VPWR picorv32_core.reg_pc\[28\]
+ sky130_fd_sc_hd__dfxtp_2
X_11287_ clknet_leaf_3_clk _01135_ VGND VGND VPWR VPWR picorv32_core.cpuregs\[3\]\[10\]
+ sky130_fd_sc_hd__dfxtp_1
X_10238_ clknet_leaf_79_clk _00157_ VGND VGND VPWR VPWR picorv32_core.count_instr\[22\]
+ sky130_fd_sc_hd__dfxtp_1
XFILLER_20_6 VPWR VGND VPWR VGND sky130_ef_sc_hd__decap_12
X_10169_ clknet_leaf_25_clk _00088_ VGND VGND VPWR VPWR picorv32_core.cpuregs\[21\]\[17\]
+ sky130_fd_sc_hd__dfxtp_1
XFILLER_94_589 VGND VGND VPWR VPWR sky130_fd_sc_hd__fill_1
XFILLER_35_623 VGND VGND VPWR VPWR sky130_fd_sc_hd__decap_3
XTAP_TAPCELL_ROW_85_1535 VGND VPWR sky130_fd_sc_hd__tapvpwrvgnd_1
X_06400_ net1359 net208 net436 VGND VGND VPWR VPWR _00070_ sky130_fd_sc_hd__mux2_1
X_07380_ _03415_ _03519_ VGND VGND VPWR VPWR _03520_ sky130_fd_sc_hd__or2_1
X_06331_ _02737_ _02738_ net565 VGND VGND VPWR VPWR _02739_ sky130_fd_sc_hd__mux2_2
XFILLER_15_391 VGND VGND VPWR VPWR sky130_fd_sc_hd__fill_1
X_09050_ net212 net1793 net343 VGND VGND VPWR VPWR _01219_ sky130_fd_sc_hd__mux2_1
X_06262_ picorv32_core.reg_out\[5\] picorv32_core.alu_out_q\[5\] net950 VGND VGND
+ VPWR VPWR _02683_ sky130_fd_sc_hd__mux2_1
XFILLER_129_761 VPWR VGND VPWR VGND sky130_ef_sc_hd__decap_12
X_08001_ picorv32_core.cpuregs\[24\]\[27\] picorv32_core.cpuregs\[25\]\[27\] picorv32_core.cpuregs\[26\]\[27\]
+ picorv32_core.cpuregs\[27\]\[27\] net755 net722 VGND VGND VPWR VPWR _04079_ sky130_fd_sc_hd__mux4_1
X_05213_ _01725_ net576 _01728_ _01723_ net908 VGND VGND VPWR VPWR _01729_ sky130_fd_sc_hd__a32o_1
Xhold502 picorv32_core.cpuregs\[20\]\[15\] VGND VGND VPWR VPWR net1611 sky130_fd_sc_hd__dlygate4sd3_1
X_06193_ _01687_ _02623_ _01688_ VGND VGND VPWR VPWR _02624_ sky130_fd_sc_hd__a21oi_1
Xhold524 picorv32_core.cpuregs\[17\]\[18\] VGND VGND VPWR VPWR net1633 sky130_fd_sc_hd__dlygate4sd3_1
Xhold513 picorv32_core.cpuregs\[1\]\[12\] VGND VGND VPWR VPWR net1622 sky130_fd_sc_hd__dlygate4sd3_1
X_05144_ picorv32_core.instr_lw _01639_ _01646_ picorv32_core.instr_sw net515 VGND
+ VGND VPWR VPWR _01673_ sky130_fd_sc_hd__a221o_1
Xhold535 picorv32_core.cpuregs\[6\]\[3\] VGND VGND VPWR VPWR net1644 sky130_fd_sc_hd__dlygate4sd3_1
Xhold568 picorv32_core.cpuregs\[28\]\[27\] VGND VGND VPWR VPWR net1677 sky130_fd_sc_hd__dlygate4sd3_1
XTAP_TAPCELL_ROW_96_1697 VGND VPWR sky130_fd_sc_hd__tapvpwrvgnd_1
X_05075_ net183 VGND VGND VPWR VPWR _01610_ sky130_fd_sc_hd__inv_2
Xhold557 picorv32_core.cpuregs\[3\]\[14\] VGND VGND VPWR VPWR net1666 sky130_fd_sc_hd__dlygate4sd3_1
X_09952_ net1752 net287 net316 VGND VGND VPWR VPWR _01430_ sky130_fd_sc_hd__mux2_1
Xhold546 picorv32_core.cpuregs\[7\]\[1\] VGND VGND VPWR VPWR net1655 sky130_fd_sc_hd__dlygate4sd3_1
Xhold579 picorv32_core.cpuregs\[5\]\[5\] VGND VGND VPWR VPWR net1688 sky130_fd_sc_hd__dlygate4sd3_1
XFILLER_106_15 VGND VGND VPWR VPWR sky130_fd_sc_hd__decap_4
XFILLER_103_149 VGND VGND VPWR VPWR sky130_fd_sc_hd__decap_3
X_08903_ net266 net1548 net360 VGND VGND VPWR VPWR _01077_ sky130_fd_sc_hd__mux2_1
XFILLER_112_650 VGND VGND VPWR VPWR sky130_fd_sc_hd__fill_1
X_09883_ net1470 net246 net326 VGND VGND VPWR VPWR _01371_ sky130_fd_sc_hd__mux2_1
XFILLER_85_523 VPWR VGND VPWR VGND sky130_ef_sc_hd__decap_12
Xhold1224 picorv32_core.count_instr\[18\] VGND VGND VPWR VPWR net2333 sky130_fd_sc_hd__dlygate4sd3_1
Xhold1202 picorv32_core.count_cycle\[50\] VGND VGND VPWR VPWR net2311 sky130_fd_sc_hd__dlygate4sd3_1
Xhold1213 picorv32_core.mem_rdata_q\[1\] VGND VGND VPWR VPWR net2322 sky130_fd_sc_hd__dlygate4sd3_1
X_08834_ net1227 net279 net366 VGND VGND VPWR VPWR _01010_ sky130_fd_sc_hd__mux2_1
XFILLER_57_225 VGND VGND VPWR VPWR sky130_fd_sc_hd__decap_4
XTAP_TAPCELL_ROW_127_2152 VGND VPWR sky130_fd_sc_hd__tapvpwrvgnd_1
XTAP_TAPCELL_ROW_127_2141 VGND VPWR sky130_fd_sc_hd__tapvpwrvgnd_1
Xhold1246 picorv32_core.reg_pc\[14\] VGND VGND VPWR VPWR net2355 sky130_fd_sc_hd__dlygate4sd3_1
Xhold1235 picorv32_core.count_instr\[14\] VGND VGND VPWR VPWR net2344 sky130_fd_sc_hd__dlygate4sd3_1
Xhold1257 picorv32_core.mem_rdata_q\[4\] VGND VGND VPWR VPWR net2366 sky130_fd_sc_hd__dlygate4sd3_1
X_08765_ net292 net2243 net374 VGND VGND VPWR VPWR _00912_ sky130_fd_sc_hd__mux2_1
X_05977_ _02440_ _02443_ VGND VGND VPWR VPWR _02444_ sky130_fd_sc_hd__xnor2_1
X_07716_ net692 _03809_ VGND VGND VPWR VPWR _03810_ sky130_fd_sc_hd__or2_1
XFILLER_38_472 VGND VGND VPWR VPWR sky130_fd_sc_hd__decap_4
XTAP_TAPCELL_ROW_140_2341 VGND VPWR sky130_fd_sc_hd__tapvpwrvgnd_1
XTAP_TAPCELL_ROW_140_2330 VGND VPWR sky130_fd_sc_hd__tapvpwrvgnd_1
XFILLER_53_442 VGND VGND VPWR VPWR sky130_fd_sc_hd__decap_6
X_08696_ net1580 net426 net382 VGND VGND VPWR VPWR _00845_ sky130_fd_sc_hd__mux2_1
XFILLER_25_111 VGND VGND VPWR VPWR sky130_fd_sc_hd__fill_1
XFILLER_25_122 VGND VGND VPWR VPWR sky130_fd_sc_hd__decap_3
XTAP_TAPCELL_ROW_0_287 VGND VPWR sky130_fd_sc_hd__tapvpwrvgnd_1
X_07647_ net693 _03741_ _03740_ net617 VGND VGND VPWR VPWR _03745_ sky130_fd_sc_hd__o211a_1
XFILLER_41_615 VGND VGND VPWR VPWR sky130_fd_sc_hd__fill_1
XTAP_TAPCELL_ROW_0_298 VGND VPWR sky130_fd_sc_hd__tapvpwrvgnd_1
X_07578_ picorv32_core.cpuregs\[16\]\[1\] picorv32_core.cpuregs\[17\]\[1\] picorv32_core.cpuregs\[18\]\[1\]
+ picorv32_core.cpuregs\[19\]\[1\] net744 net711 VGND VGND VPWR VPWR _03682_ sky130_fd_sc_hd__mux4_1
XFILLER_139_503 VGND VGND VPWR VPWR sky130_fd_sc_hd__fill_1
X_06529_ picorv32_core.count_instr\[22\] picorv32_core.count_instr\[21\] _02833_ VGND
+ VGND VPWR VPWR _02837_ sky130_fd_sc_hd__and3_1
X_09317_ picorv32_core.cpuregs\[28\]\[6\] picorv32_core.cpuregs\[29\]\[6\] picorv32_core.cpuregs\[30\]\[6\]
+ picorv32_core.cpuregs\[31\]\[6\] net874 net841 VGND VGND VPWR VPWR _04510_ sky130_fd_sc_hd__mux4_1
X_09248_ _00007_ _04441_ net644 VGND VGND VPWR VPWR _04444_ sky130_fd_sc_hd__a21o_1
X_09179_ picorv32_core.cpuregs\[24\]\[1\] picorv32_core.cpuregs\[25\]\[1\] net887
+ VGND VGND VPWR VPWR _04377_ sky130_fd_sc_hd__mux2_1
XFILLER_31_55 VGND VGND VPWR VPWR sky130_fd_sc_hd__fill_1
Xclkbuf_4_10_0_clk clknet_0_clk VGND VGND VPWR VPWR clknet_4_10_0_clk sky130_fd_sc_hd__clkbuf_8
XFILLER_135_753 VPWR VGND VPWR VGND sky130_ef_sc_hd__decap_12
XFILLER_107_455 VGND VGND VPWR VPWR sky130_fd_sc_hd__fill_1
XTAP_TAPCELL_ROW_56_1114 VGND VPWR sky130_fd_sc_hd__tapvpwrvgnd_1
X_11210_ clknet_leaf_119_clk _01061_ VGND VGND VPWR VPWR picorv32_core.cpuregs\[5\]\[0\]
+ sky130_fd_sc_hd__dfxtp_1
XFILLER_135_797 VPWR VGND VPWR VGND sky130_ef_sc_hd__decap_12
X_11141_ clknet_leaf_41_clk _00992_ VGND VGND VPWR VPWR picorv32_core.cpuregs\[8\]\[27\]
+ sky130_fd_sc_hd__dfxtp_1
XFILLER_103_3 VPWR VGND VPWR VGND sky130_ef_sc_hd__decap_12
Xoutput55 net55 VGND VGND VPWR VPWR mem_axi_araddr[26] sky130_fd_sc_hd__buf_2
Xoutput44 net44 VGND VGND VPWR VPWR mem_axi_araddr[15] sky130_fd_sc_hd__buf_2
XFILLER_0_221 VGND VGND VPWR VPWR sky130_fd_sc_hd__decap_3
Xoutput66 net66 VGND VGND VPWR VPWR mem_axi_araddr[7] sky130_fd_sc_hd__buf_2
Xoutput88 net88 VGND VGND VPWR VPWR mem_axi_awaddr[27] sky130_fd_sc_hd__buf_2
XFILLER_110_609 VPWR VGND VPWR VGND sky130_ef_sc_hd__decap_12
X_11072_ clknet_leaf_33_clk _00923_ VGND VGND VPWR VPWR picorv32_core.cpuregs\[10\]\[22\]
+ sky130_fd_sc_hd__dfxtp_1
Xoutput77 net77 VGND VGND VPWR VPWR mem_axi_awaddr[16] sky130_fd_sc_hd__buf_2
Xoutput99 net99 VGND VGND VPWR VPWR mem_axi_awaddr[8] sky130_fd_sc_hd__buf_2
XFILLER_1_777 VGND VGND VPWR VPWR sky130_fd_sc_hd__decap_6
XFILLER_88_394 VGND VGND VPWR VPWR sky130_fd_sc_hd__fill_2
XFILLER_88_372 VGND VGND VPWR VPWR sky130_fd_sc_hd__decap_4
X_10023_ net1351 net261 net310 VGND VGND VPWR VPWR _01499_ sky130_fd_sc_hd__mux2_1
XFILLER_0_265 VGND VGND VPWR VPWR sky130_fd_sc_hd__decap_3
XFILLER_76_545 VGND VGND VPWR VPWR sky130_fd_sc_hd__decap_6
XFILLER_0_298 VGND VGND VPWR VPWR sky130_fd_sc_hd__fill_1
XFILLER_91_537 VGND VGND VPWR VPWR sky130_fd_sc_hd__decap_8
XFILLER_57_781 VGND VGND VPWR VPWR sky130_fd_sc_hd__decap_3
XFILLER_57_770 VGND VGND VPWR VPWR sky130_fd_sc_hd__decap_4
XFILLER_91_559 VGND VGND VPWR VPWR sky130_fd_sc_hd__fill_1
XFILLER_56_85 VGND VGND VPWR VPWR sky130_fd_sc_hd__decap_4
XFILLER_17_623 VGND VGND VPWR VPWR sky130_fd_sc_hd__fill_1
XFILLER_17_645 VGND VGND VPWR VPWR sky130_fd_sc_hd__decap_3
XTAP_TAPCELL_ROW_67_1276 VGND VPWR sky130_fd_sc_hd__tapvpwrvgnd_1
X_10925_ clknet_leaf_118_clk _00776_ VGND VGND VPWR VPWR picorv32_core.cpuregs\[19\]\[3\]
+ sky130_fd_sc_hd__dfxtp_1
XFILLER_16_133 VGND VGND VPWR VPWR sky130_fd_sc_hd__fill_1
X_10856_ clknet_leaf_118_clk _00707_ VGND VGND VPWR VPWR picorv32_core.cpuregs\[16\]\[0\]
+ sky130_fd_sc_hd__dfxtp_1
XTAP_TAPCELL_ROW_27_695 VGND VPWR sky130_fd_sc_hd__tapvpwrvgnd_1
XFILLER_44_486 VGND VGND VPWR VPWR sky130_fd_sc_hd__decap_3
X_10787_ clknet_leaf_36_clk _00638_ VGND VGND VPWR VPWR picorv32_core.cpuregs\[14\]\[28\]
+ sky130_fd_sc_hd__dfxtp_1
XTAP_TAPCELL_ROW_80_1465 VGND VPWR sky130_fd_sc_hd__tapvpwrvgnd_1
XFILLER_9_833 VGND VGND VPWR VPWR sky130_fd_sc_hd__fill_1
XFILLER_117_219 VGND VGND VPWR VPWR sky130_fd_sc_hd__decap_4
X_11408_ clknet_leaf_46_clk _01244_ VGND VGND VPWR VPWR picorv32_core.cpuregs\[31\]\[23\]
+ sky130_fd_sc_hd__dfxtp_1
XFILLER_141_701 VGND VGND VPWR VPWR sky130_fd_sc_hd__fill_2
XFILLER_141_734 VGND VGND VPWR VPWR sky130_fd_sc_hd__decap_4
X_11339_ clknet_leaf_46_clk _01180_ VGND VGND VPWR VPWR picorv32_core.cpuregs\[29\]\[23\]
+ sky130_fd_sc_hd__dfxtp_1
XFILLER_140_299 VGND VGND VPWR VPWR sky130_fd_sc_hd__fill_1
X_06880_ net679 net589 _03099_ _03100_ VGND VGND VPWR VPWR _03101_ sky130_fd_sc_hd__and4_1
XFILLER_67_534 VGND VGND VPWR VPWR sky130_fd_sc_hd__fill_1
X_05900_ _02370_ _02371_ VGND VGND VPWR VPWR _02373_ sky130_fd_sc_hd__or2_1
XFILLER_39_225 VGND VGND VPWR VPWR sky130_fd_sc_hd__decap_3
X_05831_ _02285_ _02308_ net669 VGND VGND VPWR VPWR _02309_ sky130_fd_sc_hd__o21a_1
XFILLER_55_729 VGND VGND VPWR VPWR sky130_fd_sc_hd__decap_3
X_05762_ picorv32_core.instr_bge picorv32_core.is_slti_blt_slt _02244_ VGND VGND VPWR
+ VPWR _02246_ sky130_fd_sc_hd__mux2_1
X_08550_ net498 net2138 net399 VGND VGND VPWR VPWR _00675_ sky130_fd_sc_hd__mux2_1
X_07501_ net782 _03621_ net533 VGND VGND VPWR VPWR _03622_ sky130_fd_sc_hd__mux2_1
X_05693_ net781 net955 VGND VGND VPWR VPWR _02177_ sky130_fd_sc_hd__nand2_1
X_08481_ net1489 net498 net407 VGND VGND VPWR VPWR _00611_ sky130_fd_sc_hd__mux2_1
XFILLER_35_475 VGND VGND VPWR VPWR sky130_fd_sc_hd__decap_3
XTAP_TAPCELL_ROW_46_971 VGND VPWR sky130_fd_sc_hd__tapvpwrvgnd_1
XTAP_TAPCELL_ROW_122_2071 VGND VPWR sky130_fd_sc_hd__tapvpwrvgnd_1
X_07432_ net833 _03564_ _03571_ net647 VGND VGND VPWR VPWR _03572_ sky130_fd_sc_hd__a211o_1
X_09102_ net266 net2078 net334 VGND VGND VPWR VPWR _01269_ sky130_fd_sc_hd__mux2_1
X_07363_ _03500_ _03502_ VGND VGND VPWR VPWR _03503_ sky130_fd_sc_hd__nor2_1
XTAP_TAPCELL_ROW_98_1726 VGND VPWR sky130_fd_sc_hd__tapvpwrvgnd_1
X_06314_ picorv32_core.reg_pc\[14\] _02718_ picorv32_core.reg_pc\[15\] VGND VGND VPWR
+ VPWR _02725_ sky130_fd_sc_hd__a21oi_1
X_07294_ _03433_ VGND VGND VPWR VPWR _03434_ sky130_fd_sc_hd__inv_2
X_09033_ net276 net1867 net341 VGND VGND VPWR VPWR _01202_ sky130_fd_sc_hd__mux2_1
X_06245_ net1274 net504 net434 VGND VGND VPWR VPWR _00039_ sky130_fd_sc_hd__mux2_1
XFILLER_117_753 VPWR VGND VPWR VGND sky130_ef_sc_hd__decap_12
XPHY_EDGE_ROW_107_Left_249 VGND VGND VPWR VPWR sky130_fd_sc_hd__decap_3
X_06176_ _02606_ _02607_ net632 VGND VGND VPWR VPWR _02608_ sky130_fd_sc_hd__mux2_1
Xhold310 picorv32_core.cpuregs\[1\]\[2\] VGND VGND VPWR VPWR net1419 sky130_fd_sc_hd__dlygate4sd3_1
XFILLER_117_797 VPWR VGND VPWR VGND sky130_ef_sc_hd__decap_12
Xhold332 picorv32_core.cpuregs\[7\]\[14\] VGND VGND VPWR VPWR net1441 sky130_fd_sc_hd__dlygate4sd3_1
Xhold321 picorv32_core.cpuregs\[26\]\[14\] VGND VGND VPWR VPWR net1430 sky130_fd_sc_hd__dlygate4sd3_1
X_05127_ picorv32_core.instr_addi picorv32_core.instr_bltu picorv32_core.instr_blt
+ picorv32_core.instr_bne VGND VGND VPWR VPWR _01658_ sky130_fd_sc_hd__or4_1
Xhold343 picorv32_core.cpuregs\[3\]\[12\] VGND VGND VPWR VPWR net1452 sky130_fd_sc_hd__dlygate4sd3_1
XFILLER_131_222 VGND VGND VPWR VPWR sky130_fd_sc_hd__fill_2
Xhold376 picorv32_core.cpuregs\[27\]\[26\] VGND VGND VPWR VPWR net1485 sky130_fd_sc_hd__dlygate4sd3_1
Xhold387 picorv32_core.cpuregs\[12\]\[12\] VGND VGND VPWR VPWR net1496 sky130_fd_sc_hd__dlygate4sd3_1
Xhold365 picorv32_core.cpuregs\[9\]\[2\] VGND VGND VPWR VPWR net1474 sky130_fd_sc_hd__dlygate4sd3_1
Xhold354 picorv32_core.cpuregs\[19\]\[11\] VGND VGND VPWR VPWR net1463 sky130_fd_sc_hd__dlygate4sd3_1
Xfanout834 _00008_ VGND VGND VPWR VPWR net834 sky130_fd_sc_hd__clkbuf_4
Xhold398 picorv32_core.cpuregs\[15\]\[24\] VGND VGND VPWR VPWR net1507 sky130_fd_sc_hd__dlygate4sd3_1
XFILLER_89_169 VGND VGND VPWR VPWR sky130_fd_sc_hd__fill_1
X_05058_ picorv32_core.mem_rdata_q\[27\] VGND VGND VPWR VPWR _01593_ sky130_fd_sc_hd__inv_2
Xfanout801 net802 VGND VGND VPWR VPWR net801 sky130_fd_sc_hd__buf_2
Xfanout823 net141 VGND VGND VPWR VPWR net823 sky130_fd_sc_hd__clkbuf_4
X_09935_ picorv32_core.reg_sh\[1\] picorv32_core.reg_sh\[0\] _01691_ _01693_ VGND
+ VGND VPWR VPWR _05036_ sky130_fd_sc_hd__a31o_1
Xfanout812 net168 VGND VGND VPWR VPWR net812 sky130_fd_sc_hd__buf_1
Xfanout867 net868 VGND VGND VPWR VPWR net867 sky130_fd_sc_hd__clkbuf_4
XFILLER_98_681 VGND VGND VPWR VPWR sky130_fd_sc_hd__fill_2
Xfanout856 net857 VGND VGND VPWR VPWR net856 sky130_fd_sc_hd__clkbuf_4
XFILLER_86_821 VGND VGND VPWR VPWR sky130_fd_sc_hd__fill_1
XFILLER_86_810 VGND VGND VPWR VPWR sky130_fd_sc_hd__fill_2
XTAP_TAPCELL_ROW_51_1044 VGND VPWR sky130_fd_sc_hd__tapvpwrvgnd_1
X_09866_ net1674 net468 net325 VGND VGND VPWR VPWR _01354_ sky130_fd_sc_hd__mux2_1
Xfanout845 net847 VGND VGND VPWR VPWR net845 sky130_fd_sc_hd__clkbuf_4
XFILLER_133_57 VPWR VGND VPWR VGND sky130_ef_sc_hd__decap_12
X_08817_ net212 net2020 net373 VGND VGND VPWR VPWR _00995_ sky130_fd_sc_hd__mux2_1
Xhold1010 picorv32_core.cpuregs\[9\]\[22\] VGND VGND VPWR VPWR net2119 sky130_fd_sc_hd__dlygate4sd3_1
Xhold1021 picorv32_core.cpuregs\[10\]\[17\] VGND VGND VPWR VPWR net2130 sky130_fd_sc_hd__dlygate4sd3_1
Xfanout889 net891 VGND VGND VPWR VPWR net889 sky130_fd_sc_hd__buf_4
XTAP_TAPCELL_ROW_5_379 VGND VPWR sky130_fd_sc_hd__tapvpwrvgnd_1
Xfanout878 net880 VGND VGND VPWR VPWR net878 sky130_fd_sc_hd__buf_4
Xhold1032 picorv32_core.cpuregs\[19\]\[10\] VGND VGND VPWR VPWR net2141 sky130_fd_sc_hd__dlygate4sd3_1
Xhold1054 picorv32_core.cpuregs\[15\]\[29\] VGND VGND VPWR VPWR net2163 sky130_fd_sc_hd__dlygate4sd3_1
Xhold1065 picorv32_core.cpuregs\[4\]\[22\] VGND VGND VPWR VPWR net2174 sky130_fd_sc_hd__dlygate4sd3_1
X_09797_ _01637_ _03535_ VGND VGND VPWR VPWR _04968_ sky130_fd_sc_hd__nor2_1
XFILLER_100_686 VGND VGND VPWR VPWR sky130_fd_sc_hd__fill_1
XFILLER_58_589 VGND VGND VPWR VPWR sky130_fd_sc_hd__decap_4
XFILLER_58_578 VGND VGND VPWR VPWR sky130_fd_sc_hd__decap_3
Xhold1076 picorv32_core.cpuregs\[18\]\[12\] VGND VGND VPWR VPWR net2185 sky130_fd_sc_hd__dlygate4sd3_1
Xhold1043 picorv32_core.cpuregs\[6\]\[7\] VGND VGND VPWR VPWR net2152 sky130_fd_sc_hd__dlygate4sd3_1
XFILLER_46_729 VGND VGND VPWR VPWR sky130_fd_sc_hd__decap_4
X_08748_ net1292 net221 net380 VGND VGND VPWR VPWR _00896_ sky130_fd_sc_hd__mux2_1
XPHY_EDGE_ROW_116_Left_258 VGND VGND VPWR VPWR sky130_fd_sc_hd__decap_3
XFILLER_73_559 VGND VGND VPWR VPWR sky130_fd_sc_hd__fill_1
Xhold1087 picorv32_core.instr_and VGND VGND VPWR VPWR net2196 sky130_fd_sc_hd__dlygate4sd3_1
Xhold1098 picorv32_core.cpuregs\[29\]\[13\] VGND VGND VPWR VPWR net2207 sky130_fd_sc_hd__dlygate4sd3_1
X_08679_ net234 net1392 net388 VGND VGND VPWR VPWR _00829_ sky130_fd_sc_hd__mux2_1
XTAP_TAPCELL_ROW_107_1855 VGND VPWR sky130_fd_sc_hd__tapvpwrvgnd_1
X_10710_ clknet_leaf_6_clk _00561_ VGND VGND VPWR VPWR net116 sky130_fd_sc_hd__dfxtp_1
XFILLER_41_423 VGND VGND VPWR VPWR sky130_fd_sc_hd__fill_1
XTAP_TAPCELL_ROW_24_654 VGND VPWR sky130_fd_sc_hd__tapvpwrvgnd_1
X_11690_ clknet_leaf_131_clk _01521_ VGND VGND VPWR VPWR picorv32_core.cpuregs\[27\]\[7\]
+ sky130_fd_sc_hd__dfxtp_1
XFILLER_139_300 VGND VGND VPWR VPWR sky130_fd_sc_hd__fill_2
X_10641_ clknet_leaf_0_clk _00495_ VGND VGND VPWR VPWR picorv32_core.cpuregs\[20\]\[9\]
+ sky130_fd_sc_hd__dfxtp_1
X_10572_ clknet_leaf_39_clk _00426_ VGND VGND VPWR VPWR picorv32_core.cpuregs\[25\]\[28\]
+ sky130_fd_sc_hd__dfxtp_1
XPHY_EDGE_ROW_125_Left_267 VGND VGND VPWR VPWR sky130_fd_sc_hd__decap_3
XFILLER_6_825 VGND VGND VPWR VPWR sky130_fd_sc_hd__decap_8
XFILLER_21_191 VGND VGND VPWR VPWR sky130_fd_sc_hd__fill_2
XFILLER_122_211 VGND VGND VPWR VPWR sky130_fd_sc_hd__decap_4
XFILLER_96_629 VGND VGND VPWR VPWR sky130_fd_sc_hd__fill_1
XFILLER_68_309 VGND VGND VPWR VPWR sky130_fd_sc_hd__decap_3
XFILLER_3_15 VPWR VGND VPWR VGND sky130_ef_sc_hd__decap_12
X_11124_ clknet_leaf_2_clk _00975_ VGND VGND VPWR VPWR picorv32_core.cpuregs\[8\]\[10\]
+ sky130_fd_sc_hd__dfxtp_1
XFILLER_110_428 VGND VGND VPWR VPWR sky130_fd_sc_hd__decap_3
XFILLER_49_512 VGND VGND VPWR VPWR sky130_fd_sc_hd__fill_1
X_11055_ clknet_leaf_138_clk _00906_ VGND VGND VPWR VPWR picorv32_core.cpuregs\[10\]\[5\]
+ sky130_fd_sc_hd__dfxtp_1
X_10006_ net2026 net502 net308 VGND VGND VPWR VPWR _01482_ sky130_fd_sc_hd__mux2_1
XPHY_EDGE_ROW_134_Left_276 VGND VGND VPWR VPWR sky130_fd_sc_hd__decap_3
XTAP_TAPCELL_ROW_69_1305 VGND VPWR sky130_fd_sc_hd__tapvpwrvgnd_1
XFILLER_83_61 VGND VGND VPWR VPWR sky130_fd_sc_hd__fill_1
X_10908_ clknet_leaf_84_clk _00759_ VGND VGND VPWR VPWR picorv32_core.mem_rdata_q\[18\]
+ sky130_fd_sc_hd__dfxtp_1
XFILLER_17_486 VGND VGND VPWR VPWR sky130_fd_sc_hd__fill_1
XTAP_TAPCELL_ROW_43_930 VGND VPWR sky130_fd_sc_hd__tapvpwrvgnd_1
X_10839_ clknet_leaf_21_clk _00690_ VGND VGND VPWR VPWR picorv32_core.cpuregs\[17\]\[16\]
+ sky130_fd_sc_hd__dfxtp_1
XFILLER_32_467 VGND VGND VPWR VPWR sky130_fd_sc_hd__fill_1
XFILLER_32_489 VGND VGND VPWR VPWR sky130_fd_sc_hd__decap_3
XPHY_EDGE_ROW_132_Right_132 VGND VGND VPWR VPWR sky130_fd_sc_hd__decap_3
X_06030_ _02178_ net571 net608 VGND VGND VPWR VPWR _02493_ sky130_fd_sc_hd__a21o_1
XFILLER_66_3 VGND VGND VPWR VPWR sky130_fd_sc_hd__fill_1
XFILLER_99_401 VGND VGND VPWR VPWR sky130_fd_sc_hd__decap_4
XFILLER_141_531 VGND VGND VPWR VPWR sky130_fd_sc_hd__fill_1
XTAP_TAPCELL_ROW_93_1656 VGND VPWR sky130_fd_sc_hd__tapvpwrvgnd_1
X_07981_ picorv32_core.cpuregs\[16\]\[26\] picorv32_core.cpuregs\[17\]\[26\] picorv32_core.cpuregs\[18\]\[26\]
+ picorv32_core.cpuregs\[19\]\[26\] net759 net726 VGND VGND VPWR VPWR _04060_ sky130_fd_sc_hd__mux4_1
X_09720_ picorv32_core.cpuregs\[24\]\[24\] picorv32_core.cpuregs\[25\]\[24\] picorv32_core.cpuregs\[26\]\[24\]
+ picorv32_core.cpuregs\[27\]\[24\] net895 net861 VGND VGND VPWR VPWR _04895_ sky130_fd_sc_hd__mux4_1
XFILLER_99_489 VGND VGND VPWR VPWR sky130_fd_sc_hd__fill_1
X_06932_ _02931_ _03135_ VGND VGND VPWR VPWR _03149_ sky130_fd_sc_hd__xor2_1
XFILLER_87_629 VGND VGND VPWR VPWR sky130_fd_sc_hd__decap_6
XTAP_TAPCELL_ROW_124_2100 VGND VPWR sky130_fd_sc_hd__tapvpwrvgnd_1
X_09651_ picorv32_core.cpuregs\[16\]\[21\] picorv32_core.cpuregs\[17\]\[21\] picorv32_core.cpuregs\[18\]\[21\]
+ picorv32_core.cpuregs\[19\]\[21\] net897 net863 VGND VGND VPWR VPWR _04829_ sky130_fd_sc_hd__mux4_1
X_06863_ _03068_ _03076_ _03083_ net664 VGND VGND VPWR VPWR _03085_ sky130_fd_sc_hd__a31o_1
XTAP_TAPCELL_ROW_2_338 VGND VPWR sky130_fd_sc_hd__tapvpwrvgnd_1
XTAP_TAPCELL_ROW_2_327 VGND VPWR sky130_fd_sc_hd__tapvpwrvgnd_1
XFILLER_103_27 VGND VGND VPWR VPWR sky130_fd_sc_hd__decap_4
X_08602_ net257 net2148 net396 VGND VGND VPWR VPWR _00725_ sky130_fd_sc_hd__mux2_1
X_09582_ net470 _04695_ _04760_ _04762_ VGND VGND VPWR VPWR _04763_ sky130_fd_sc_hd__a31o_1
XFILLER_55_559 VGND VGND VPWR VPWR sky130_fd_sc_hd__fill_1
X_06794_ net588 _03020_ _03021_ VGND VGND VPWR VPWR _03022_ sky130_fd_sc_hd__a21o_1
X_05814_ net813 net965 net567 _02291_ _02293_ VGND VGND VPWR VPWR picorv32_core.alu_out\[4\]
+ sky130_fd_sc_hd__a311o_1
X_08533_ net2065 net255 net404 VGND VGND VPWR VPWR _00660_ sky130_fd_sc_hd__mux2_1
X_05745_ net779 _01611_ _02228_ net781 VGND VGND VPWR VPWR _02229_ sky130_fd_sc_hd__o22a_1
XFILLER_70_507 VGND VGND VPWR VPWR sky130_fd_sc_hd__decap_8
X_05676_ net769 net191 VGND VGND VPWR VPWR _02160_ sky130_fd_sc_hd__or2_1
X_08464_ net674 picorv32_core.decoded_imm_j\[5\] _04283_ picorv32_core.mem_rdata_q\[25\]
+ net525 VGND VGND VPWR VPWR _04313_ sky130_fd_sc_hd__a221o_1
X_07415_ picorv32_core.cpuregs\[0\]\[31\] picorv32_core.cpuregs\[1\]\[31\] picorv32_core.cpuregs\[2\]\[31\]
+ picorv32_core.cpuregs\[3\]\[31\] net903 net871 VGND VGND VPWR VPWR _03555_ sky130_fd_sc_hd__mux4_1
X_08395_ _04271_ _04273_ _04270_ VGND VGND VPWR VPWR _04274_ sky130_fd_sc_hd__a21oi_1
XTAP_TAPCELL_ROW_102_1785 VGND VPWR sky130_fd_sc_hd__tapvpwrvgnd_1
X_07346_ _03440_ _03446_ _03482_ _03485_ VGND VGND VPWR VPWR _03486_ sky130_fd_sc_hd__o31a_1
XTAP_TAPCELL_ROW_21_613 VGND VPWR sky130_fd_sc_hd__tapvpwrvgnd_1
XTAP_TAPCELL_ROW_135_2262 VGND VPWR sky130_fd_sc_hd__tapvpwrvgnd_1
X_09016_ net214 net1236 net347 VGND VGND VPWR VPWR _01186_ sky130_fd_sc_hd__mux2_1
X_07277_ _03416_ VGND VGND VPWR VPWR _03417_ sky130_fd_sc_hd__inv_2
X_06228_ net688 _02657_ net619 VGND VGND VPWR VPWR _02658_ sky130_fd_sc_hd__a21o_1
XFILLER_132_531 VGND VGND VPWR VPWR sky130_fd_sc_hd__fill_1
Xhold140 picorv32_core.cpuregs\[27\]\[12\] VGND VGND VPWR VPWR net1249 sky130_fd_sc_hd__dlygate4sd3_1
Xhold151 picorv32_core.cpuregs\[24\]\[11\] VGND VGND VPWR VPWR net1260 sky130_fd_sc_hd__dlygate4sd3_1
X_06159_ picorv32_core.mem_rdata_q\[20\] net16 net518 VGND VGND VPWR VPWR _00761_
+ sky130_fd_sc_hd__mux2_1
Xhold162 picorv32_core.cpuregs\[22\]\[10\] VGND VGND VPWR VPWR net1271 sky130_fd_sc_hd__dlygate4sd3_1
Xhold173 picorv32_core.cpuregs\[15\]\[16\] VGND VGND VPWR VPWR net1282 sky130_fd_sc_hd__dlygate4sd3_1
Xhold184 picorv32_core.cpuregs\[15\]\[12\] VGND VGND VPWR VPWR net1293 sky130_fd_sc_hd__dlygate4sd3_1
Xhold195 picorv32_core.cpuregs\[27\]\[7\] VGND VGND VPWR VPWR net1304 sky130_fd_sc_hd__dlygate4sd3_1
X_09918_ net257 net2219 net322 VGND VGND VPWR VPWR _01402_ sky130_fd_sc_hd__mux2_1
Xfanout620 net622 VGND VGND VPWR VPWR net620 sky130_fd_sc_hd__buf_4
XFILLER_59_821 VGND VGND VPWR VPWR sky130_fd_sc_hd__fill_1
Xfanout642 net644 VGND VGND VPWR VPWR net642 sky130_fd_sc_hd__buf_4
Xfanout631 net641 VGND VGND VPWR VPWR net631 sky130_fd_sc_hd__buf_2
Xfanout664 _01592_ VGND VGND VPWR VPWR net664 sky130_fd_sc_hd__clkbuf_4
Xfanout675 net680 VGND VGND VPWR VPWR net675 sky130_fd_sc_hd__clkbuf_4
XFILLER_58_320 VGND VGND VPWR VPWR sky130_fd_sc_hd__fill_1
Xfanout653 net655 VGND VGND VPWR VPWR net653 sky130_fd_sc_hd__buf_2
X_09849_ picorv32_core.cpuregs\[4\]\[30\] picorv32_core.cpuregs\[5\]\[30\] picorv32_core.cpuregs\[6\]\[30\]
+ picorv32_core.cpuregs\[7\]\[30\] net901 net867 VGND VGND VPWR VPWR _05018_ sky130_fd_sc_hd__mux4_1
Xfanout686 _00004_ VGND VGND VPWR VPWR net686 sky130_fd_sc_hd__buf_4
Xfanout697 _00002_ VGND VGND VPWR VPWR net697 sky130_fd_sc_hd__buf_4
XFILLER_74_813 VGND VGND VPWR VPWR sky130_fd_sc_hd__fill_1
XFILLER_19_718 VGND VGND VPWR VPWR sky130_fd_sc_hd__decap_8
XFILLER_19_729 VPWR VGND VPWR VGND sky130_ef_sc_hd__decap_12
XFILLER_46_515 VGND VGND VPWR VPWR sky130_fd_sc_hd__fill_1
XFILLER_58_397 VGND VGND VPWR VPWR sky130_fd_sc_hd__fill_2
XTAP_TAPCELL_ROW_29_724 VGND VPWR sky130_fd_sc_hd__tapvpwrvgnd_1
XTAP_TAPCELL_ROW_64_1235 VGND VPWR sky130_fd_sc_hd__tapvpwrvgnd_1
X_11673_ clknet_leaf_32_clk _01504_ VGND VGND VPWR VPWR picorv32_core.cpuregs\[26\]\[22\]
+ sky130_fd_sc_hd__dfxtp_1
XFILLER_53_75 VGND VGND VPWR VPWR sky130_fd_sc_hd__fill_1
X_10624_ clknet_leaf_92_clk _00478_ VGND VGND VPWR VPWR picorv32_core.decoded_imm_j\[8\]
+ sky130_fd_sc_hd__dfxtp_1
XFILLER_41_297 VGND VGND VPWR VPWR sky130_fd_sc_hd__decap_4
X_10555_ clknet_leaf_12_clk _00409_ VGND VGND VPWR VPWR picorv32_core.cpuregs\[25\]\[11\]
+ sky130_fd_sc_hd__dfxtp_1
X_10486_ clknet_leaf_16_clk _00372_ VGND VGND VPWR VPWR net176 sky130_fd_sc_hd__dfxtp_1
XFILLER_6_699 VGND VGND VPWR VPWR sky130_fd_sc_hd__fill_1
XTAP_TAPCELL_ROW_75_1386 VGND VPWR sky130_fd_sc_hd__tapvpwrvgnd_1
X_11107_ clknet_leaf_71_clk _00958_ VGND VGND VPWR VPWR picorv32_core.cpuregs\[0\]\[25\]
+ sky130_fd_sc_hd__dfxtp_1
XFILLER_111_726 VGND VGND VPWR VPWR sky130_fd_sc_hd__fill_2
XTAP_TAPCELL_ROW_75_1397 VGND VPWR sky130_fd_sc_hd__tapvpwrvgnd_1
XFILLER_1_393 VPWR VGND VPWR VGND sky130_ef_sc_hd__decap_12
X_11038_ clknet_leaf_21_clk _00889_ VGND VGND VPWR VPWR picorv32_core.cpuregs\[11\]\[20\]
+ sky130_fd_sc_hd__dfxtp_1
XFILLER_77_662 VGND VGND VPWR VPWR sky130_fd_sc_hd__decap_4
XFILLER_65_813 VGND VGND VPWR VPWR sky130_fd_sc_hd__fill_1
XFILLER_65_835 VGND VGND VPWR VPWR sky130_fd_sc_hd__fill_2
XFILLER_92_698 VGND VGND VPWR VPWR sky130_fd_sc_hd__fill_2
X_05530_ picorv32_core.count_instr\[55\] net937 net941 picorv32_core.count_instr\[23\]
+ VGND VGND VPWR VPWR _02023_ sky130_fd_sc_hd__a22o_1
X_05461_ _01957_ _01958_ VGND VGND VPWR VPWR _01959_ sky130_fd_sc_hd__xor2_1
XFILLER_32_264 VGND VGND VPWR VPWR sky130_fd_sc_hd__fill_1
X_07200_ picorv32_core.count_cycle\[46\] _03354_ picorv32_core.count_cycle\[47\] VGND
+ VGND VPWR VPWR _03357_ sky130_fd_sc_hd__a21o_1
X_05392_ net8 _01818_ VGND VGND VPWR VPWR _01895_ sky130_fd_sc_hd__or2_1
X_08180_ picorv32_core.mem_rdata_q\[12\] _01594_ picorv32_core.mem_rdata_q\[14\] VGND
+ VGND VPWR VPWR _04195_ sky130_fd_sc_hd__or3_1
X_07131_ picorv32_core.count_cycle\[19\] picorv32_core.count_cycle\[20\] picorv32_core.count_cycle\[21\]
+ _03309_ VGND VGND VPWR VPWR _03314_ sky130_fd_sc_hd__and4_1
X_07062_ _03265_ _03266_ _03267_ VGND VGND VPWR VPWR _03268_ sky130_fd_sc_hd__a21o_1
Xoutput201 net201 VGND VGND VPWR VPWR pcpi_rs2[6] sky130_fd_sc_hd__buf_2
X_06013_ _02450_ _02461_ _02462_ VGND VGND VPWR VPWR _02477_ sky130_fd_sc_hd__o21a_1
XTAP_TAPCELL_ROW_7_408 VGND VPWR sky130_fd_sc_hd__tapvpwrvgnd_1
XTAP_TAPCELL_ROW_130_2192 VGND VPWR sky130_fd_sc_hd__tapvpwrvgnd_1
XFILLER_114_586 VGND VGND VPWR VPWR sky130_fd_sc_hd__fill_2
XFILLER_99_275 VGND VGND VPWR VPWR sky130_fd_sc_hd__decap_4
XFILLER_87_437 VGND VGND VPWR VPWR sky130_fd_sc_hd__decap_8
X_07964_ picorv32_core.cpuregs\[12\]\[25\] picorv32_core.cpuregs\[13\]\[25\] picorv32_core.cpuregs\[14\]\[25\]
+ picorv32_core.cpuregs\[15\]\[25\] net763 net730 VGND VGND VPWR VPWR _04044_ sky130_fd_sc_hd__mux4_1
XFILLER_114_15 VGND VGND VPWR VPWR sky130_fd_sc_hd__decap_4
X_09703_ picorv32_core.cpuregs\[0\]\[23\] picorv32_core.cpuregs\[1\]\[23\] picorv32_core.cpuregs\[2\]\[23\]
+ picorv32_core.cpuregs\[3\]\[23\] net899 net864 VGND VGND VPWR VPWR _04879_ sky130_fd_sc_hd__mux4_1
X_07895_ picorv32_core.cpuregs\[28\]\[21\] picorv32_core.cpuregs\[29\]\[21\] picorv32_core.cpuregs\[30\]\[21\]
+ picorv32_core.cpuregs\[31\]\[21\] net755 net722 VGND VGND VPWR VPWR _03979_ sky130_fd_sc_hd__mux4_1
X_06915_ _03120_ _03124_ _03132_ VGND VGND VPWR VPWR _03133_ sky130_fd_sc_hd__a21oi_1
XFILLER_110_781 VPWR VGND VPWR VGND sky130_ef_sc_hd__decap_12
X_09634_ picorv32_core.cpuregs\[4\]\[20\] picorv32_core.cpuregs\[5\]\[20\] picorv32_core.cpuregs\[6\]\[20\]
+ picorv32_core.cpuregs\[7\]\[20\] net895 net861 VGND VGND VPWR VPWR _04813_ sky130_fd_sc_hd__mux4_1
X_06846_ _03067_ _03068_ VGND VGND VPWR VPWR _03069_ sky130_fd_sc_hd__and2_1
XFILLER_28_559 VGND VGND VPWR VPWR sky130_fd_sc_hd__fill_1
XTAP_TAPCELL_ROW_104_1814 VGND VPWR sky130_fd_sc_hd__tapvpwrvgnd_1
X_09565_ picorv32_core.cpuregs\[20\]\[17\] picorv32_core.cpuregs\[21\]\[17\] picorv32_core.cpuregs\[22\]\[17\]
+ picorv32_core.cpuregs\[23\]\[17\] net889 net855 VGND VGND VPWR VPWR _04747_ sky130_fd_sc_hd__mux4_1
XFILLER_55_378 VGND VGND VPWR VPWR sky130_fd_sc_hd__fill_1
X_06777_ net663 _03004_ _03005_ VGND VGND VPWR VPWR _03006_ sky130_fd_sc_hd__or3_1
XFILLER_36_570 VGND VGND VPWR VPWR sky130_fd_sc_hd__fill_1
XFILLER_36_581 VGND VGND VPWR VPWR sky130_fd_sc_hd__fill_1
X_09496_ picorv32_core.cpuregs\[20\]\[14\] picorv32_core.cpuregs\[21\]\[14\] picorv32_core.cpuregs\[22\]\[14\]
+ picorv32_core.cpuregs\[23\]\[14\] net879 net846 VGND VGND VPWR VPWR _04681_ sky130_fd_sc_hd__mux4_1
X_08516_ net1717 net498 net403 VGND VGND VPWR VPWR _00643_ sky130_fd_sc_hd__mux2_1
XFILLER_24_743 VPWR VGND VPWR VGND sky130_ef_sc_hd__decap_12
X_05728_ net815 _01604_ _02140_ _02210_ _02211_ VGND VGND VPWR VPWR _02212_ sky130_fd_sc_hd__o221a_1
XFILLER_90_29 VGND VGND VPWR VPWR sky130_fd_sc_hd__decap_3
X_05659_ net783 net183 VGND VGND VPWR VPWR _02143_ sky130_fd_sc_hd__or2_1
X_08447_ net680 picorv32_core.decoded_imm_j\[13\] net615 picorv32_core.mem_rdata_q\[13\]
+ VGND VGND VPWR VPWR _04304_ sky130_fd_sc_hd__a22o_1
XFILLER_51_551 VGND VGND VPWR VPWR sky130_fd_sc_hd__fill_1
XFILLER_11_426 VGND VGND VPWR VPWR sky130_fd_sc_hd__decap_4
XTAP_TAPCELL_ROW_34_793 VGND VPWR sky130_fd_sc_hd__tapvpwrvgnd_1
X_08378_ net192 net581 net452 _04243_ VGND VGND VPWR VPWR _04264_ sky130_fd_sc_hd__a211o_1
XFILLER_99_27 VGND VGND VPWR VPWR sky130_fd_sc_hd__decap_4
X_07329_ _03456_ _03467_ _03468_ VGND VGND VPWR VPWR _03469_ sky130_fd_sc_hd__a21oi_1
X_10340_ clknet_leaf_76_clk _00259_ VGND VGND VPWR VPWR picorv32_core.reg_next_pc\[30\]
+ sky130_fd_sc_hd__dfxtp_1
X_10271_ clknet_leaf_79_clk _00190_ VGND VGND VPWR VPWR picorv32_core.count_instr\[55\]
+ sky130_fd_sc_hd__dfxtp_1
XFILLER_3_625 VGND VGND VPWR VPWR sky130_fd_sc_hd__decap_4
XFILLER_3_614 VGND VGND VPWR VPWR sky130_fd_sc_hd__fill_2
XTAP_TAPCELL_ROW_115_1976 VGND VPWR sky130_fd_sc_hd__tapvpwrvgnd_1
XFILLER_132_361 VGND VGND VPWR VPWR sky130_fd_sc_hd__decap_3
XFILLER_105_564 VGND VGND VPWR VPWR sky130_fd_sc_hd__fill_2
Xfanout450 _02687_ VGND VGND VPWR VPWR net450 sky130_fd_sc_hd__buf_1
Xfanout483 net484 VGND VGND VPWR VPWR net483 sky130_fd_sc_hd__clkbuf_4
Xfanout472 net473 VGND VGND VPWR VPWR net472 sky130_fd_sc_hd__buf_2
Xfanout461 net464 VGND VGND VPWR VPWR net461 sky130_fd_sc_hd__dlymetal6s2s_1
XFILLER_101_792 VGND VGND VPWR VPWR sky130_fd_sc_hd__decap_4
XFILLER_101_781 VGND VGND VPWR VPWR sky130_fd_sc_hd__decap_3
Xfanout494 _02677_ VGND VGND VPWR VPWR net494 sky130_fd_sc_hd__clkbuf_2
XFILLER_19_559 VGND VGND VPWR VPWR sky130_fd_sc_hd__fill_1
XFILLER_46_356 VGND VGND VPWR VPWR sky130_fd_sc_hd__fill_2
XFILLER_74_698 VGND VGND VPWR VPWR sky130_fd_sc_hd__fill_2
XFILLER_15_765 VPWR VGND VPWR VGND sky130_ef_sc_hd__decap_12
XFILLER_9_69 VPWR VGND VPWR VGND sky130_ef_sc_hd__decap_12
XFILLER_30_757 VPWR VGND VPWR VGND sky130_ef_sc_hd__decap_12
XFILLER_80_62 VGND VGND VPWR VPWR sky130_fd_sc_hd__decap_3
X_11656_ clknet_leaf_139_clk _01487_ VGND VGND VPWR VPWR picorv32_core.cpuregs\[26\]\[5\]
+ sky130_fd_sc_hd__dfxtp_1
X_10607_ clknet_leaf_97_clk _00461_ VGND VGND VPWR VPWR picorv32_core.instr_slt sky130_fd_sc_hd__dfxtp_1
XTAP_TAPCELL_ROW_12_476 VGND VPWR sky130_fd_sc_hd__tapvpwrvgnd_1
X_11587_ clknet_leaf_133_clk _01418_ VGND VGND VPWR VPWR picorv32_core.cpuregs\[23\]\[0\]
+ sky130_fd_sc_hd__dfxtp_1
X_10538_ clknet_leaf_61_clk picorv32_core.alu_out\[26\] VGND VGND VPWR VPWR picorv32_core.alu_out_q\[26\]
+ sky130_fd_sc_hd__dfxtp_1
XTAP_TAPCELL_ROW_77_1426 VGND VPWR sky130_fd_sc_hd__tapvpwrvgnd_1
XTAP_TAPCELL_ROW_77_1415 VGND VPWR sky130_fd_sc_hd__tapvpwrvgnd_1
Xhold909 picorv32_core.cpuregs\[8\]\[8\] VGND VGND VPWR VPWR net2018 sky130_fd_sc_hd__dlygate4sd3_1
XFILLER_6_474 VGND VGND VPWR VPWR sky130_fd_sc_hd__fill_2
XTAP_TAPCELL_ROW_90_1615 VGND VPWR sky130_fd_sc_hd__tapvpwrvgnd_1
XTAP_TAPCELL_ROW_90_1604 VGND VPWR sky130_fd_sc_hd__tapvpwrvgnd_1
X_10469_ clknet_leaf_105_clk _00356_ VGND VGND VPWR VPWR picorv32_core.mem_do_prefetch
+ sky130_fd_sc_hd__dfxtp_1
XFILLER_84_418 VGND VGND VPWR VPWR sky130_fd_sc_hd__fill_2
XFILLER_29_3 VPWR VGND VPWR VGND sky130_ef_sc_hd__decap_12
XFILLER_38_813 VPWR VGND VPWR VGND sky130_ef_sc_hd__decap_12
X_06700_ picorv32_core.reg_pc\[27\] net554 _02939_ net516 VGND VGND VPWR VPWR _00225_
+ sky130_fd_sc_hd__a22o_1
XTAP_TAPCELL_ROW_88_1577 VGND VPWR sky130_fd_sc_hd__tapvpwrvgnd_1
X_07680_ net627 _03775_ VGND VGND VPWR VPWR _03776_ sky130_fd_sc_hd__or2_1
X_06631_ picorv32_core.count_instr\[59\] _02900_ net978 VGND VGND VPWR VPWR _02902_
+ sky130_fd_sc_hd__a21oi_1
XFILLER_92_473 VGND VGND VPWR VPWR sky130_fd_sc_hd__decap_3
XTAP_TAPCELL_ROW_88_1588 VGND VPWR sky130_fd_sc_hd__tapvpwrvgnd_1
XFILLER_80_624 VGND VGND VPWR VPWR sky130_fd_sc_hd__decap_4
XFILLER_25_518 VGND VGND VPWR VPWR sky130_fd_sc_hd__decap_3
XFILLER_64_197 VGND VGND VPWR VPWR sky130_fd_sc_hd__fill_2
X_09350_ _04537_ _04540_ _04541_ net825 net648 VGND VGND VPWR VPWR _04542_ sky130_fd_sc_hd__a221o_1
X_06562_ picorv32_core.count_instr\[34\] picorv32_core.count_instr\[33\] _02854_ VGND
+ VGND VPWR VPWR _02858_ sky130_fd_sc_hd__and3_1
X_05513_ _02005_ _02006_ VGND VGND VPWR VPWR _02007_ sky130_fd_sc_hd__nand2_1
X_09281_ net827 _04471_ _04473_ _04475_ VGND VGND VPWR VPWR _04476_ sky130_fd_sc_hd__o22a_1
X_08301_ net1179 _00751_ net437 VGND VGND VPWR VPWR _00521_ sky130_fd_sc_hd__mux2_1
X_06493_ picorv32_core.count_instr\[9\] picorv32_core.count_instr\[8\] _02810_ VGND
+ VGND VPWR VPWR _02814_ sky130_fd_sc_hd__and3_1
X_08232_ _04211_ _04218_ net2294 net523 VGND VGND VPWR VPWR _00469_ sky130_fd_sc_hd__a2bb2o_1
XTAP_TAPCELL_ROW_119_2032 VGND VPWR sky130_fd_sc_hd__tapvpwrvgnd_1
X_05444_ picorv32_core.reg_pc\[17\] picorv32_core.decoded_imm\[17\] VGND VGND VPWR
+ VPWR _01943_ sky130_fd_sc_hd__and2_1
XTAP_TAPCELL_ROW_31_752 VGND VPWR sky130_fd_sc_hd__tapvpwrvgnd_1
X_05375_ picorv32_core.reg_pc\[12\] picorv32_core.decoded_imm\[12\] VGND VGND VPWR
+ VPWR _01879_ sky130_fd_sc_hd__or2_1
X_08163_ net930 _01594_ net929 VGND VGND VPWR VPWR _04187_ sky130_fd_sc_hd__and3_1
XFILLER_20_267 VGND VGND VPWR VPWR sky130_fd_sc_hd__decap_4
XTAP_TAPCELL_ROW_132_2221 VGND VPWR sky130_fd_sc_hd__tapvpwrvgnd_1
XFILLER_109_15 VPWR VGND VPWR VGND sky130_ef_sc_hd__decap_12
X_07114_ _03303_ net993 _03302_ VGND VGND VPWR VPWR _00275_ sky130_fd_sc_hd__and3b_1
X_08094_ picorv32_core.cpu_state\[2\] net915 net908 _04166_ VGND VGND VPWR VPWR _04167_
+ sky130_fd_sc_hd__or4b_1
Xclkload71 clknet_leaf_42_clk VGND VGND VPWR VPWR clkload71/Y sky130_fd_sc_hd__inv_6
Xclkload60 clknet_leaf_38_clk VGND VGND VPWR VPWR clkload60/Y sky130_fd_sc_hd__inv_6
X_07045_ _03251_ _03252_ net990 VGND VGND VPWR VPWR _00257_ sky130_fd_sc_hd__o21a_1
Xclkload82 clknet_leaf_114_clk VGND VGND VPWR VPWR clkload82/Y sky130_fd_sc_hd__clkinvlp_4
Xclkload93 clknet_leaf_122_clk VGND VGND VPWR VPWR clkload93/Y sky130_fd_sc_hd__inv_6
XFILLER_133_169 VGND VGND VPWR VPWR sky130_fd_sc_hd__fill_1
XFILLER_88_724 VGND VGND VPWR VPWR sky130_fd_sc_hd__fill_1
XFILLER_0_617 VPWR VGND VPWR VGND sky130_ef_sc_hd__decap_12
XFILLER_114_394 VGND VGND VPWR VPWR sky130_fd_sc_hd__fill_2
XFILLER_88_757 VPWR VGND VPWR VGND sky130_ef_sc_hd__decap_12
XFILLER_87_234 VGND VGND VPWR VPWR sky130_fd_sc_hd__decap_4
X_08996_ net300 net2037 net344 VGND VGND VPWR VPWR _01166_ sky130_fd_sc_hd__mux2_1
XFILLER_125_69 VGND VGND VPWR VPWR sky130_fd_sc_hd__decap_3
X_07947_ picorv32_core.cpuregs\[16\]\[24\] picorv32_core.cpuregs\[17\]\[24\] picorv32_core.cpuregs\[18\]\[24\]
+ picorv32_core.cpuregs\[19\]\[24\] net752 net719 VGND VGND VPWR VPWR _04028_ sky130_fd_sc_hd__mux4_1
XFILLER_102_589 VGND VGND VPWR VPWR sky130_fd_sc_hd__fill_1
XTAP_TAPCELL_ROW_110_1895 VGND VPWR sky130_fd_sc_hd__tapvpwrvgnd_1
XFILLER_96_790 VGND VGND VPWR VPWR sky130_fd_sc_hd__fill_2
X_07878_ net636 _03962_ VGND VGND VPWR VPWR _03963_ sky130_fd_sc_hd__or2_1
XFILLER_141_57 VPWR VGND VPWR VGND sky130_ef_sc_hd__decap_12
X_09617_ _04790_ _04791_ _04794_ _04795_ net657 net645 VGND VGND VPWR VPWR _04797_
+ sky130_fd_sc_hd__mux4_1
X_06829_ net675 _03051_ _03052_ _03053_ VGND VGND VPWR VPWR _03054_ sky130_fd_sc_hd__a22o_1
XFILLER_56_698 VGND VGND VPWR VPWR sky130_fd_sc_hd__fill_2
XTAP_TAPCELL_ROW_48_1005 VGND VPWR sky130_fd_sc_hd__tapvpwrvgnd_1
XTAP_TAPCELL_ROW_39_874 VGND VPWR sky130_fd_sc_hd__tapvpwrvgnd_1
X_09548_ _04727_ _04728_ net657 VGND VGND VPWR VPWR _04731_ sky130_fd_sc_hd__mux2_1
XFILLER_55_197 VGND VGND VPWR VPWR sky130_fd_sc_hd__decap_3
XFILLER_24_540 VGND VGND VPWR VPWR sky130_fd_sc_hd__decap_8
XFILLER_34_33 VGND VGND VPWR VPWR sky130_fd_sc_hd__fill_1
X_11510_ clknet_leaf_57_clk _01346_ VGND VGND VPWR VPWR net160 sky130_fd_sc_hd__dfxtp_1
X_09479_ picorv32_core.cpuregs\[28\]\[13\] picorv32_core.cpuregs\[29\]\[13\] picorv32_core.cpuregs\[30\]\[13\]
+ picorv32_core.cpuregs\[31\]\[13\] net881 net848 VGND VGND VPWR VPWR _04665_ sky130_fd_sc_hd__mux4_1
XFILLER_51_381 VGND VGND VPWR VPWR sky130_fd_sc_hd__decap_8
Xclkbuf_leaf_144_clk clknet_4_0_0_clk VGND VGND VPWR VPWR clknet_leaf_144_clk sky130_fd_sc_hd__clkbuf_8
XFILLER_133_3 VPWR VGND VPWR VGND sky130_ef_sc_hd__decap_12
XFILLER_7_205 VGND VGND VPWR VPWR sky130_fd_sc_hd__decap_8
XFILLER_12_757 VPWR VGND VPWR VGND sky130_ef_sc_hd__decap_12
X_11441_ clknet_leaf_34_clk _01277_ VGND VGND VPWR VPWR picorv32_core.cpuregs\[1\]\[24\]
+ sky130_fd_sc_hd__dfxtp_1
X_11372_ clknet_leaf_35_clk _01213_ VGND VGND VPWR VPWR picorv32_core.cpuregs\[18\]\[24\]
+ sky130_fd_sc_hd__dfxtp_1
X_10323_ clknet_leaf_91_clk _00242_ VGND VGND VPWR VPWR picorv32_core.reg_next_pc\[13\]
+ sky130_fd_sc_hd__dfxtp_1
XTAP_TAPCELL_ROW_59_1156 VGND VPWR sky130_fd_sc_hd__tapvpwrvgnd_1
XTAP_TAPCELL_ROW_59_1167 VGND VPWR sky130_fd_sc_hd__tapvpwrvgnd_1
XFILLER_133_681 VGND VGND VPWR VPWR sky130_fd_sc_hd__fill_2
XFILLER_121_821 VGND VGND VPWR VPWR sky130_fd_sc_hd__decap_8
XFILLER_112_309 VGND VGND VPWR VPWR sky130_fd_sc_hd__fill_1
XFILLER_105_361 VGND VGND VPWR VPWR sky130_fd_sc_hd__decap_6
X_10254_ clknet_leaf_102_clk _00173_ VGND VGND VPWR VPWR picorv32_core.count_instr\[38\]
+ sky130_fd_sc_hd__dfxtp_1
XFILLER_121_832 VGND VGND VPWR VPWR sky130_fd_sc_hd__fill_1
XFILLER_79_768 VGND VGND VPWR VPWR sky130_fd_sc_hd__decap_8
XTAP_TAPCELL_ROW_72_1356 VGND VPWR sky130_fd_sc_hd__tapvpwrvgnd_1
XTAP_TAPCELL_ROW_72_1345 VGND VPWR sky130_fd_sc_hd__tapvpwrvgnd_1
X_10185_ clknet_leaf_114_clk _00104_ VGND VGND VPWR VPWR picorv32_core.cpuregs\[9\]\[1\]
+ sky130_fd_sc_hd__dfxtp_1
XFILLER_66_407 VPWR VGND VPWR VGND sky130_ef_sc_hd__decap_12
XFILLER_94_749 VGND VGND VPWR VPWR sky130_fd_sc_hd__decap_6
XFILLER_75_40 VGND VGND VPWR VPWR sky130_fd_sc_hd__fill_1
Xfanout280 net281 VGND VGND VPWR VPWR net280 sky130_fd_sc_hd__buf_2
Xfanout291 net293 VGND VGND VPWR VPWR net291 sky130_fd_sc_hd__dlymetal6s2s_1
XFILLER_74_451 VPWR VGND VPWR VGND sky130_ef_sc_hd__decap_12
XFILLER_50_808 VGND VGND VPWR VPWR sky130_fd_sc_hd__decap_4
XTAP_TAPCELL_ROW_17_546 VGND VPWR sky130_fd_sc_hd__tapvpwrvgnd_1
XTAP_TAPCELL_ROW_17_557 VGND VPWR sky130_fd_sc_hd__tapvpwrvgnd_1
Xclkbuf_leaf_135_clk clknet_4_2_0_clk VGND VGND VPWR VPWR clknet_leaf_135_clk sky130_fd_sc_hd__clkbuf_8
X_11708_ clknet_leaf_70_clk _01539_ VGND VGND VPWR VPWR picorv32_core.cpuregs\[27\]\[25\]
+ sky130_fd_sc_hd__dfxtp_1
X_11639_ clknet_leaf_50_clk _01470_ VGND VGND VPWR VPWR picorv32_core.cpuregs\[28\]\[20\]
+ sky130_fd_sc_hd__dfxtp_1
XFILLER_30_587 VGND VGND VPWR VPWR sky130_fd_sc_hd__fill_1
X_05160_ net984 picorv32_core.instr_sh picorv32_core.cpu_state\[5\] _01632_ _01685_
+ VGND VGND VPWR VPWR _01686_ sky130_fd_sc_hd__a41o_1
Xhold717 picorv32_core.cpuregs\[21\]\[27\] VGND VGND VPWR VPWR net1826 sky130_fd_sc_hd__dlygate4sd3_1
Xhold706 picorv32_core.cpuregs\[17\]\[29\] VGND VGND VPWR VPWR net1815 sky130_fd_sc_hd__dlygate4sd3_1
Xhold728 picorv32_core.cpuregs\[10\]\[6\] VGND VGND VPWR VPWR net1837 sky130_fd_sc_hd__dlygate4sd3_1
XFILLER_7_783 VGND VGND VPWR VPWR sky130_fd_sc_hd__fill_1
Xhold739 picorv32_core.cpuregs\[24\]\[21\] VGND VGND VPWR VPWR net1848 sky130_fd_sc_hd__dlygate4sd3_1
X_05091_ net675 net616 VGND VGND VPWR VPWR _00031_ sky130_fd_sc_hd__or2_1
X_08850_ net1528 net215 net368 VGND VGND VPWR VPWR _01026_ sky130_fd_sc_hd__mux2_1
XFILLER_97_521 VGND VGND VPWR VPWR sky130_fd_sc_hd__fill_2
XFILLER_69_223 VGND VGND VPWR VPWR sky130_fd_sc_hd__fill_1
X_07801_ picorv32_core.cpuregs\[24\]\[16\] picorv32_core.cpuregs\[25\]\[16\] picorv32_core.cpuregs\[26\]\[16\]
+ picorv32_core.cpuregs\[27\]\[16\] net751 net718 VGND VGND VPWR VPWR _03890_ sky130_fd_sc_hd__mux4_1
X_08781_ net221 net2081 net376 VGND VGND VPWR VPWR _00928_ sky130_fd_sc_hd__mux2_1
X_05993_ net956 net181 net182 _02429_ VGND VGND VPWR VPWR _02458_ sky130_fd_sc_hd__or4_1
XFILLER_65_440 VGND VGND VPWR VPWR sky130_fd_sc_hd__decap_8
X_07732_ picorv32_core.cpuregs\[24\]\[12\] picorv32_core.cpuregs\[25\]\[12\] picorv32_core.cpuregs\[26\]\[12\]
+ picorv32_core.cpuregs\[27\]\[12\] net738 net705 VGND VGND VPWR VPWR _03825_ sky130_fd_sc_hd__mux4_1
XFILLER_38_643 VGND VGND VPWR VPWR sky130_fd_sc_hd__fill_1
XFILLER_52_101 VGND VGND VPWR VPWR sky130_fd_sc_hd__fill_1
XFILLER_1_81 VPWR VGND VPWR VGND sky130_ef_sc_hd__decap_12
X_07663_ net694 _03754_ net682 VGND VGND VPWR VPWR _03760_ sky130_fd_sc_hd__o21a_1
X_06614_ _02887_ _02890_ VGND VGND VPWR VPWR _02891_ sky130_fd_sc_hd__and2_1
XFILLER_80_421 VGND VGND VPWR VPWR sky130_fd_sc_hd__decap_8
X_09402_ net804 net541 _04525_ net469 VGND VGND VPWR VPWR _04591_ sky130_fd_sc_hd__o211a_1
XTAP_TAPCELL_ROW_36_822 VGND VPWR sky130_fd_sc_hd__tapvpwrvgnd_1
XTAP_TAPCELL_ROW_36_833 VGND VPWR sky130_fd_sc_hd__tapvpwrvgnd_1
X_09333_ net799 net548 VGND VGND VPWR VPWR _04525_ sky130_fd_sc_hd__or2_1
X_07594_ _01682_ _02660_ VGND VGND VPWR VPWR _03695_ sky130_fd_sc_hd__nand2_1
XFILLER_40_307 VGND VGND VPWR VPWR sky130_fd_sc_hd__fill_1
X_06545_ picorv32_core.count_instr\[27\] _02844_ picorv32_core.count_instr\[28\] VGND
+ VGND VPWR VPWR _02847_ sky130_fd_sc_hd__a21o_1
Xclkbuf_leaf_126_clk clknet_4_9_0_clk VGND VGND VPWR VPWR clknet_leaf_126_clk sky130_fd_sc_hd__clkbuf_8
XFILLER_33_370 VGND VGND VPWR VPWR sky130_fd_sc_hd__fill_2
XFILLER_139_729 VPWR VGND VPWR VGND sky130_ef_sc_hd__decap_12
XFILLER_139_718 VGND VGND VPWR VPWR sky130_fd_sc_hd__decap_8
X_09264_ net886 picorv32_core.cpuregs\[23\]\[4\] net851 VGND VGND VPWR VPWR _04459_
+ sky130_fd_sc_hd__a21bo_1
X_06476_ picorv32_core.count_instr\[2\] _02801_ picorv32_core.count_instr\[3\] VGND
+ VGND VPWR VPWR _02803_ sky130_fd_sc_hd__a21o_1
X_05427_ _01911_ _01916_ VGND VGND VPWR VPWR _01927_ sky130_fd_sc_hd__nor2_1
X_08215_ net1595 net477 _04194_ _04208_ VGND VGND VPWR VPWR _00461_ sky130_fd_sc_hd__a22o_1
X_09195_ _04390_ _04391_ _04389_ _04392_ net837 net853 VGND VGND VPWR VPWR _04393_
+ sky130_fd_sc_hd__mux4_1
X_08146_ _04174_ _00745_ _00746_ VGND VGND VPWR VPWR _04175_ sky130_fd_sc_hd__and3_1
XFILLER_5_709 VPWR VGND VPWR VGND sky130_ef_sc_hd__decap_12
Xpicorv32_axi_1105 VGND VGND VPWR VPWR picorv32_axi_1105/HI trace_data[32] sky130_fd_sc_hd__conb_1
XFILLER_107_615 VGND VGND VPWR VPWR sky130_fd_sc_hd__fill_1
X_05358_ _01861_ _01862_ VGND VGND VPWR VPWR _01863_ sky130_fd_sc_hd__nand2_1
X_08077_ picorv32_core.cpuregs\[0\]\[31\] picorv32_core.cpuregs\[1\]\[31\] picorv32_core.cpuregs\[2\]\[31\]
+ picorv32_core.cpuregs\[3\]\[31\] net762 net729 VGND VGND VPWR VPWR _04151_ sky130_fd_sc_hd__mux4_1
X_05289_ net18 _01717_ _01722_ net32 _01798_ VGND VGND VPWR VPWR _01799_ sky130_fd_sc_hd__a221o_1
XFILLER_115_670 VGND VGND VPWR VPWR sky130_fd_sc_hd__fill_2
XTAP_TAPCELL_ROW_112_1935 VGND VPWR sky130_fd_sc_hd__tapvpwrvgnd_1
XTAP_TAPCELL_ROW_112_1924 VGND VPWR sky130_fd_sc_hd__tapvpwrvgnd_1
X_07028_ _02938_ _03219_ _02939_ VGND VGND VPWR VPWR _03237_ sky130_fd_sc_hd__a21oi_1
XFILLER_88_543 VGND VGND VPWR VPWR sky130_fd_sc_hd__fill_1
Xhold11 picorv32_core.cpuregs\[0\]\[25\] VGND VGND VPWR VPWR net1120 sky130_fd_sc_hd__dlygate4sd3_1
Xhold22 picorv32_core.cpuregs\[0\]\[28\] VGND VGND VPWR VPWR net1131 sky130_fd_sc_hd__dlygate4sd3_1
XFILLER_102_342 VGND VGND VPWR VPWR sky130_fd_sc_hd__decap_8
XTAP_TAPCELL_ROW_54_1086 VGND VPWR sky130_fd_sc_hd__tapvpwrvgnd_1
XFILLER_48_418 VGND VGND VPWR VPWR sky130_fd_sc_hd__fill_2
X_08979_ net1228 net227 net351 VGND VGND VPWR VPWR _01151_ sky130_fd_sc_hd__mux2_1
XFILLER_102_386 VGND VGND VPWR VPWR sky130_fd_sc_hd__fill_1
XFILLER_88_587 VGND VGND VPWR VPWR sky130_fd_sc_hd__fill_1
Xhold44 net112 VGND VGND VPWR VPWR net1153 sky130_fd_sc_hd__dlygate4sd3_1
Xhold55 picorv32_core.instr_lbu VGND VGND VPWR VPWR net1164 sky130_fd_sc_hd__dlygate4sd3_1
XFILLER_29_55 VGND VGND VPWR VPWR sky130_fd_sc_hd__fill_1
Xhold33 picorv32_core.cpuregs\[0\]\[10\] VGND VGND VPWR VPWR net1142 sky130_fd_sc_hd__dlygate4sd3_1
Xhold99 picorv32_core.cpuregs\[24\]\[24\] VGND VGND VPWR VPWR net1208 sky130_fd_sc_hd__dlygate4sd3_1
Xhold66 net133 VGND VGND VPWR VPWR net1175 sky130_fd_sc_hd__dlygate4sd3_1
Xhold88 picorv32_core.cpuregs\[24\]\[3\] VGND VGND VPWR VPWR net1197 sky130_fd_sc_hd__dlygate4sd3_1
Xhold77 picorv32_core.decoded_rd\[1\] VGND VGND VPWR VPWR net1186 sky130_fd_sc_hd__dlygate4sd3_1
X_10941_ clknet_leaf_30_clk _00792_ VGND VGND VPWR VPWR picorv32_core.cpuregs\[19\]\[19\]
+ sky130_fd_sc_hd__dfxtp_1
XFILLER_83_281 VGND VGND VPWR VPWR sky130_fd_sc_hd__fill_1
XFILLER_28_197 VGND VGND VPWR VPWR sky130_fd_sc_hd__fill_2
X_10872_ clknet_leaf_20_clk _00723_ VGND VGND VPWR VPWR picorv32_core.cpuregs\[16\]\[16\]
+ sky130_fd_sc_hd__dfxtp_1
XFILLER_71_476 VPWR VGND VPWR VGND sky130_ef_sc_hd__decap_12
XFILLER_71_498 VGND VGND VPWR VPWR sky130_fd_sc_hd__decap_6
Xclkbuf_leaf_117_clk clknet_4_8_0_clk VGND VGND VPWR VPWR clknet_leaf_117_clk sky130_fd_sc_hd__clkbuf_8
XTAP_TAPCELL_ROW_14_505 VGND VPWR sky130_fd_sc_hd__tapvpwrvgnd_1
XFILLER_24_381 VGND VGND VPWR VPWR sky130_fd_sc_hd__fill_1
X_11424_ clknet_leaf_140_clk _01260_ VGND VGND VPWR VPWR picorv32_core.cpuregs\[1\]\[7\]
+ sky130_fd_sc_hd__dfxtp_1
XANTENNA_8 _02747_ VGND VGND VPWR VPWR sky130_fd_sc_hd__diode_2
XFILLER_6_26 VGND VGND VPWR VPWR sky130_fd_sc_hd__fill_2
X_11355_ clknet_leaf_130_clk _01196_ VGND VGND VPWR VPWR picorv32_core.cpuregs\[18\]\[7\]
+ sky130_fd_sc_hd__dfxtp_1
X_10306_ clknet_leaf_69_clk _00225_ VGND VGND VPWR VPWR picorv32_core.reg_pc\[27\]
+ sky130_fd_sc_hd__dfxtp_1
X_11286_ clknet_leaf_144_clk _01134_ VGND VGND VPWR VPWR picorv32_core.cpuregs\[3\]\[9\]
+ sky130_fd_sc_hd__dfxtp_1
X_10237_ clknet_leaf_79_clk _00156_ VGND VGND VPWR VPWR picorv32_core.count_instr\[21\]
+ sky130_fd_sc_hd__dfxtp_1
XFILLER_121_662 VGND VGND VPWR VPWR sky130_fd_sc_hd__fill_1
XFILLER_121_673 VGND VGND VPWR VPWR sky130_fd_sc_hd__fill_2
X_10168_ clknet_leaf_22_clk _00087_ VGND VGND VPWR VPWR picorv32_core.cpuregs\[21\]\[16\]
+ sky130_fd_sc_hd__dfxtp_1
XFILLER_86_61 VGND VGND VPWR VPWR sky130_fd_sc_hd__decap_3
X_10099_ net1123 VGND VGND VPWR VPWR _00949_ sky130_fd_sc_hd__clkbuf_1
XFILLER_66_248 VGND VGND VPWR VPWR sky130_fd_sc_hd__decap_4
XTAP_TAPCELL_ROW_85_1536 VGND VPWR sky130_fd_sc_hd__tapvpwrvgnd_1
XFILLER_62_443 VGND VGND VPWR VPWR sky130_fd_sc_hd__decap_4
XFILLER_50_616 VPWR VGND VPWR VGND sky130_ef_sc_hd__decap_12
XFILLER_34_167 VGND VGND VPWR VPWR sky130_fd_sc_hd__fill_2
XFILLER_96_3 VPWR VGND VPWR VGND sky130_ef_sc_hd__decap_12
Xclkbuf_leaf_108_clk clknet_4_10_0_clk VGND VGND VPWR VPWR clknet_leaf_108_clk sky130_fd_sc_hd__clkbuf_8
X_06330_ picorv32_core.reg_pc\[18\] _02734_ VGND VGND VPWR VPWR _02738_ sky130_fd_sc_hd__xor2_1
X_06261_ net1512 net465 net434 VGND VGND VPWR VPWR _00043_ sky130_fd_sc_hd__mux2_1
X_08000_ picorv32_core.cpuregs\[28\]\[27\] picorv32_core.cpuregs\[29\]\[27\] picorv32_core.cpuregs\[30\]\[27\]
+ picorv32_core.cpuregs\[31\]\[27\] net756 net723 VGND VGND VPWR VPWR _04078_ sky130_fd_sc_hd__mux4_1
X_05212_ picorv32_core.count_cycle\[0\] net599 VGND VGND VPWR VPWR _01728_ sky130_fd_sc_hd__or2_1
XFILLER_129_773 VGND VGND VPWR VPWR sky130_fd_sc_hd__decap_8
X_06192_ picorv32_core.reg_sh\[3\] picorv32_core.reg_sh\[2\] VGND VGND VPWR VPWR _02623_
+ sky130_fd_sc_hd__nand2_1
Xhold525 picorv32_core.cpuregs\[13\]\[31\] VGND VGND VPWR VPWR net1634 sky130_fd_sc_hd__dlygate4sd3_1
Xhold503 picorv32_core.cpuregs\[1\]\[22\] VGND VGND VPWR VPWR net1612 sky130_fd_sc_hd__dlygate4sd3_1
Xhold514 picorv32_core.cpuregs\[5\]\[4\] VGND VGND VPWR VPWR net1623 sky130_fd_sc_hd__dlygate4sd3_1
Xhold536 picorv32_core.cpuregs\[17\]\[10\] VGND VGND VPWR VPWR net1645 sky130_fd_sc_hd__dlygate4sd3_1
X_05143_ net980 _01672_ _00038_ _01666_ VGND VGND VPWR VPWR _00010_ sky130_fd_sc_hd__a211o_1
XFILLER_131_415 VGND VGND VPWR VPWR sky130_fd_sc_hd__decap_3
Xhold569 picorv32_core.cpuregs\[20\]\[21\] VGND VGND VPWR VPWR net1678 sky130_fd_sc_hd__dlygate4sd3_1
XTAP_TAPCELL_ROW_96_1698 VGND VPWR sky130_fd_sc_hd__tapvpwrvgnd_1
X_05074_ net181 VGND VGND VPWR VPWR _01609_ sky130_fd_sc_hd__inv_2
Xhold558 picorv32_core.cpuregs\[28\]\[12\] VGND VGND VPWR VPWR net1667 sky130_fd_sc_hd__dlygate4sd3_1
Xhold547 picorv32_core.cpuregs\[3\]\[1\] VGND VGND VPWR VPWR net1656 sky130_fd_sc_hd__dlygate4sd3_1
X_09951_ net1421 net291 net316 VGND VGND VPWR VPWR _01429_ sky130_fd_sc_hd__mux2_1
X_08902_ net270 net1642 net358 VGND VGND VPWR VPWR _01076_ sky130_fd_sc_hd__mux2_1
X_09882_ net1387 net247 net327 VGND VGND VPWR VPWR _01370_ sky130_fd_sc_hd__mux2_1
XFILLER_97_362 VGND VGND VPWR VPWR sky130_fd_sc_hd__fill_2
Xhold1214 picorv32_core.count_cycle\[28\] VGND VGND VPWR VPWR net2323 sky130_fd_sc_hd__dlygate4sd3_1
Xhold1225 picorv32_core.count_cycle\[22\] VGND VGND VPWR VPWR net2334 sky130_fd_sc_hd__dlygate4sd3_1
XFILLER_85_535 VGND VGND VPWR VPWR sky130_fd_sc_hd__decap_8
X_08833_ net1486 net286 net366 VGND VGND VPWR VPWR _01009_ sky130_fd_sc_hd__mux2_1
XPHY_EDGE_ROW_29_Left_171 VGND VGND VPWR VPWR sky130_fd_sc_hd__decap_3
Xhold1203 picorv32_core.mem_state\[1\] VGND VGND VPWR VPWR net2312 sky130_fd_sc_hd__dlygate4sd3_1
XTAP_TAPCELL_ROW_127_2153 VGND VPWR sky130_fd_sc_hd__tapvpwrvgnd_1
XTAP_TAPCELL_ROW_127_2142 VGND VPWR sky130_fd_sc_hd__tapvpwrvgnd_1
XFILLER_85_546 VPWR VGND VPWR VGND sky130_ef_sc_hd__decap_12
X_05976_ _02439_ _02442_ VGND VGND VPWR VPWR _02443_ sky130_fd_sc_hd__nand2_1
Xhold1258 picorv32_core.is_lb_lh_lw_lbu_lhu VGND VGND VPWR VPWR net2367 sky130_fd_sc_hd__dlygate4sd3_1
Xhold1247 picorv32_core.count_instr\[5\] VGND VGND VPWR VPWR net2356 sky130_fd_sc_hd__dlygate4sd3_1
X_08764_ net296 net1971 net374 VGND VGND VPWR VPWR _00911_ sky130_fd_sc_hd__mux2_1
Xhold1236 picorv32_core.count_instr\[36\] VGND VGND VPWR VPWR net2345 sky130_fd_sc_hd__dlygate4sd3_1
XFILLER_122_15 VPWR VGND VPWR VGND sky130_ef_sc_hd__decap_12
XFILLER_66_771 VGND VGND VPWR VPWR sky130_fd_sc_hd__fill_2
X_07715_ picorv32_core.cpuregs\[0\]\[11\] picorv32_core.cpuregs\[1\]\[11\] picorv32_core.cpuregs\[2\]\[11\]
+ picorv32_core.cpuregs\[3\]\[11\] net736 net703 VGND VGND VPWR VPWR _03809_ sky130_fd_sc_hd__mux4_1
XTAP_TAPCELL_ROW_140_2342 VGND VPWR sky130_fd_sc_hd__tapvpwrvgnd_1
XTAP_TAPCELL_ROW_140_2331 VGND VPWR sky130_fd_sc_hd__tapvpwrvgnd_1
X_08695_ net1649 net431 net382 VGND VGND VPWR VPWR _00844_ sky130_fd_sc_hd__mux2_1
XFILLER_81_785 VPWR VGND VPWR VGND sky130_ef_sc_hd__decap_12
XTAP_TAPCELL_ROW_0_288 VGND VPWR sky130_fd_sc_hd__tapvpwrvgnd_1
X_07646_ _03738_ _03742_ _03743_ net681 net687 VGND VGND VPWR VPWR _03744_ sky130_fd_sc_hd__a221o_1
XTAP_TAPCELL_ROW_0_299 VGND VPWR sky130_fd_sc_hd__tapvpwrvgnd_1
XFILLER_15_57 VPWR VGND VPWR VGND sky130_ef_sc_hd__decap_12
X_07577_ picorv32_core.cpuregs\[20\]\[1\] picorv32_core.cpuregs\[21\]\[1\] picorv32_core.cpuregs\[22\]\[1\]
+ picorv32_core.cpuregs\[23\]\[1\] net744 net711 VGND VGND VPWR VPWR _03681_ sky130_fd_sc_hd__mux4_1
XFILLER_25_178 VGND VGND VPWR VPWR sky130_fd_sc_hd__fill_1
X_06528_ _02835_ _02836_ VGND VGND VPWR VPWR _00156_ sky130_fd_sc_hd__nor2_1
X_09316_ picorv32_core.cpuregs\[16\]\[6\] picorv32_core.cpuregs\[17\]\[6\] picorv32_core.cpuregs\[18\]\[6\]
+ picorv32_core.cpuregs\[19\]\[6\] net874 net841 VGND VGND VPWR VPWR _04509_ sky130_fd_sc_hd__mux4_1
XPHY_EDGE_ROW_38_Left_180 VGND VGND VPWR VPWR sky130_fd_sc_hd__decap_3
X_09247_ net656 _04442_ VGND VGND VPWR VPWR _04443_ sky130_fd_sc_hd__and2_1
XFILLER_21_351 VGND VGND VPWR VPWR sky130_fd_sc_hd__fill_1
X_06459_ net242 net2119 net419 VGND VGND VPWR VPWR _00125_ sky130_fd_sc_hd__mux2_1
XFILLER_135_710 VPWR VGND VPWR VGND sky130_ef_sc_hd__decap_12
XFILLER_119_250 VGND VGND VPWR VPWR sky130_fd_sc_hd__decap_6
X_09178_ picorv32_core.cpuregs\[26\]\[1\] picorv32_core.cpuregs\[27\]\[1\] net888
+ VGND VGND VPWR VPWR _04376_ sky130_fd_sc_hd__mux2_1
XFILLER_135_765 VPWR VGND VPWR VGND sky130_ef_sc_hd__decap_12
X_08129_ net234 net2237 net416 VGND VGND VPWR VPWR _00422_ sky130_fd_sc_hd__mux2_1
XFILLER_134_253 VGND VGND VPWR VPWR sky130_fd_sc_hd__decap_3
X_11140_ clknet_leaf_63_clk _00991_ VGND VGND VPWR VPWR picorv32_core.cpuregs\[8\]\[26\]
+ sky130_fd_sc_hd__dfxtp_1
XTAP_TAPCELL_ROW_56_1115 VGND VPWR sky130_fd_sc_hd__tapvpwrvgnd_1
Xoutput56 net56 VGND VGND VPWR VPWR mem_axi_araddr[27] sky130_fd_sc_hd__buf_2
Xoutput45 net45 VGND VGND VPWR VPWR mem_axi_araddr[16] sky130_fd_sc_hd__buf_2
Xoutput67 net67 VGND VGND VPWR VPWR mem_axi_araddr[8] sky130_fd_sc_hd__buf_2
Xoutput89 net89 VGND VGND VPWR VPWR mem_axi_awaddr[28] sky130_fd_sc_hd__buf_2
X_11071_ clknet_leaf_50_clk _00922_ VGND VGND VPWR VPWR picorv32_core.cpuregs\[10\]\[21\]
+ sky130_fd_sc_hd__dfxtp_1
Xoutput78 net78 VGND VGND VPWR VPWR mem_axi_awaddr[17] sky130_fd_sc_hd__buf_2
XFILLER_130_470 VGND VGND VPWR VPWR sky130_fd_sc_hd__fill_1
X_10022_ net1230 net264 net310 VGND VGND VPWR VPWR _01498_ sky130_fd_sc_hd__mux2_1
XFILLER_29_462 VGND VGND VPWR VPWR sky130_fd_sc_hd__decap_8
XFILLER_16_101 VGND VGND VPWR VPWR sky130_fd_sc_hd__fill_2
XFILLER_44_421 VGND VGND VPWR VPWR sky130_fd_sc_hd__decap_3
XPHY_EDGE_ROW_113_Right_113 VGND VGND VPWR VPWR sky130_fd_sc_hd__decap_3
XFILLER_72_752 VGND VGND VPWR VPWR sky130_fd_sc_hd__decap_4
XTAP_TAPCELL_ROW_67_1277 VGND VPWR sky130_fd_sc_hd__tapvpwrvgnd_1
X_10924_ clknet_leaf_137_clk _00775_ VGND VGND VPWR VPWR picorv32_core.cpuregs\[19\]\[2\]
+ sky130_fd_sc_hd__dfxtp_1
XFILLER_72_41 VGND VGND VPWR VPWR sky130_fd_sc_hd__decap_3
X_10855_ clknet_leaf_108_clk _00706_ VGND VGND VPWR VPWR axi_adapter.ack_awvalid sky130_fd_sc_hd__dfxtp_1
XTAP_TAPCELL_ROW_27_696 VGND VPWR sky130_fd_sc_hd__tapvpwrvgnd_1
XFILLER_71_295 VGND VGND VPWR VPWR sky130_fd_sc_hd__fill_2
X_10786_ clknet_leaf_41_clk _00637_ VGND VGND VPWR VPWR picorv32_core.cpuregs\[14\]\[27\]
+ sky130_fd_sc_hd__dfxtp_1
XTAP_TAPCELL_ROW_80_1466 VGND VPWR sky130_fd_sc_hd__tapvpwrvgnd_1
XFILLER_12_373 VGND VGND VPWR VPWR sky130_fd_sc_hd__fill_1
XFILLER_40_693 VGND VGND VPWR VPWR sky130_fd_sc_hd__fill_2
X_11407_ clknet_leaf_32_clk _01243_ VGND VGND VPWR VPWR picorv32_core.cpuregs\[31\]\[22\]
+ sky130_fd_sc_hd__dfxtp_1
XFILLER_141_713 VGND VGND VPWR VPWR sky130_fd_sc_hd__decap_4
X_11338_ clknet_leaf_21_clk _01179_ VGND VGND VPWR VPWR picorv32_core.cpuregs\[29\]\[22\]
+ sky130_fd_sc_hd__dfxtp_1
XFILLER_141_757 VGND VGND VPWR VPWR sky130_fd_sc_hd__fill_2
XFILLER_99_638 VGND VGND VPWR VPWR sky130_fd_sc_hd__fill_1
X_11269_ clknet_leaf_35_clk _01117_ VGND VGND VPWR VPWR picorv32_core.cpuregs\[4\]\[24\]
+ sky130_fd_sc_hd__dfxtp_1
XFILLER_121_470 VGND VGND VPWR VPWR sky130_fd_sc_hd__decap_6
XFILLER_95_811 VGND VGND VPWR VPWR sky130_fd_sc_hd__fill_1
X_05830_ picorv32_core.mem_la_wdata\[4\] picorv32_core.mem_la_wdata\[5\] VGND VGND
+ VPWR VPWR _02308_ sky130_fd_sc_hd__or2_1
XFILLER_39_237 VGND VGND VPWR VPWR sky130_fd_sc_hd__fill_2
XFILLER_94_365 VGND VGND VPWR VPWR sky130_fd_sc_hd__decap_8
XFILLER_82_505 VGND VGND VPWR VPWR sky130_fd_sc_hd__decap_8
X_07500_ picorv32_core.reg_out\[20\] picorv32_core.reg_next_pc\[20\] net560 VGND VGND
+ VPWR VPWR _03621_ sky130_fd_sc_hd__mux2_1
XFILLER_82_549 VGND VGND VPWR VPWR sky130_fd_sc_hd__decap_3
X_05761_ _02203_ picorv32_core.is_slti_blt_slt _01648_ _02242_ VGND VGND VPWR VPWR
+ _02245_ sky130_fd_sc_hd__and4bb_1
X_05692_ net781 net955 VGND VGND VPWR VPWR _02176_ sky130_fd_sc_hd__or2_1
XFILLER_62_251 VGND VGND VPWR VPWR sky130_fd_sc_hd__fill_1
X_08480_ net1516 net503 net406 VGND VGND VPWR VPWR _00610_ sky130_fd_sc_hd__mux2_1
XFILLER_35_454 VGND VGND VPWR VPWR sky130_fd_sc_hd__decap_4
X_07431_ net833 _03570_ VGND VGND VPWR VPWR _03571_ sky130_fd_sc_hd__nor2_1
XTAP_TAPCELL_ROW_122_2072 VGND VPWR sky130_fd_sc_hd__tapvpwrvgnd_1
XFILLER_63_785 VPWR VGND VPWR VGND sky130_ef_sc_hd__decap_12
XFILLER_35_487 VPWR VGND VPWR VGND sky130_ef_sc_hd__decap_12
XTAP_TAPCELL_ROW_46_972 VGND VPWR sky130_fd_sc_hd__tapvpwrvgnd_1
X_07362_ _03494_ _03496_ _03497_ _03422_ _03420_ VGND VGND VPWR VPWR _03502_ sky130_fd_sc_hd__a2111oi_1
X_09101_ net271 net1327 net334 VGND VGND VPWR VPWR _01268_ sky130_fd_sc_hd__mux2_1
X_06313_ picorv32_core.reg_out\[15\] picorv32_core.alu_out_q\[15\] net952 VGND VGND
+ VPWR VPWR _02724_ sky130_fd_sc_hd__mux2_1
XFILLER_31_671 VGND VGND VPWR VPWR sky130_fd_sc_hd__fill_1
XTAP_TAPCELL_ROW_98_1727 VGND VPWR sky130_fd_sc_hd__tapvpwrvgnd_1
X_07293_ net799 picorv32_core.decoded_imm\[11\] VGND VGND VPWR VPWR _03433_ sky130_fd_sc_hd__nand2_1
X_09032_ net286 net2185 net340 VGND VGND VPWR VPWR _01201_ sky130_fd_sc_hd__mux2_1
X_06244_ net563 _02669_ VGND VGND VPWR VPWR _02670_ sky130_fd_sc_hd__and2b_1
Xhold311 picorv32_core.cpuregs\[5\]\[13\] VGND VGND VPWR VPWR net1420 sky130_fd_sc_hd__dlygate4sd3_1
Xhold300 picorv32_core.cpuregs\[11\]\[2\] VGND VGND VPWR VPWR net1409 sky130_fd_sc_hd__dlygate4sd3_1
X_06175_ picorv32_core.cpuregs\[0\]\[2\] picorv32_core.cpuregs\[1\]\[2\] picorv32_core.cpuregs\[2\]\[2\]
+ picorv32_core.cpuregs\[3\]\[2\] net742 net709 VGND VGND VPWR VPWR _02607_ sky130_fd_sc_hd__mux4_1
XFILLER_117_765 VPWR VGND VPWR VGND sky130_ef_sc_hd__decap_12
XFILLER_117_15 VGND VGND VPWR VPWR sky130_fd_sc_hd__decap_4
XFILLER_116_253 VGND VGND VPWR VPWR sky130_fd_sc_hd__decap_6
Xhold344 picorv32_core.cpuregs\[14\]\[17\] VGND VGND VPWR VPWR net1453 sky130_fd_sc_hd__dlygate4sd3_1
Xhold333 picorv32_core.cpuregs\[19\]\[17\] VGND VGND VPWR VPWR net1442 sky130_fd_sc_hd__dlygate4sd3_1
X_05126_ picorv32_core.instr_beq picorv32_core.instr_rdcycle picorv32_core.instr_srai
+ picorv32_core.instr_slli VGND VGND VPWR VPWR _01657_ sky130_fd_sc_hd__or4_1
Xhold322 picorv32_core.cpuregs\[11\]\[1\] VGND VGND VPWR VPWR net1431 sky130_fd_sc_hd__dlygate4sd3_1
Xhold355 picorv32_core.cpuregs\[19\]\[29\] VGND VGND VPWR VPWR net1464 sky130_fd_sc_hd__dlygate4sd3_1
XFILLER_131_212 VGND VGND VPWR VPWR sky130_fd_sc_hd__fill_1
XFILLER_116_275 VGND VGND VPWR VPWR sky130_fd_sc_hd__decap_3
XFILLER_104_437 VGND VGND VPWR VPWR sky130_fd_sc_hd__fill_1
Xhold377 picorv32_core.cpuregs\[7\]\[12\] VGND VGND VPWR VPWR net1486 sky130_fd_sc_hd__dlygate4sd3_1
Xhold366 picorv32_core.cpuregs\[13\]\[9\] VGND VGND VPWR VPWR net1475 sky130_fd_sc_hd__dlygate4sd3_1
XFILLER_132_757 VPWR VGND VPWR VGND sky130_ef_sc_hd__decap_12
Xhold399 picorv32_core.cpuregs\[17\]\[22\] VGND VGND VPWR VPWR net1508 sky130_fd_sc_hd__dlygate4sd3_1
X_05057_ net677 VGND VGND VPWR VPWR _01592_ sky130_fd_sc_hd__inv_2
XFILLER_77_19 VGND VGND VPWR VPWR sky130_fd_sc_hd__fill_2
Xfanout802 net142 VGND VGND VPWR VPWR net802 sky130_fd_sc_hd__buf_2
Xhold388 picorv32_core.cpuregs\[17\]\[0\] VGND VGND VPWR VPWR net1497 sky130_fd_sc_hd__dlygate4sd3_1
Xfanout824 net141 VGND VGND VPWR VPWR net824 sky130_fd_sc_hd__clkbuf_2
X_09934_ net2288 net474 _05035_ _01591_ _05034_ VGND VGND VPWR VPWR _01416_ sky130_fd_sc_hd__a221o_1
Xfanout813 net167 VGND VGND VPWR VPWR net813 sky130_fd_sc_hd__clkbuf_4
Xhold1000 picorv32_core.cpuregs\[10\]\[21\] VGND VGND VPWR VPWR net2109 sky130_fd_sc_hd__dlygate4sd3_1
Xfanout857 net866 VGND VGND VPWR VPWR net857 sky130_fd_sc_hd__clkbuf_2
Xfanout846 net847 VGND VGND VPWR VPWR net846 sky130_fd_sc_hd__clkbuf_4
X_09865_ net1213 net494 net325 VGND VGND VPWR VPWR _01353_ sky130_fd_sc_hd__mux2_1
Xfanout835 net836 VGND VGND VPWR VPWR net835 sky130_fd_sc_hd__buf_4
Xhold1033 picorv32_core.cpuregs\[18\]\[26\] VGND VGND VPWR VPWR net2142 sky130_fd_sc_hd__dlygate4sd3_1
Xfanout868 net872 VGND VGND VPWR VPWR net868 sky130_fd_sc_hd__clkbuf_4
X_08816_ net213 net1782 net373 VGND VGND VPWR VPWR _00994_ sky130_fd_sc_hd__mux2_1
XFILLER_100_632 VGND VGND VPWR VPWR sky130_fd_sc_hd__fill_1
Xhold1011 picorv32_core.cpuregs\[2\]\[16\] VGND VGND VPWR VPWR net2120 sky130_fd_sc_hd__dlygate4sd3_1
XFILLER_85_332 VGND VGND VPWR VPWR sky130_fd_sc_hd__decap_4
Xfanout879 net880 VGND VGND VPWR VPWR net879 sky130_fd_sc_hd__buf_4
XTAP_TAPCELL_ROW_51_1045 VGND VPWR sky130_fd_sc_hd__tapvpwrvgnd_1
Xhold1022 picorv32_core.cpuregs\[1\]\[8\] VGND VGND VPWR VPWR net2131 sky130_fd_sc_hd__dlygate4sd3_1
Xhold1066 net52 VGND VGND VPWR VPWR net2175 sky130_fd_sc_hd__dlygate4sd3_1
Xhold1044 picorv32_core.cpuregs\[1\]\[30\] VGND VGND VPWR VPWR net2153 sky130_fd_sc_hd__dlygate4sd3_1
Xhold1055 picorv32_core.cpuregs\[18\]\[27\] VGND VGND VPWR VPWR net2164 sky130_fd_sc_hd__dlygate4sd3_1
XFILLER_133_69 VPWR VGND VPWR VGND sky130_ef_sc_hd__decap_12
X_09796_ _03402_ _03534_ VGND VGND VPWR VPWR _04967_ sky130_fd_sc_hd__nand2_1
XFILLER_73_505 VGND VGND VPWR VPWR sky130_fd_sc_hd__fill_2
X_08747_ net1647 net225 net380 VGND VGND VPWR VPWR _00895_ sky130_fd_sc_hd__mux2_1
Xhold1099 picorv32_core.cpuregs\[5\]\[31\] VGND VGND VPWR VPWR net2208 sky130_fd_sc_hd__dlygate4sd3_1
X_05959_ _02336_ _02345_ _02381_ _02425_ VGND VGND VPWR VPWR _02427_ sky130_fd_sc_hd__nor4_1
Xhold1077 picorv32_core.instr_sb VGND VGND VPWR VPWR net2186 sky130_fd_sc_hd__dlygate4sd3_1
Xhold1088 picorv32_core.cpuregs\[13\]\[5\] VGND VGND VPWR VPWR net2197 sky130_fd_sc_hd__dlygate4sd3_1
X_08678_ net236 net2016 net388 VGND VGND VPWR VPWR _00828_ sky130_fd_sc_hd__mux2_1
XTAP_TAPCELL_ROW_107_1856 VGND VPWR sky130_fd_sc_hd__tapvpwrvgnd_1
X_07629_ net693 _03723_ _03722_ net617 VGND VGND VPWR VPWR _03728_ sky130_fd_sc_hd__o211a_1
X_10640_ clknet_leaf_12_clk _00494_ VGND VGND VPWR VPWR picorv32_core.cpuregs\[20\]\[8\]
+ sky130_fd_sc_hd__dfxtp_1
XFILLER_10_811 VGND VGND VPWR VPWR sky130_fd_sc_hd__fill_1
XTAP_TAPCELL_ROW_24_655 VGND VPWR sky130_fd_sc_hd__tapvpwrvgnd_1
X_10571_ clknet_leaf_41_clk _00425_ VGND VGND VPWR VPWR picorv32_core.cpuregs\[25\]\[27\]
+ sky130_fd_sc_hd__dfxtp_1
XFILLER_10_833 VGND VGND VPWR VPWR sky130_fd_sc_hd__fill_1
XFILLER_3_27 VPWR VGND VPWR VGND sky130_ef_sc_hd__decap_12
X_11123_ clknet_leaf_1_clk _00974_ VGND VGND VPWR VPWR picorv32_core.cpuregs\[8\]\[9\]
+ sky130_fd_sc_hd__dfxtp_1
XFILLER_49_502 VGND VGND VPWR VPWR sky130_fd_sc_hd__fill_2
X_11054_ clknet_leaf_115_clk _00905_ VGND VGND VPWR VPWR picorv32_core.cpuregs\[10\]\[4\]
+ sky130_fd_sc_hd__dfxtp_1
X_10005_ _02666_ _04171_ VGND VGND VPWR VPWR _05041_ sky130_fd_sc_hd__nor2_2
XFILLER_91_302 VGND VGND VPWR VPWR sky130_fd_sc_hd__fill_1
XTAP_TAPCELL_ROW_69_1306 VGND VPWR sky130_fd_sc_hd__tapvpwrvgnd_1
XFILLER_29_281 VGND VGND VPWR VPWR sky130_fd_sc_hd__fill_1
X_10907_ clknet_leaf_83_clk _00758_ VGND VGND VPWR VPWR picorv32_core.mem_rdata_q\[17\]
+ sky130_fd_sc_hd__dfxtp_1
XFILLER_32_413 VGND VGND VPWR VPWR sky130_fd_sc_hd__fill_2
XFILLER_60_755 VGND VGND VPWR VPWR sky130_fd_sc_hd__fill_1
XTAP_TAPCELL_ROW_43_931 VGND VPWR sky130_fd_sc_hd__tapvpwrvgnd_1
X_10838_ clknet_leaf_18_clk _00689_ VGND VGND VPWR VPWR picorv32_core.cpuregs\[17\]\[15\]
+ sky130_fd_sc_hd__dfxtp_1
X_10769_ clknet_leaf_0_clk _00620_ VGND VGND VPWR VPWR picorv32_core.cpuregs\[14\]\[10\]
+ sky130_fd_sc_hd__dfxtp_1
XFILLER_12_192 VGND VGND VPWR VPWR sky130_fd_sc_hd__decap_4
XFILLER_9_686 VGND VGND VPWR VPWR sky130_fd_sc_hd__fill_1
XFILLER_8_141 VGND VGND VPWR VPWR sky130_fd_sc_hd__decap_8
XTAP_TAPCELL_ROW_93_1657 VGND VPWR sky130_fd_sc_hd__tapvpwrvgnd_1
X_07980_ net640 _04058_ VGND VGND VPWR VPWR _04059_ sky130_fd_sc_hd__or2_1
XFILLER_114_757 VPWR VGND VPWR VGND sky130_ef_sc_hd__decap_12
XFILLER_99_457 VGND VGND VPWR VPWR sky130_fd_sc_hd__fill_2
XFILLER_99_446 VGND VGND VPWR VPWR sky130_fd_sc_hd__fill_2
X_06931_ _03146_ _03147_ net677 VGND VGND VPWR VPWR _03148_ sky130_fd_sc_hd__o21ai_1
X_09650_ picorv32_core.cpuregs\[20\]\[21\] picorv32_core.cpuregs\[21\]\[21\] picorv32_core.cpuregs\[22\]\[21\]
+ picorv32_core.cpuregs\[23\]\[21\] net897 net863 VGND VGND VPWR VPWR _04828_ sky130_fd_sc_hd__mux4_1
XTAP_TAPCELL_ROW_124_2101 VGND VPWR sky130_fd_sc_hd__tapvpwrvgnd_1
X_08601_ net259 net2069 net396 VGND VGND VPWR VPWR _00724_ sky130_fd_sc_hd__mux2_1
X_06862_ _03068_ _03076_ _03083_ VGND VGND VPWR VPWR _03084_ sky130_fd_sc_hd__a21oi_1
XFILLER_55_505 VGND VGND VPWR VPWR sky130_fd_sc_hd__decap_6
XTAP_TAPCELL_ROW_2_328 VGND VPWR sky130_fd_sc_hd__tapvpwrvgnd_1
X_09581_ net472 _04697_ _04761_ net487 VGND VGND VPWR VPWR _04762_ sky130_fd_sc_hd__a31o_1
X_06793_ net665 picorv32_core.reg_next_pc\[8\] _02920_ net491 VGND VGND VPWR VPWR
+ _03021_ sky130_fd_sc_hd__a22o_1
XTAP_TAPCELL_ROW_2_339 VGND VPWR sky130_fd_sc_hd__tapvpwrvgnd_1
X_05813_ net813 net965 net606 _02292_ VGND VGND VPWR VPWR _02293_ sky130_fd_sc_hd__o22a_1
X_05744_ _02178_ _02179_ net955 VGND VGND VPWR VPWR _02228_ sky130_fd_sc_hd__a21bo_1
X_08532_ net1405 net260 net404 VGND VGND VPWR VPWR _00659_ sky130_fd_sc_hd__mux2_1
X_08463_ picorv32_core.decoded_imm\[6\] net526 _04312_ VGND VGND VPWR VPWR _00604_
+ sky130_fd_sc_hd__o21a_1
X_07414_ net871 _03551_ _03552_ _03553_ net839 VGND VGND VPWR VPWR _03554_ sky130_fd_sc_hd__o221a_1
X_05675_ net768 net192 VGND VGND VPWR VPWR _02159_ sky130_fd_sc_hd__xor2_1
XFILLER_23_446 VGND VGND VPWR VPWR sky130_fd_sc_hd__fill_2
XTAP_TAPCELL_ROW_21_603 VGND VPWR sky130_fd_sc_hd__tapvpwrvgnd_1
X_08394_ net925 net824 net822 VGND VGND VPWR VPWR _04273_ sky130_fd_sc_hd__o21bai_1
XTAP_TAPCELL_ROW_102_1786 VGND VPWR sky130_fd_sc_hd__tapvpwrvgnd_1
X_07345_ _03435_ _03437_ _03440_ _03445_ _03433_ VGND VGND VPWR VPWR _03485_ sky130_fd_sc_hd__o221a_1
XTAP_TAPCELL_ROW_21_614 VGND VPWR sky130_fd_sc_hd__tapvpwrvgnd_1
XFILLER_109_518 VGND VGND VPWR VPWR sky130_fd_sc_hd__decap_8
Xclkbuf_leaf_30_clk clknet_4_4_0_clk VGND VGND VPWR VPWR clknet_leaf_30_clk sky130_fd_sc_hd__clkbuf_8
X_07276_ net779 picorv32_core.decoded_imm\[21\] VGND VGND VPWR VPWR _03416_ sky130_fd_sc_hd__nand2_1
XTAP_TAPCELL_ROW_135_2263 VGND VPWR sky130_fd_sc_hd__tapvpwrvgnd_1
X_09015_ net220 net1797 net346 VGND VGND VPWR VPWR _01185_ sky130_fd_sc_hd__mux2_1
X_06227_ _02655_ _02656_ net632 VGND VGND VPWR VPWR _02657_ sky130_fd_sc_hd__mux2_1
Xhold141 picorv32_core.cpuregs\[3\]\[27\] VGND VGND VPWR VPWR net1250 sky130_fd_sc_hd__dlygate4sd3_1
Xhold152 picorv32_core.cpuregs\[11\]\[22\] VGND VGND VPWR VPWR net1261 sky130_fd_sc_hd__dlygate4sd3_1
XFILLER_88_29 VGND VGND VPWR VPWR sky130_fd_sc_hd__decap_3
X_06158_ picorv32_core.decoded_imm_j\[19\] _00760_ net440 VGND VGND VPWR VPWR _00029_
+ sky130_fd_sc_hd__mux2_1
Xhold130 picorv32_core.cpuregs\[26\]\[18\] VGND VGND VPWR VPWR net1239 sky130_fd_sc_hd__dlygate4sd3_1
Xhold163 picorv32_core.cpuregs\[3\]\[25\] VGND VGND VPWR VPWR net1272 sky130_fd_sc_hd__dlygate4sd3_1
X_06089_ _02522_ _02546_ _02530_ VGND VGND VPWR VPWR _02547_ sky130_fd_sc_hd__a21oi_1
Xhold174 picorv32_core.cpuregs\[27\]\[18\] VGND VGND VPWR VPWR net1283 sky130_fd_sc_hd__dlygate4sd3_1
X_05109_ picorv32_core.instr_lbu picorv32_core.instr_lb VGND VGND VPWR VPWR _01641_
+ sky130_fd_sc_hd__or2_1
Xhold185 picorv32_core.cpuregs\[27\]\[6\] VGND VGND VPWR VPWR net1294 sky130_fd_sc_hd__dlygate4sd3_1
Xfanout621 net622 VGND VGND VPWR VPWR net621 sky130_fd_sc_hd__clkbuf_4
X_09917_ net259 net2013 net322 VGND VGND VPWR VPWR _01401_ sky130_fd_sc_hd__mux2_1
Xhold196 picorv32_core.cpuregs\[22\]\[3\] VGND VGND VPWR VPWR net1305 sky130_fd_sc_hd__dlygate4sd3_1
Xfanout632 net641 VGND VGND VPWR VPWR net632 sky130_fd_sc_hd__buf_4
Xfanout610 net613 VGND VGND VPWR VPWR net610 sky130_fd_sc_hd__clkbuf_4
XFILLER_98_490 VGND VGND VPWR VPWR sky130_fd_sc_hd__fill_2
Xfanout676 net679 VGND VGND VPWR VPWR net676 sky130_fd_sc_hd__buf_2
Xclkbuf_leaf_97_clk clknet_4_11_0_clk VGND VGND VPWR VPWR clknet_leaf_97_clk sky130_fd_sc_hd__clkbuf_8
Xfanout643 net644 VGND VGND VPWR VPWR net643 sky130_fd_sc_hd__buf_2
Xfanout665 net668 VGND VGND VPWR VPWR net665 sky130_fd_sc_hd__clkbuf_4
Xfanout654 net655 VGND VGND VPWR VPWR net654 sky130_fd_sc_hd__buf_4
X_09848_ picorv32_core.cpuregs\[24\]\[30\] picorv32_core.cpuregs\[25\]\[30\] picorv32_core.cpuregs\[26\]\[30\]
+ picorv32_core.cpuregs\[27\]\[30\] net906 net867 VGND VGND VPWR VPWR _05017_ sky130_fd_sc_hd__mux4_1
XFILLER_74_803 VGND VGND VPWR VPWR sky130_fd_sc_hd__fill_2
XFILLER_58_365 VGND VGND VPWR VPWR sky130_fd_sc_hd__fill_1
Xfanout698 net699 VGND VGND VPWR VPWR net698 sky130_fd_sc_hd__clkbuf_4
Xfanout687 net688 VGND VGND VPWR VPWR net687 sky130_fd_sc_hd__buf_4
X_09779_ picorv32_core.cpuregs\[20\]\[27\] picorv32_core.cpuregs\[21\]\[27\] picorv32_core.cpuregs\[22\]\[27\]
+ picorv32_core.cpuregs\[23\]\[27\] net898 net864 VGND VGND VPWR VPWR _04951_ sky130_fd_sc_hd__mux4_1
XTAP_TAPCELL_ROW_29_725 VGND VPWR sky130_fd_sc_hd__tapvpwrvgnd_1
XFILLER_46_538 VGND VGND VPWR VPWR sky130_fd_sc_hd__fill_1
XFILLER_27_785 VPWR VGND VPWR VGND sky130_ef_sc_hd__decap_12
XFILLER_42_722 VGND VGND VPWR VPWR sky130_fd_sc_hd__decap_3
XTAP_TAPCELL_ROW_64_1236 VGND VPWR sky130_fd_sc_hd__tapvpwrvgnd_1
X_11672_ clknet_leaf_48_clk _01503_ VGND VGND VPWR VPWR picorv32_core.cpuregs\[26\]\[21\]
+ sky130_fd_sc_hd__dfxtp_1
XFILLER_128_805 VGND VGND VPWR VPWR sky130_fd_sc_hd__decap_6
X_10623_ clknet_leaf_94_clk _00477_ VGND VGND VPWR VPWR picorv32_core.decoded_imm_j\[7\]
+ sky130_fd_sc_hd__dfxtp_1
XFILLER_139_153 VGND VGND VPWR VPWR sky130_fd_sc_hd__fill_1
Xclkbuf_leaf_21_clk clknet_4_4_0_clk VGND VGND VPWR VPWR clknet_leaf_21_clk sky130_fd_sc_hd__clkbuf_8
X_10554_ clknet_leaf_1_clk _00408_ VGND VGND VPWR VPWR picorv32_core.cpuregs\[25\]\[10\]
+ sky130_fd_sc_hd__dfxtp_1
XFILLER_127_337 VGND VGND VPWR VPWR sky130_fd_sc_hd__fill_1
XFILLER_6_645 VGND VGND VPWR VPWR sky130_fd_sc_hd__fill_2
XFILLER_5_111 VGND VGND VPWR VPWR sky130_fd_sc_hd__fill_1
X_10485_ clknet_leaf_16_clk _00371_ VGND VGND VPWR VPWR net175 sky130_fd_sc_hd__dfxtp_4
XFILLER_6_656 VGND VGND VPWR VPWR sky130_fd_sc_hd__fill_1
XTAP_TAPCELL_ROW_75_1387 VGND VPWR sky130_fd_sc_hd__tapvpwrvgnd_1
X_11106_ clknet_leaf_33_clk _00957_ VGND VGND VPWR VPWR picorv32_core.cpuregs\[0\]\[24\]
+ sky130_fd_sc_hd__dfxtp_1
XFILLER_110_215 VGND VGND VPWR VPWR sky130_fd_sc_hd__fill_2
XFILLER_78_73 VGND VGND VPWR VPWR sky130_fd_sc_hd__decap_3
XTAP_TAPCELL_ROW_75_1398 VGND VPWR sky130_fd_sc_hd__tapvpwrvgnd_1
XFILLER_77_630 VPWR VGND VPWR VGND sky130_ef_sc_hd__decap_12
Xclkbuf_leaf_88_clk clknet_4_12_0_clk VGND VGND VPWR VPWR clknet_leaf_88_clk sky130_fd_sc_hd__clkbuf_8
X_11037_ clknet_leaf_31_clk _00888_ VGND VGND VPWR VPWR picorv32_core.cpuregs\[11\]\[19\]
+ sky130_fd_sc_hd__dfxtp_1
XFILLER_65_825 VGND VGND VPWR VPWR sky130_fd_sc_hd__fill_1
XFILLER_37_505 VGND VGND VPWR VPWR sky130_fd_sc_hd__fill_2
XFILLER_94_83 VGND VGND VPWR VPWR sky130_fd_sc_hd__fill_1
XFILLER_92_677 VGND VGND VPWR VPWR sky130_fd_sc_hd__fill_1
XFILLER_76_195 VGND VGND VPWR VPWR sky130_fd_sc_hd__fill_1
XFILLER_52_508 VPWR VGND VPWR VGND sky130_ef_sc_hd__decap_12
XFILLER_18_741 VPWR VGND VPWR VGND sky130_ef_sc_hd__decap_12
X_05460_ _01943_ _01946_ _01947_ VGND VGND VPWR VPWR _01958_ sky130_fd_sc_hd__or3_1
XFILLER_60_552 VGND VGND VPWR VPWR sky130_fd_sc_hd__decap_6
X_05391_ _01880_ _01888_ _01892_ VGND VGND VPWR VPWR _01894_ sky130_fd_sc_hd__a21o_1
X_07130_ _03313_ net994 _03312_ VGND VGND VPWR VPWR _00281_ sky130_fd_sc_hd__and3b_1
Xclkbuf_leaf_12_clk clknet_4_1_0_clk VGND VGND VPWR VPWR clknet_leaf_12_clk sky130_fd_sc_hd__clkbuf_8
X_07061_ _03265_ _03266_ net677 VGND VGND VPWR VPWR _03267_ sky130_fd_sc_hd__o21ai_1
X_06012_ _02432_ _02439_ _02441_ _02452_ _02463_ VGND VGND VPWR VPWR _02476_ sky130_fd_sc_hd__a2111o_1
Xoutput202 net202 VGND VGND VPWR VPWR pcpi_rs2[7] sky130_fd_sc_hd__buf_2
XTAP_TAPCELL_ROW_7_409 VGND VPWR sky130_fd_sc_hd__tapvpwrvgnd_1
XTAP_TAPCELL_ROW_130_2193 VGND VPWR sky130_fd_sc_hd__tapvpwrvgnd_1
XFILLER_87_405 VPWR VGND VPWR VGND sky130_ef_sc_hd__decap_12
X_07963_ net189 net511 _04042_ _04043_ VGND VGND VPWR VPWR _00384_ sky130_fd_sc_hd__o22a_1
Xclkbuf_leaf_79_clk clknet_4_14_0_clk VGND VGND VPWR VPWR clknet_leaf_79_clk sky130_fd_sc_hd__clkbuf_8
X_09702_ picorv32_core.cpuregs\[4\]\[23\] picorv32_core.cpuregs\[5\]\[23\] picorv32_core.cpuregs\[6\]\[23\]
+ picorv32_core.cpuregs\[7\]\[23\] net899 net865 VGND VGND VPWR VPWR _04878_ sky130_fd_sc_hd__mux4_1
X_07894_ net695 _03977_ VGND VGND VPWR VPWR _03978_ sky130_fd_sc_hd__or2_1
X_06914_ _03130_ _03131_ VGND VGND VPWR VPWR _03132_ sky130_fd_sc_hd__nand2_1
XFILLER_83_600 VGND VGND VPWR VPWR sky130_fd_sc_hd__decap_8
XFILLER_68_652 VPWR VGND VPWR VGND sky130_ef_sc_hd__decap_12
XFILLER_110_793 VPWR VGND VPWR VGND sky130_ef_sc_hd__decap_12
X_09633_ picorv32_core.cpuregs\[12\]\[20\] picorv32_core.cpuregs\[13\]\[20\] picorv32_core.cpuregs\[14\]\[20\]
+ picorv32_core.cpuregs\[15\]\[20\] net892 net858 VGND VGND VPWR VPWR _04812_ sky130_fd_sc_hd__mux4_1
X_06845_ picorv32_core.decoded_imm_j\[13\] _02925_ VGND VGND VPWR VPWR _03068_ sky130_fd_sc_hd__nand2_1
X_09564_ picorv32_core.cpuregs\[0\]\[17\] picorv32_core.cpuregs\[1\]\[17\] picorv32_core.cpuregs\[2\]\[17\]
+ picorv32_core.cpuregs\[3\]\[17\] net889 net855 VGND VGND VPWR VPWR _04746_ sky130_fd_sc_hd__mux4_1
XFILLER_83_644 VGND VGND VPWR VPWR sky130_fd_sc_hd__fill_2
XFILLER_55_357 VGND VGND VPWR VPWR sky130_fd_sc_hd__fill_2
XFILLER_55_346 VGND VGND VPWR VPWR sky130_fd_sc_hd__decap_4
XFILLER_130_15 VPWR VGND VPWR VGND sky130_ef_sc_hd__decap_12
XTAP_TAPCELL_ROW_104_1815 VGND VPWR sky130_fd_sc_hd__tapvpwrvgnd_1
X_06776_ _03000_ _03001_ _03003_ VGND VGND VPWR VPWR _03005_ sky130_fd_sc_hd__and3_1
X_08515_ net1606 net503 net402 VGND VGND VPWR VPWR _00642_ sky130_fd_sc_hd__mux2_1
X_09495_ picorv32_core.cpuregs\[0\]\[14\] picorv32_core.cpuregs\[1\]\[14\] picorv32_core.cpuregs\[2\]\[14\]
+ picorv32_core.cpuregs\[3\]\[14\] net879 net846 VGND VGND VPWR VPWR _04680_ sky130_fd_sc_hd__mux4_1
XFILLER_24_755 VGND VGND VPWR VPWR sky130_fd_sc_hd__fill_1
X_05727_ net817 _02137_ net967 VGND VGND VPWR VPWR _02211_ sky130_fd_sc_hd__or3b_1
X_05658_ net783 net183 VGND VGND VPWR VPWR _02142_ sky130_fd_sc_hd__nand2_1
X_08446_ net2341 net530 _04284_ _04303_ VGND VGND VPWR VPWR _00596_ sky130_fd_sc_hd__o22a_1
X_08377_ net1183 net454 _04263_ VGND VGND VPWR VPWR _00567_ sky130_fd_sc_hd__o21a_1
XFILLER_51_596 VGND VGND VPWR VPWR sky130_fd_sc_hd__decap_3
XFILLER_51_585 VGND VGND VPWR VPWR sky130_fd_sc_hd__fill_2
XFILLER_11_438 VGND VGND VPWR VPWR sky130_fd_sc_hd__fill_2
XTAP_TAPCELL_ROW_34_794 VGND VPWR sky130_fd_sc_hd__tapvpwrvgnd_1
X_05589_ _02043_ _02076_ _02066_ _02055_ VGND VGND VPWR VPWR _02077_ sky130_fd_sc_hd__a211o_1
XFILLER_23_57 VGND VGND VPWR VPWR sky130_fd_sc_hd__fill_1
X_07328_ net813 picorv32_core.decoded_imm\[4\] VGND VGND VPWR VPWR _03468_ sky130_fd_sc_hd__xnor2_1
XFILLER_139_57 VPWR VGND VPWR VGND sky130_ef_sc_hd__decap_12
XFILLER_109_326 VGND VGND VPWR VPWR sky130_fd_sc_hd__fill_1
X_07259_ net765 picorv32_core.decoded_imm\[29\] VGND VGND VPWR VPWR _03399_ sky130_fd_sc_hd__or2_1
XFILLER_124_329 VGND VGND VPWR VPWR sky130_fd_sc_hd__fill_2
X_10270_ clknet_leaf_79_clk _00189_ VGND VGND VPWR VPWR picorv32_core.count_instr\[54\]
+ sky130_fd_sc_hd__dfxtp_1
XTAP_TAPCELL_ROW_115_1977 VGND VPWR sky130_fd_sc_hd__tapvpwrvgnd_1
XTAP_TAPCELL_ROW_115_1966 VGND VPWR sky130_fd_sc_hd__tapvpwrvgnd_1
XFILLER_132_351 VGND VGND VPWR VPWR sky130_fd_sc_hd__fill_1
XFILLER_78_438 VGND VGND VPWR VPWR sky130_fd_sc_hd__fill_2
Xfanout440 net441 VGND VGND VPWR VPWR net440 sky130_fd_sc_hd__buf_2
Xfanout462 net464 VGND VGND VPWR VPWR net462 sky130_fd_sc_hd__clkbuf_4
Xfanout484 _03392_ VGND VGND VPWR VPWR net484 sky130_fd_sc_hd__clkbuf_4
Xfanout473 _01690_ VGND VGND VPWR VPWR net473 sky130_fd_sc_hd__buf_2
Xfanout451 net453 VGND VGND VPWR VPWR net451 sky130_fd_sc_hd__clkbuf_4
Xfanout495 net496 VGND VGND VPWR VPWR net495 sky130_fd_sc_hd__clkbuf_2
XFILLER_47_836 VGND VGND VPWR VPWR sky130_fd_sc_hd__fill_1
XFILLER_58_195 VGND VGND VPWR VPWR sky130_fd_sc_hd__fill_1
XFILLER_15_777 VGND VGND VPWR VPWR sky130_fd_sc_hd__decap_6
XFILLER_42_552 VGND VGND VPWR VPWR sky130_fd_sc_hd__decap_8
XFILLER_14_298 VGND VGND VPWR VPWR sky130_fd_sc_hd__fill_1
X_11655_ clknet_leaf_113_clk _01486_ VGND VGND VPWR VPWR picorv32_core.cpuregs\[26\]\[4\]
+ sky130_fd_sc_hd__dfxtp_1
XFILLER_30_769 VPWR VGND VPWR VGND sky130_ef_sc_hd__decap_12
X_10606_ clknet_leaf_93_clk _00460_ VGND VGND VPWR VPWR picorv32_core.instr_sll sky130_fd_sc_hd__dfxtp_1
XTAP_TAPCELL_ROW_12_477 VGND VPWR sky130_fd_sc_hd__tapvpwrvgnd_1
X_11586_ clknet_leaf_121_clk _01417_ VGND VGND VPWR VPWR picorv32_core.reg_sh\[1\]
+ sky130_fd_sc_hd__dfxtp_1
X_10537_ clknet_leaf_48_clk picorv32_core.alu_out\[25\] VGND VGND VPWR VPWR picorv32_core.alu_out_q\[25\]
+ sky130_fd_sc_hd__dfxtp_1
XTAP_TAPCELL_ROW_77_1427 VGND VPWR sky130_fd_sc_hd__tapvpwrvgnd_1
XTAP_TAPCELL_ROW_77_1416 VGND VPWR sky130_fd_sc_hd__tapvpwrvgnd_1
XFILLER_127_167 VGND VGND VPWR VPWR sky130_fd_sc_hd__fill_1
X_10468_ clknet_leaf_73_clk _00355_ VGND VGND VPWR VPWR net61 sky130_fd_sc_hd__dfxtp_1
XFILLER_50_7 VGND VGND VPWR VPWR sky130_fd_sc_hd__decap_3
XTAP_TAPCELL_ROW_90_1616 VGND VPWR sky130_fd_sc_hd__tapvpwrvgnd_1
XTAP_TAPCELL_ROW_90_1605 VGND VPWR sky130_fd_sc_hd__tapvpwrvgnd_1
X_10399_ clknet_leaf_77_clk _00318_ VGND VGND VPWR VPWR picorv32_core.count_cycle\[57\]
+ sky130_fd_sc_hd__dfxtp_1
XFILLER_96_213 VGND VGND VPWR VPWR sky130_fd_sc_hd__fill_2
XFILLER_84_408 VGND VGND VPWR VPWR sky130_fd_sc_hd__fill_1
Xclkbuf_leaf_1_clk clknet_4_0_0_clk VGND VGND VPWR VPWR clknet_leaf_1_clk sky130_fd_sc_hd__clkbuf_8
XFILLER_38_825 VGND VGND VPWR VPWR sky130_fd_sc_hd__decap_8
X_06630_ _02900_ _02901_ VGND VGND VPWR VPWR _00193_ sky130_fd_sc_hd__nor2_1
XFILLER_65_666 VGND VGND VPWR VPWR sky130_fd_sc_hd__decap_6
XFILLER_37_335 VGND VGND VPWR VPWR sky130_fd_sc_hd__fill_1
XTAP_TAPCELL_ROW_88_1578 VGND VPWR sky130_fd_sc_hd__tapvpwrvgnd_1
XFILLER_65_688 VGND VGND VPWR VPWR sky130_fd_sc_hd__fill_1
X_06561_ picorv32_core.count_instr\[33\] _02854_ picorv32_core.count_instr\[34\] VGND
+ VGND VPWR VPWR _02857_ sky130_fd_sc_hd__a21o_1
X_05512_ picorv32_core.reg_pc\[22\] picorv32_core.decoded_imm\[22\] VGND VGND VPWR
+ VPWR _02006_ sky130_fd_sc_hd__nand2_1
X_06492_ picorv32_core.count_instr\[8\] _02810_ picorv32_core.count_instr\[9\] VGND
+ VGND VPWR VPWR _02813_ sky130_fd_sc_hd__a21o_1
X_09280_ net662 _04474_ net644 VGND VGND VPWR VPWR _04475_ sky130_fd_sc_hd__a21o_1
XFILLER_21_714 VPWR VGND VPWR VGND sky130_ef_sc_hd__decap_12
X_08300_ net2264 net5 net519 VGND VGND VPWR VPWR _00751_ sky130_fd_sc_hd__mux2_1
XFILLER_100_29 VGND VGND VPWR VPWR sky130_fd_sc_hd__decap_4
X_05443_ picorv32_core.reg_pc\[17\] picorv32_core.decoded_imm\[17\] VGND VGND VPWR
+ VPWR _01942_ sky130_fd_sc_hd__nor2_1
X_08231_ picorv32_core.mem_rdata_q\[21\] picorv32_core.mem_rdata_q\[22\] picorv32_core.mem_rdata_q\[23\]
+ _04217_ VGND VGND VPWR VPWR _04218_ sky130_fd_sc_hd__or4_1
XTAP_TAPCELL_ROW_119_2033 VGND VPWR sky130_fd_sc_hd__tapvpwrvgnd_1
XFILLER_20_257 VGND VGND VPWR VPWR sky130_fd_sc_hd__fill_1
XTAP_TAPCELL_ROW_31_753 VGND VPWR sky130_fd_sc_hd__tapvpwrvgnd_1
X_05374_ _01727_ _01877_ VGND VGND VPWR VPWR _01878_ sky130_fd_sc_hd__or2_1
X_08162_ net1747 net476 _04185_ _04186_ VGND VGND VPWR VPWR _00434_ sky130_fd_sc_hd__a22o_1
XTAP_TAPCELL_ROW_132_2222 VGND VPWR sky130_fd_sc_hd__tapvpwrvgnd_1
XFILLER_119_657 VGND VGND VPWR VPWR sky130_fd_sc_hd__decap_6
XFILLER_109_27 VGND VGND VPWR VPWR sky130_fd_sc_hd__decap_4
X_07113_ picorv32_core.count_cycle\[13\] picorv32_core.count_cycle\[14\] _03299_ VGND
+ VGND VPWR VPWR _03303_ sky130_fd_sc_hd__and3_1
X_08093_ net924 picorv32_core.cpu_state\[2\] _01727_ _04164_ VGND VGND VPWR VPWR _04166_
+ sky130_fd_sc_hd__o31a_1
XFILLER_134_638 VGND VGND VPWR VPWR sky130_fd_sc_hd__decap_6
Xclkload61 clknet_leaf_39_clk VGND VGND VPWR VPWR clkload61/Y sky130_fd_sc_hd__clkinvlp_4
X_07044_ net666 picorv32_core.reg_next_pc\[28\] _02940_ net489 VGND VGND VPWR VPWR
+ _03252_ sky130_fd_sc_hd__a22o_1
Xclkload50 clknet_leaf_27_clk VGND VGND VPWR VPWR clkload50/Y sky130_fd_sc_hd__clkinv_8
Xclkload72 clknet_leaf_43_clk VGND VGND VPWR VPWR clkload72/Y sky130_fd_sc_hd__inv_6
Xclkload83 clknet_leaf_115_clk VGND VGND VPWR VPWR clkload83/Y sky130_fd_sc_hd__bufinv_16
Xclkload94 clknet_leaf_123_clk VGND VGND VPWR VPWR clkload94/Y sky130_fd_sc_hd__inv_8
XFILLER_130_811 VGND VGND VPWR VPWR sky130_fd_sc_hd__fill_1
XFILLER_125_15 VPWR VGND VPWR VGND sky130_ef_sc_hd__decap_12
XFILLER_0_629 VGND VGND VPWR VPWR sky130_fd_sc_hd__decap_8
XFILLER_141_181 VPWR VGND VPWR VGND sky130_ef_sc_hd__decap_12
XFILLER_130_833 VGND VGND VPWR VPWR sky130_fd_sc_hd__fill_1
XFILLER_88_769 VGND VGND VPWR VPWR sky130_fd_sc_hd__decap_8
XPHY_EDGE_ROW_10_Left_152 VGND VGND VPWR VPWR sky130_fd_sc_hd__decap_3
X_08995_ net428 net2176 net345 VGND VGND VPWR VPWR _01165_ sky130_fd_sc_hd__mux2_1
X_07946_ net637 _04026_ VGND VGND VPWR VPWR _04027_ sky130_fd_sc_hd__or2_1
XFILLER_102_579 VGND VGND VPWR VPWR sky130_fd_sc_hd__fill_1
XFILLER_87_268 VGND VGND VPWR VPWR sky130_fd_sc_hd__decap_3
XTAP_TAPCELL_ROW_110_1896 VGND VPWR sky130_fd_sc_hd__tapvpwrvgnd_1
XFILLER_68_471 VGND VGND VPWR VPWR sky130_fd_sc_hd__decap_4
XFILLER_28_313 VGND VGND VPWR VPWR sky130_fd_sc_hd__fill_1
X_07877_ picorv32_core.cpuregs\[4\]\[20\] picorv32_core.cpuregs\[5\]\[20\] picorv32_core.cpuregs\[6\]\[20\]
+ picorv32_core.cpuregs\[7\]\[20\] net753 net720 VGND VGND VPWR VPWR _03962_ sky130_fd_sc_hd__mux4_1
XFILLER_141_69 VPWR VGND VPWR VGND sky130_ef_sc_hd__decap_12
X_09616_ _04788_ _04789_ _04792_ _04793_ net657 net645 VGND VGND VPWR VPWR _04796_
+ sky130_fd_sc_hd__mux4_1
XFILLER_83_463 VGND VGND VPWR VPWR sky130_fd_sc_hd__decap_4
X_06828_ _02923_ _03040_ net664 VGND VGND VPWR VPWR _03053_ sky130_fd_sc_hd__o21a_1
XTAP_TAPCELL_ROW_48_1006 VGND VPWR sky130_fd_sc_hd__tapvpwrvgnd_1
XTAP_TAPCELL_ROW_39_864 VGND VPWR sky130_fd_sc_hd__tapvpwrvgnd_1
XTAP_TAPCELL_ROW_39_875 VGND VPWR sky130_fd_sc_hd__tapvpwrvgnd_1
X_09547_ net838 _04724_ net828 VGND VGND VPWR VPWR _04730_ sky130_fd_sc_hd__o21a_1
X_06759_ picorv32_core.decoded_imm_j\[6\] _02918_ VGND VGND VPWR VPWR _02989_ sky130_fd_sc_hd__and2_1
X_09478_ picorv32_core.cpuregs\[16\]\[13\] picorv32_core.cpuregs\[17\]\[13\] picorv32_core.cpuregs\[18\]\[13\]
+ picorv32_core.cpuregs\[19\]\[13\] net882 net849 VGND VGND VPWR VPWR _04664_ sky130_fd_sc_hd__mux4_1
X_08429_ picorv32_core.mem_rdata_q\[22\] net614 VGND VGND VPWR VPWR _04295_ sky130_fd_sc_hd__and2_1
XFILLER_12_769 VPWR VGND VPWR VGND sky130_ef_sc_hd__decap_12
X_11440_ clknet_leaf_44_clk _01276_ VGND VGND VPWR VPWR picorv32_core.cpuregs\[1\]\[23\]
+ sky130_fd_sc_hd__dfxtp_1
XFILLER_137_432 VGND VGND VPWR VPWR sky130_fd_sc_hd__decap_6
XFILLER_137_410 VGND VGND VPWR VPWR sky130_fd_sc_hd__fill_1
XFILLER_126_3 VPWR VGND VPWR VGND sky130_ef_sc_hd__decap_12
Xclkload0 clknet_4_0_0_clk VGND VGND VPWR VPWR clkload0/Y sky130_fd_sc_hd__inv_8
X_11371_ clknet_leaf_44_clk _01212_ VGND VGND VPWR VPWR picorv32_core.cpuregs\[18\]\[23\]
+ sky130_fd_sc_hd__dfxtp_1
XFILLER_125_605 VGND VGND VPWR VPWR sky130_fd_sc_hd__fill_2
X_10322_ clknet_leaf_90_clk _00241_ VGND VGND VPWR VPWR picorv32_core.reg_next_pc\[12\]
+ sky130_fd_sc_hd__dfxtp_1
XTAP_TAPCELL_ROW_59_1157 VGND VPWR sky130_fd_sc_hd__tapvpwrvgnd_1
XFILLER_133_671 VGND VGND VPWR VPWR sky130_fd_sc_hd__fill_1
XFILLER_133_660 VGND VGND VPWR VPWR sky130_fd_sc_hd__fill_2
X_10253_ clknet_leaf_103_clk _00172_ VGND VGND VPWR VPWR picorv32_core.count_instr\[37\]
+ sky130_fd_sc_hd__dfxtp_1
XTAP_TAPCELL_ROW_72_1346 VGND VPWR sky130_fd_sc_hd__tapvpwrvgnd_1
XFILLER_59_53 VGND VGND VPWR VPWR sky130_fd_sc_hd__decap_3
X_10184_ clknet_leaf_132_clk _00103_ VGND VGND VPWR VPWR picorv32_core.cpuregs\[9\]\[0\]
+ sky130_fd_sc_hd__dfxtp_1
XFILLER_120_365 VGND VGND VPWR VPWR sky130_fd_sc_hd__decap_6
XFILLER_66_419 VGND VGND VPWR VPWR sky130_fd_sc_hd__fill_1
XFILLER_59_97 VGND VGND VPWR VPWR sky130_fd_sc_hd__decap_4
Xfanout270 _02728_ VGND VGND VPWR VPWR net270 sky130_fd_sc_hd__clkbuf_2
Xfanout292 net293 VGND VGND VPWR VPWR net292 sky130_fd_sc_hd__clkbuf_2
Xfanout281 _03395_ VGND VGND VPWR VPWR net281 sky130_fd_sc_hd__clkbuf_4
XFILLER_19_357 VGND VGND VPWR VPWR sky130_fd_sc_hd__fill_1
XFILLER_47_655 VGND VGND VPWR VPWR sky130_fd_sc_hd__fill_1
XFILLER_61_113 VGND VGND VPWR VPWR sky130_fd_sc_hd__decap_3
XTAP_TAPCELL_ROW_17_547 VGND VPWR sky130_fd_sc_hd__tapvpwrvgnd_1
XTAP_TAPCELL_ROW_17_558 VGND VPWR sky130_fd_sc_hd__tapvpwrvgnd_1
X_11707_ clknet_leaf_39_clk _01538_ VGND VGND VPWR VPWR picorv32_core.cpuregs\[27\]\[24\]
+ sky130_fd_sc_hd__dfxtp_1
XFILLER_128_421 VGND VGND VPWR VPWR sky130_fd_sc_hd__decap_3
X_11638_ clknet_leaf_21_clk _01469_ VGND VGND VPWR VPWR picorv32_core.cpuregs\[28\]\[19\]
+ sky130_fd_sc_hd__dfxtp_1
XFILLER_128_432 VGND VGND VPWR VPWR sky130_fd_sc_hd__decap_3
X_11569_ clknet_leaf_22_clk _01400_ VGND VGND VPWR VPWR picorv32_core.cpuregs\[2\]\[16\]
+ sky130_fd_sc_hd__dfxtp_1
Xhold707 picorv32_core.cpuregs\[29\]\[3\] VGND VGND VPWR VPWR net1816 sky130_fd_sc_hd__dlygate4sd3_1
Xhold718 picorv32_core.cpuregs\[21\]\[2\] VGND VGND VPWR VPWR net1827 sky130_fd_sc_hd__dlygate4sd3_1
X_05090_ picorv32_core.instr_lui picorv32_core.instr_auipc VGND VGND VPWR VPWR _01623_
+ sky130_fd_sc_hd__or2_1
Xhold729 picorv32_core.cpuregs\[3\]\[10\] VGND VGND VPWR VPWR net1838 sky130_fd_sc_hd__dlygate4sd3_1
XFILLER_112_811 VGND VGND VPWR VPWR sky130_fd_sc_hd__fill_1
XFILLER_41_3 VPWR VGND VPWR VGND sky130_ef_sc_hd__decap_12
X_08780_ net225 net2189 net376 VGND VGND VPWR VPWR _00927_ sky130_fd_sc_hd__mux2_1
X_07800_ picorv32_core.cpuregs\[28\]\[16\] picorv32_core.cpuregs\[29\]\[16\] picorv32_core.cpuregs\[30\]\[16\]
+ picorv32_core.cpuregs\[31\]\[16\] net751 net718 VGND VGND VPWR VPWR _03889_ sky130_fd_sc_hd__mux4_1
XPHY_EDGE_ROW_127_Right_127 VGND VGND VPWR VPWR sky130_fd_sc_hd__decap_3
XFILLER_111_365 VGND VGND VPWR VPWR sky130_fd_sc_hd__fill_1
X_05992_ net507 _02454_ _02457_ VGND VGND VPWR VPWR picorv32_core.alu_out\[18\] sky130_fd_sc_hd__a21o_1
X_07731_ picorv32_core.cpuregs\[28\]\[12\] picorv32_core.cpuregs\[29\]\[12\] picorv32_core.cpuregs\[30\]\[12\]
+ picorv32_core.cpuregs\[31\]\[12\] net737 net704 VGND VGND VPWR VPWR _03824_ sky130_fd_sc_hd__mux4_1
XFILLER_38_622 VGND VGND VPWR VPWR sky130_fd_sc_hd__decap_4
XFILLER_93_783 VGND VGND VPWR VPWR sky130_fd_sc_hd__fill_1
X_07662_ picorv32_core.cpuregs\[8\]\[8\] picorv32_core.cpuregs\[9\]\[8\] picorv32_core.cpuregs\[10\]\[8\]
+ picorv32_core.cpuregs\[11\]\[8\] net739 net706 VGND VGND VPWR VPWR _03759_ sky130_fd_sc_hd__mux4_1
X_06613_ picorv32_core.count_instr\[53\] picorv32_core.count_instr\[52\] VGND VGND
+ VPWR VPWR _02890_ sky130_fd_sc_hd__and2_1
X_09401_ _03439_ _03484_ VGND VGND VPWR VPWR _04590_ sky130_fd_sc_hd__xor2_1
XFILLER_1_93 VPWR VGND VPWR VGND sky130_ef_sc_hd__decap_12
X_07593_ net966 net594 _03693_ _03694_ VGND VGND VPWR VPWR _00363_ sky130_fd_sc_hd__a22o_1
XTAP_TAPCELL_ROW_36_823 VGND VPWR sky130_fd_sc_hd__tapvpwrvgnd_1
XTAP_TAPCELL_ROW_36_834 VGND VPWR sky130_fd_sc_hd__tapvpwrvgnd_1
X_06544_ net2362 _02844_ _02846_ VGND VGND VPWR VPWR _00162_ sky130_fd_sc_hd__o21a_1
X_09332_ _03475_ _03477_ VGND VGND VPWR VPWR _04524_ sky130_fd_sc_hd__xnor2_1
XFILLER_80_499 VGND VGND VPWR VPWR sky130_fd_sc_hd__decap_8
X_09263_ net886 picorv32_core.cpuregs\[22\]\[4\] VGND VGND VPWR VPWR _04458_ sky130_fd_sc_hd__and2b_1
X_06475_ picorv32_core.count_instr\[2\] _02801_ _02802_ VGND VGND VPWR VPWR _00137_
+ sky130_fd_sc_hd__o21a_1
X_05426_ net910 net303 _01922_ _01926_ VGND VGND VPWR VPWR _01553_ sky130_fd_sc_hd__a31o_1
X_08214_ net1406 net475 _04184_ _04208_ VGND VGND VPWR VPWR _00460_ sky130_fd_sc_hd__a22o_1
X_09194_ picorv32_core.cpuregs\[6\]\[1\] picorv32_core.cpuregs\[7\]\[1\] net887 VGND
+ VGND VPWR VPWR _04392_ sky130_fd_sc_hd__mux2_1
Xpicorv32_axi_1106 VGND VGND VPWR VPWR picorv32_axi_1106/HI trace_data[33] sky130_fd_sc_hd__conb_1
X_05357_ _01854_ _01857_ _01855_ VGND VGND VPWR VPWR _01862_ sky130_fd_sc_hd__a21boi_1
X_08145_ picorv32_core.mem_rdata_q\[5\] net31 net521 VGND VGND VPWR VPWR _00746_ sky130_fd_sc_hd__mux2_1
XFILLER_4_209 VPWR VGND VPWR VGND sky130_ef_sc_hd__decap_12
X_08076_ picorv32_core.cpuregs\[4\]\[31\] picorv32_core.cpuregs\[5\]\[31\] picorv32_core.cpuregs\[6\]\[31\]
+ picorv32_core.cpuregs\[7\]\[31\] net762 net729 VGND VGND VPWR VPWR _04150_ sky130_fd_sc_hd__mux4_1
X_05288_ net821 net9 _01718_ _01797_ VGND VGND VPWR VPWR _01798_ sky130_fd_sc_hd__o211a_1
XTAP_TAPCELL_ROW_112_1936 VGND VPWR sky130_fd_sc_hd__tapvpwrvgnd_1
XTAP_TAPCELL_ROW_112_1925 VGND VPWR sky130_fd_sc_hd__tapvpwrvgnd_1
X_07027_ _03232_ _03233_ _03234_ VGND VGND VPWR VPWR _03236_ sky130_fd_sc_hd__or3_1
XFILLER_96_29 VGND VGND VPWR VPWR sky130_fd_sc_hd__fill_1
Xhold23 picorv32_core.cpuregs\[0\]\[27\] VGND VGND VPWR VPWR net1132 sky130_fd_sc_hd__dlygate4sd3_1
Xhold12 picorv32_core.cpuregs\[0\]\[12\] VGND VGND VPWR VPWR net1121 sky130_fd_sc_hd__dlygate4sd3_1
XTAP_TAPCELL_ROW_54_1087 VGND VPWR sky130_fd_sc_hd__tapvpwrvgnd_1
X_08978_ net1272 net231 net351 VGND VGND VPWR VPWR _01150_ sky130_fd_sc_hd__mux2_1
Xhold34 picorv32_core.cpuregs\[0\]\[30\] VGND VGND VPWR VPWR net1143 sky130_fd_sc_hd__dlygate4sd3_1
Xhold56 net135 VGND VGND VPWR VPWR net1165 sky130_fd_sc_hd__dlygate4sd3_1
Xhold45 net121 VGND VGND VPWR VPWR net1154 sky130_fd_sc_hd__dlygate4sd3_1
X_07929_ net187 net511 _04010_ _04011_ VGND VGND VPWR VPWR _00382_ sky130_fd_sc_hd__o22a_1
Xhold67 net113 VGND VGND VPWR VPWR net1176 sky130_fd_sc_hd__dlygate4sd3_1
Xhold89 picorv32_core.cpuregs\[20\]\[0\] VGND VGND VPWR VPWR net1198 sky130_fd_sc_hd__dlygate4sd3_1
Xhold78 _00453_ VGND VGND VPWR VPWR net1187 sky130_fd_sc_hd__dlygate4sd3_1
XFILLER_29_89 VGND VGND VPWR VPWR sky130_fd_sc_hd__fill_1
X_10940_ clknet_leaf_51_clk _00791_ VGND VGND VPWR VPWR picorv32_core.cpuregs\[19\]\[18\]
+ sky130_fd_sc_hd__dfxtp_1
XFILLER_43_113 VGND VGND VPWR VPWR sky130_fd_sc_hd__decap_3
X_10871_ clknet_leaf_18_clk _00722_ VGND VGND VPWR VPWR picorv32_core.cpuregs\[16\]\[15\]
+ sky130_fd_sc_hd__dfxtp_1
XFILLER_71_466 VGND VGND VPWR VPWR sky130_fd_sc_hd__decap_4
XTAP_TAPCELL_ROW_14_506 VGND VPWR sky130_fd_sc_hd__tapvpwrvgnd_1
XFILLER_52_691 VGND VGND VPWR VPWR sky130_fd_sc_hd__fill_1
XFILLER_12_522 VGND VGND VPWR VPWR sky130_fd_sc_hd__fill_1
XFILLER_8_537 VGND VGND VPWR VPWR sky130_fd_sc_hd__fill_1
X_11423_ clknet_leaf_142_clk _01259_ VGND VGND VPWR VPWR picorv32_core.cpuregs\[1\]\[6\]
+ sky130_fd_sc_hd__dfxtp_1
XANTENNA_9 _02778_ VGND VGND VPWR VPWR sky130_fd_sc_hd__diode_2
X_11354_ clknet_leaf_0_clk _01195_ VGND VGND VPWR VPWR picorv32_core.cpuregs\[18\]\[6\]
+ sky130_fd_sc_hd__dfxtp_1
X_10305_ clknet_leaf_59_clk _00224_ VGND VGND VPWR VPWR picorv32_core.reg_pc\[26\]
+ sky130_fd_sc_hd__dfxtp_2
XFILLER_79_500 VGND VGND VPWR VPWR sky130_fd_sc_hd__decap_4
X_11285_ clknet_leaf_1_clk _01133_ VGND VGND VPWR VPWR picorv32_core.cpuregs\[3\]\[8\]
+ sky130_fd_sc_hd__dfxtp_1
XFILLER_106_693 VGND VGND VPWR VPWR sky130_fd_sc_hd__decap_6
X_10236_ clknet_leaf_80_clk _00155_ VGND VGND VPWR VPWR picorv32_core.count_instr\[20\]
+ sky130_fd_sc_hd__dfxtp_1
XFILLER_39_408 VGND VGND VPWR VPWR sky130_fd_sc_hd__decap_3
X_10167_ clknet_leaf_19_clk _00086_ VGND VGND VPWR VPWR picorv32_core.cpuregs\[21\]\[15\]
+ sky130_fd_sc_hd__dfxtp_1
XFILLER_120_184 VGND VGND VPWR VPWR sky130_fd_sc_hd__decap_4
X_10098_ net1111 VGND VGND VPWR VPWR _00948_ sky130_fd_sc_hd__clkbuf_1
XFILLER_59_290 VGND VGND VPWR VPWR sky130_fd_sc_hd__fill_1
XTAP_TAPCELL_ROW_85_1537 VGND VPWR sky130_fd_sc_hd__tapvpwrvgnd_1
XFILLER_90_764 VGND VGND VPWR VPWR sky130_fd_sc_hd__fill_1
XFILLER_90_753 VGND VGND VPWR VPWR sky130_fd_sc_hd__decap_3
XFILLER_62_477 VPWR VGND VPWR VGND sky130_ef_sc_hd__decap_12
XFILLER_50_628 VGND VGND VPWR VPWR sky130_fd_sc_hd__decap_8
XFILLER_89_3 VGND VGND VPWR VPWR sky130_fd_sc_hd__decap_3
XFILLER_30_363 VGND VGND VPWR VPWR sky130_fd_sc_hd__fill_1
X_06260_ _02678_ _02681_ net563 VGND VGND VPWR VPWR _02682_ sky130_fd_sc_hd__mux2_1
X_05211_ net923 net918 net910 VGND VGND VPWR VPWR _01727_ sky130_fd_sc_hd__or3_2
XFILLER_129_785 VPWR VGND VPWR VGND sky130_ef_sc_hd__decap_12
X_06191_ _02601_ _02622_ _01591_ VGND VGND VPWR VPWR _00034_ sky130_fd_sc_hd__mux2_1
Xhold526 picorv32_core.cpuregs\[11\]\[23\] VGND VGND VPWR VPWR net1635 sky130_fd_sc_hd__dlygate4sd3_1
Xhold515 picorv32_core.cpuregs\[24\]\[17\] VGND VGND VPWR VPWR net1624 sky130_fd_sc_hd__dlygate4sd3_1
Xhold504 picorv32_core.cpuregs\[3\]\[7\] VGND VGND VPWR VPWR net1613 sky130_fd_sc_hd__dlygate4sd3_1
X_05142_ picorv32_core.mem_do_rinst picorv32_core.reg_pc\[1\] net980 _01670_ VGND
+ VGND VPWR VPWR _01672_ sky130_fd_sc_hd__a31o_1
Xhold559 picorv32_core.cpuregs\[27\]\[25\] VGND VGND VPWR VPWR net1668 sky130_fd_sc_hd__dlygate4sd3_1
Xhold548 picorv32_core.cpuregs\[3\]\[18\] VGND VGND VPWR VPWR net1657 sky130_fd_sc_hd__dlygate4sd3_1
XTAP_TAPCELL_ROW_96_1699 VGND VPWR sky130_fd_sc_hd__tapvpwrvgnd_1
X_05073_ net179 VGND VGND VPWR VPWR _01608_ sky130_fd_sc_hd__inv_2
Xhold537 picorv32_core.cpuregs\[25\]\[9\] VGND VGND VPWR VPWR net1646 sky130_fd_sc_hd__dlygate4sd3_1
X_09950_ net1255 net295 net316 VGND VGND VPWR VPWR _01428_ sky130_fd_sc_hd__mux2_1
XFILLER_131_449 VGND VGND VPWR VPWR sky130_fd_sc_hd__decap_3
X_08901_ net272 net2149 net360 VGND VGND VPWR VPWR _01075_ sky130_fd_sc_hd__mux2_1
XFILLER_97_352 VGND VGND VPWR VPWR sky130_fd_sc_hd__decap_3
X_09881_ net2128 net253 net326 VGND VGND VPWR VPWR _01369_ sky130_fd_sc_hd__mux2_1
XFILLER_85_503 VGND VGND VPWR VPWR sky130_fd_sc_hd__fill_1
Xhold1215 picorv32_core.instr_bgeu VGND VGND VPWR VPWR net2324 sky130_fd_sc_hd__dlygate4sd3_1
XFILLER_58_728 VGND VGND VPWR VPWR sky130_fd_sc_hd__fill_1
X_08832_ net1299 net290 net366 VGND VGND VPWR VPWR _01008_ sky130_fd_sc_hd__mux2_1
Xhold1204 picorv32_core.mem_state\[0\] VGND VGND VPWR VPWR net2313 sky130_fd_sc_hd__dlygate4sd3_1
XTAP_TAPCELL_ROW_127_2143 VGND VPWR sky130_fd_sc_hd__tapvpwrvgnd_1
Xhold1237 net45 VGND VGND VPWR VPWR net2346 sky130_fd_sc_hd__dlygate4sd3_1
Xhold1226 picorv32_core.count_cycle\[19\] VGND VGND VPWR VPWR net2335 sky130_fd_sc_hd__dlygate4sd3_1
XFILLER_85_558 VGND VGND VPWR VPWR sky130_fd_sc_hd__fill_2
X_05975_ _02441_ VGND VGND VPWR VPWR _02442_ sky130_fd_sc_hd__inv_2
Xhold1248 picorv32_core.cpu_state\[3\] VGND VGND VPWR VPWR net2357 sky130_fd_sc_hd__dlygate4sd3_1
X_08763_ net300 net1904 net374 VGND VGND VPWR VPWR _00910_ sky130_fd_sc_hd__mux2_1
XFILLER_122_27 VGND VGND VPWR VPWR sky130_fd_sc_hd__fill_1
XFILLER_66_783 VGND VGND VPWR VPWR sky130_fd_sc_hd__decap_4
X_07714_ picorv32_core.cpuregs\[4\]\[11\] picorv32_core.cpuregs\[5\]\[11\] picorv32_core.cpuregs\[6\]\[11\]
+ picorv32_core.cpuregs\[7\]\[11\] net736 net703 VGND VGND VPWR VPWR _03808_ sky130_fd_sc_hd__mux4_1
Xhold1259 picorv32_core.instr_sb VGND VGND VPWR VPWR net2368 sky130_fd_sc_hd__dlygate4sd3_1
XFILLER_38_441 VGND VGND VPWR VPWR sky130_fd_sc_hd__fill_2
XTAP_TAPCELL_ROW_140_2332 VGND VPWR sky130_fd_sc_hd__tapvpwrvgnd_1
XFILLER_53_411 VGND VGND VPWR VPWR sky130_fd_sc_hd__decap_4
X_08694_ net1543 net445 net382 VGND VGND VPWR VPWR _00843_ sky130_fd_sc_hd__mux2_1
XFILLER_80_241 VGND VGND VPWR VPWR sky130_fd_sc_hd__fill_2
X_07645_ _03732_ _03733_ net631 VGND VGND VPWR VPWR _03743_ sky130_fd_sc_hd__mux2_1
XFILLER_81_797 VGND VGND VPWR VPWR sky130_fd_sc_hd__fill_1
XFILLER_53_477 VGND VGND VPWR VPWR sky130_fd_sc_hd__fill_2
X_07576_ net624 _03675_ _03679_ VGND VGND VPWR VPWR _03680_ sky130_fd_sc_hd__a21oi_1
XTAP_TAPCELL_ROW_0_289 VGND VPWR sky130_fd_sc_hd__tapvpwrvgnd_1
X_06527_ net2330 _02833_ net996 VGND VGND VPWR VPWR _02836_ sky130_fd_sc_hd__o21ai_1
XFILLER_15_69 VGND VGND VPWR VPWR sky130_fd_sc_hd__decap_6
X_09315_ picorv32_core.cpuregs\[20\]\[6\] picorv32_core.cpuregs\[21\]\[6\] picorv32_core.cpuregs\[22\]\[6\]
+ picorv32_core.cpuregs\[23\]\[6\] net874 net841 VGND VGND VPWR VPWR _04508_ sky130_fd_sc_hd__mux4_1
XFILLER_33_190 VGND VGND VPWR VPWR sky130_fd_sc_hd__decap_3
X_06458_ net244 net1798 net419 VGND VGND VPWR VPWR _00124_ sky130_fd_sc_hd__mux2_1
X_09246_ picorv32_core.cpuregs\[16\]\[3\] picorv32_core.cpuregs\[17\]\[3\] picorv32_core.cpuregs\[18\]\[3\]
+ picorv32_core.cpuregs\[19\]\[3\] net884 net851 VGND VGND VPWR VPWR _04442_ sky130_fd_sc_hd__mux4_1
X_05409_ _01909_ _01910_ VGND VGND VPWR VPWR _01911_ sky130_fd_sc_hd__nand2_1
XFILLER_135_722 VGND VGND VPWR VPWR sky130_fd_sc_hd__decap_6
X_06389_ _02782_ _02785_ net564 VGND VGND VPWR VPWR _02786_ sky130_fd_sc_hd__mux2_1
X_09177_ picorv32_core.cpuregs\[28\]\[1\] picorv32_core.cpuregs\[29\]\[1\] net888
+ VGND VGND VPWR VPWR _04375_ sky130_fd_sc_hd__mux2_1
X_08128_ net237 net1821 net416 VGND VGND VPWR VPWR _00421_ sky130_fd_sc_hd__mux2_1
XFILLER_135_777 VGND VGND VPWR VPWR sky130_fd_sc_hd__decap_6
XFILLER_134_265 VGND VGND VPWR VPWR sky130_fd_sc_hd__fill_2
X_08059_ picorv32_core.cpuregs\[12\]\[30\] picorv32_core.cpuregs\[13\]\[30\] picorv32_core.cpuregs\[14\]\[30\]
+ picorv32_core.cpuregs\[15\]\[30\] net759 net726 VGND VGND VPWR VPWR _04134_ sky130_fd_sc_hd__mux4_1
XFILLER_107_468 VGND VGND VPWR VPWR sky130_fd_sc_hd__fill_1
XTAP_TAPCELL_ROW_56_1116 VGND VPWR sky130_fd_sc_hd__tapvpwrvgnd_1
Xoutput46 net46 VGND VGND VPWR VPWR mem_axi_araddr[17] sky130_fd_sc_hd__buf_2
Xoutput57 net57 VGND VGND VPWR VPWR mem_axi_araddr[28] sky130_fd_sc_hd__buf_2
X_11070_ clknet_leaf_21_clk _00921_ VGND VGND VPWR VPWR picorv32_core.cpuregs\[10\]\[20\]
+ sky130_fd_sc_hd__dfxtp_1
XFILLER_122_449 VGND VGND VPWR VPWR sky130_fd_sc_hd__decap_6
Xoutput79 net79 VGND VGND VPWR VPWR mem_axi_awaddr[18] sky130_fd_sc_hd__buf_2
X_10021_ net1830 net270 net309 VGND VGND VPWR VPWR _01497_ sky130_fd_sc_hd__mux2_1
Xoutput68 net68 VGND VGND VPWR VPWR mem_axi_araddr[9] sky130_fd_sc_hd__buf_2
XFILLER_49_739 VGND VGND VPWR VPWR sky130_fd_sc_hd__decap_8
XFILLER_48_238 VGND VGND VPWR VPWR sky130_fd_sc_hd__fill_2
XFILLER_72_775 VPWR VGND VPWR VGND sky130_ef_sc_hd__decap_12
X_10923_ clknet_leaf_113_clk _00774_ VGND VGND VPWR VPWR picorv32_core.cpuregs\[19\]\[1\]
+ sky130_fd_sc_hd__dfxtp_1
XFILLER_17_669 VGND VGND VPWR VPWR sky130_fd_sc_hd__decap_3
XPHY_EDGE_ROW_19_Right_19 VGND VGND VPWR VPWR sky130_fd_sc_hd__decap_3
X_10854_ clknet_leaf_65_clk _00705_ VGND VGND VPWR VPWR picorv32_core.cpuregs\[17\]\[31\]
+ sky130_fd_sc_hd__dfxtp_1
XTAP_TAPCELL_ROW_67_1278 VGND VPWR sky130_fd_sc_hd__tapvpwrvgnd_1
XTAP_TAPCELL_ROW_27_697 VGND VPWR sky130_fd_sc_hd__tapvpwrvgnd_1
X_10785_ clknet_leaf_46_clk _00636_ VGND VGND VPWR VPWR picorv32_core.cpuregs\[14\]\[26\]
+ sky130_fd_sc_hd__dfxtp_1
XTAP_TAPCELL_ROW_80_1467 VGND VPWR sky130_fd_sc_hd__tapvpwrvgnd_1
XFILLER_8_334 VGND VGND VPWR VPWR sky130_fd_sc_hd__fill_2
XFILLER_126_755 VGND VGND VPWR VPWR sky130_fd_sc_hd__fill_1
X_11406_ clknet_leaf_48_clk _01242_ VGND VGND VPWR VPWR picorv32_core.cpuregs\[31\]\[21\]
+ sky130_fd_sc_hd__dfxtp_1
X_11337_ clknet_leaf_47_clk _01178_ VGND VGND VPWR VPWR picorv32_core.cpuregs\[29\]\[21\]
+ sky130_fd_sc_hd__dfxtp_1
XFILLER_99_617 VGND VGND VPWR VPWR sky130_fd_sc_hd__fill_2
XPHY_EDGE_ROW_28_Right_28 VGND VGND VPWR VPWR sky130_fd_sc_hd__decap_3
XFILLER_4_584 VGND VGND VPWR VPWR sky130_fd_sc_hd__decap_4
XFILLER_141_769 VGND VGND VPWR VPWR sky130_fd_sc_hd__decap_4
X_11268_ clknet_leaf_44_clk _01116_ VGND VGND VPWR VPWR picorv32_core.cpuregs\[4\]\[23\]
+ sky130_fd_sc_hd__dfxtp_1
XFILLER_113_449 VGND VGND VPWR VPWR sky130_fd_sc_hd__fill_1
XFILLER_97_61 VGND VGND VPWR VPWR sky130_fd_sc_hd__fill_1
XFILLER_95_801 VGND VGND VPWR VPWR sky130_fd_sc_hd__fill_2
X_11199_ clknet_leaf_40_clk _01050_ VGND VGND VPWR VPWR picorv32_core.cpuregs\[6\]\[21\]
+ sky130_fd_sc_hd__dfxtp_1
X_10219_ clknet_leaf_103_clk _00138_ VGND VGND VPWR VPWR picorv32_core.count_instr\[3\]
+ sky130_fd_sc_hd__dfxtp_1
XFILLER_0_790 VGND VGND VPWR VPWR sky130_fd_sc_hd__decap_4
X_05760_ net971 _01615_ _02165_ _02240_ _02203_ VGND VGND VPWR VPWR _02244_ sky130_fd_sc_hd__o221a_1
XPHY_EDGE_ROW_37_Right_37 VGND VGND VPWR VPWR sky130_fd_sc_hd__decap_3
X_05691_ _02173_ _02174_ _02172_ VGND VGND VPWR VPWR _02175_ sky130_fd_sc_hd__a21o_1
X_07430_ net661 _03569_ _03568_ VGND VGND VPWR VPWR _03570_ sky130_fd_sc_hd__a21oi_1
XTAP_TAPCELL_ROW_122_2073 VGND VPWR sky130_fd_sc_hd__tapvpwrvgnd_1
XFILLER_63_797 VGND VGND VPWR VPWR sky130_fd_sc_hd__decap_8
XFILLER_35_499 VGND VGND VPWR VPWR sky130_fd_sc_hd__decap_4
XTAP_TAPCELL_ROW_46_973 VGND VPWR sky130_fd_sc_hd__tapvpwrvgnd_1
X_07361_ _03420_ _03422_ VGND VGND VPWR VPWR _03501_ sky130_fd_sc_hd__nor2_1
XFILLER_50_458 VGND VGND VPWR VPWR sky130_fd_sc_hd__decap_4
XFILLER_50_436 VPWR VGND VPWR VGND sky130_ef_sc_hd__decap_12
X_06312_ net1417 net272 net433 VGND VGND VPWR VPWR _00053_ sky130_fd_sc_hd__mux2_1
X_09100_ net272 net1618 net332 VGND VGND VPWR VPWR _01267_ sky130_fd_sc_hd__mux2_1
XTAP_TAPCELL_ROW_98_1728 VGND VPWR sky130_fd_sc_hd__tapvpwrvgnd_1
X_07292_ _03430_ _03431_ VGND VGND VPWR VPWR _03432_ sky130_fd_sc_hd__nand2_1
X_09031_ net290 net2161 net340 VGND VGND VPWR VPWR _01200_ sky130_fd_sc_hd__mux2_1
X_06243_ picorv32_core.reg_out\[0\] picorv32_core.alu_out_q\[0\] net950 VGND VGND
+ VPWR VPWR _02669_ sky130_fd_sc_hd__mux2_1
XPHY_EDGE_ROW_46_Right_46 VGND VGND VPWR VPWR sky130_fd_sc_hd__decap_3
Xhold301 picorv32_core.cpuregs\[16\]\[15\] VGND VGND VPWR VPWR net1410 sky130_fd_sc_hd__dlygate4sd3_1
X_06174_ picorv32_core.cpuregs\[4\]\[2\] picorv32_core.cpuregs\[5\]\[2\] picorv32_core.cpuregs\[6\]\[2\]
+ picorv32_core.cpuregs\[7\]\[2\] net742 net709 VGND VGND VPWR VPWR _02606_ sky130_fd_sc_hd__mux4_1
XFILLER_7_81 VPWR VGND VPWR VGND sky130_ef_sc_hd__decap_12
XFILLER_117_777 VGND VGND VPWR VPWR sky130_fd_sc_hd__decap_6
XFILLER_104_405 VPWR VGND VPWR VGND sky130_ef_sc_hd__decap_12
Xhold323 picorv32_core.cpuregs\[24\]\[18\] VGND VGND VPWR VPWR net1432 sky130_fd_sc_hd__dlygate4sd3_1
X_05125_ picorv32_core.instr_sub picorv32_core.instr_add picorv32_core.instr_andi
+ picorv32_core.instr_xori VGND VGND VPWR VPWR _01656_ sky130_fd_sc_hd__or4_1
Xhold334 picorv32_core.cpuregs\[24\]\[2\] VGND VGND VPWR VPWR net1443 sky130_fd_sc_hd__dlygate4sd3_1
Xhold312 picorv32_core.cpuregs\[23\]\[11\] VGND VGND VPWR VPWR net1421 sky130_fd_sc_hd__dlygate4sd3_1
Xhold378 picorv32_core.cpuregs\[15\]\[31\] VGND VGND VPWR VPWR net1487 sky130_fd_sc_hd__dlygate4sd3_1
XFILLER_89_105 VGND VGND VPWR VPWR sky130_fd_sc_hd__decap_6
Xhold356 picorv32_core.cpuregs\[28\]\[1\] VGND VGND VPWR VPWR net1465 sky130_fd_sc_hd__dlygate4sd3_1
Xhold345 picorv32_core.cpuregs\[3\]\[0\] VGND VGND VPWR VPWR net1454 sky130_fd_sc_hd__dlygate4sd3_1
Xhold367 picorv32_core.cpuregs\[7\]\[10\] VGND VGND VPWR VPWR net1476 sky130_fd_sc_hd__dlygate4sd3_1
XFILLER_132_769 VPWR VGND VPWR VGND sky130_ef_sc_hd__decap_12
XFILLER_89_138 VGND VGND VPWR VPWR sky130_fd_sc_hd__fill_1
Xfanout803 net804 VGND VGND VPWR VPWR net803 sky130_fd_sc_hd__buf_2
Xhold389 picorv32_core.cpuregs\[22\]\[5\] VGND VGND VPWR VPWR net1498 sky130_fd_sc_hd__dlygate4sd3_1
Xfanout814 net167 VGND VGND VPWR VPWR net814 sky130_fd_sc_hd__clkbuf_2
X_05056_ net913 VGND VGND VPWR VPWR _01591_ sky130_fd_sc_hd__inv_2
X_09933_ _03671_ picorv32_core.decoded_imm_j\[11\] picorv32_core.is_slli_srli_srai
+ VGND VGND VPWR VPWR _05035_ sky130_fd_sc_hd__mux2_1
Xfanout825 net827 VGND VGND VPWR VPWR net825 sky130_fd_sc_hd__buf_4
Xfanout858 net859 VGND VGND VPWR VPWR net858 sky130_fd_sc_hd__clkbuf_4
Xfanout847 net850 VGND VGND VPWR VPWR net847 sky130_fd_sc_hd__clkbuf_4
Xfanout836 net837 VGND VGND VPWR VPWR net836 sky130_fd_sc_hd__clkbuf_4
X_09864_ net1588 net497 net324 VGND VGND VPWR VPWR _01352_ sky130_fd_sc_hd__mux2_1
Xfanout869 net872 VGND VGND VPWR VPWR net869 sky130_fd_sc_hd__clkbuf_4
XFILLER_133_15 VPWR VGND VPWR VGND sky130_ef_sc_hd__decap_12
X_08815_ net219 net2066 net373 VGND VGND VPWR VPWR _00993_ sky130_fd_sc_hd__mux2_1
Xhold1012 picorv32_core.cpuregs\[6\]\[31\] VGND VGND VPWR VPWR net2121 sky130_fd_sc_hd__dlygate4sd3_1
XFILLER_112_493 VGND VGND VPWR VPWR sky130_fd_sc_hd__fill_1
XFILLER_100_622 VGND VGND VPWR VPWR sky130_fd_sc_hd__fill_2
Xhold1023 picorv32_core.cpuregs\[9\]\[17\] VGND VGND VPWR VPWR net2132 sky130_fd_sc_hd__dlygate4sd3_1
XTAP_TAPCELL_ROW_51_1046 VGND VPWR sky130_fd_sc_hd__tapvpwrvgnd_1
Xhold1001 picorv32_core.cpuregs\[16\]\[9\] VGND VGND VPWR VPWR net2110 sky130_fd_sc_hd__dlygate4sd3_1
X_09795_ net766 _03395_ VGND VGND VPWR VPWR _04966_ sky130_fd_sc_hd__and2_1
Xhold1034 picorv32_core.cpuregs\[11\]\[21\] VGND VGND VPWR VPWR net2143 sky130_fd_sc_hd__dlygate4sd3_1
Xhold1045 picorv32_core.cpuregs\[10\]\[12\] VGND VGND VPWR VPWR net2154 sky130_fd_sc_hd__dlygate4sd3_1
XPHY_EDGE_ROW_55_Right_55 VGND VGND VPWR VPWR sky130_fd_sc_hd__decap_3
Xhold1056 picorv32_core.cpuregs\[25\]\[10\] VGND VGND VPWR VPWR net2165 sky130_fd_sc_hd__dlygate4sd3_1
Xhold1067 picorv32_core.cpuregs\[29\]\[8\] VGND VGND VPWR VPWR net2176 sky130_fd_sc_hd__dlygate4sd3_1
X_08746_ net1665 net228 net380 VGND VGND VPWR VPWR _00894_ sky130_fd_sc_hd__mux2_1
Xhold1078 net61 VGND VGND VPWR VPWR net2187 sky130_fd_sc_hd__dlygate4sd3_1
Xhold1089 picorv32_core.cpuregs\[1\]\[18\] VGND VGND VPWR VPWR net2198 sky130_fd_sc_hd__dlygate4sd3_1
X_05958_ _02380_ _02382_ _02425_ VGND VGND VPWR VPWR _02426_ sky130_fd_sc_hd__a21oi_1
XTAP_TAPCELL_ROW_107_1857 VGND VPWR sky130_fd_sc_hd__tapvpwrvgnd_1
X_08677_ net242 net1654 net388 VGND VGND VPWR VPWR _00827_ sky130_fd_sc_hd__mux2_1
X_05889_ net509 _02359_ _02362_ VGND VGND VPWR VPWR picorv32_core.alu_out\[10\] sky130_fd_sc_hd__a21o_1
XFILLER_13_105 VGND VGND VPWR VPWR sky130_fd_sc_hd__decap_6
X_07628_ _03717_ _03718_ net627 VGND VGND VPWR VPWR _03727_ sky130_fd_sc_hd__mux2_1
XFILLER_9_109 VGND VGND VPWR VPWR sky130_fd_sc_hd__decap_3
X_07559_ _03662_ _03663_ net694 VGND VGND VPWR VPWR _03664_ sky130_fd_sc_hd__mux2_1
XTAP_TAPCELL_ROW_24_656 VGND VPWR sky130_fd_sc_hd__tapvpwrvgnd_1
XFILLER_139_346 VGND VGND VPWR VPWR sky130_fd_sc_hd__fill_2
X_10570_ clknet_leaf_47_clk _00424_ VGND VGND VPWR VPWR picorv32_core.cpuregs\[25\]\[26\]
+ sky130_fd_sc_hd__dfxtp_1
XPHY_EDGE_ROW_64_Right_64 VGND VGND VPWR VPWR sky130_fd_sc_hd__decap_3
XTAP_TAPCELL_ROW_62_1197 VGND VPWR sky130_fd_sc_hd__tapvpwrvgnd_1
XFILLER_6_805 VGND VGND VPWR VPWR sky130_fd_sc_hd__decap_6
X_09229_ _03457_ _03463_ _03462_ _03458_ VGND VGND VPWR VPWR _04426_ sky130_fd_sc_hd__a211o_1
XFILLER_5_337 VGND VGND VPWR VPWR sky130_fd_sc_hd__decap_3
XPHY_EDGE_ROW_2_Left_144 VGND VGND VPWR VPWR sky130_fd_sc_hd__decap_3
Xhold890 picorv32_core.cpuregs\[10\]\[24\] VGND VGND VPWR VPWR net1999 sky130_fd_sc_hd__dlygate4sd3_1
X_11122_ clknet_leaf_129_clk _00973_ VGND VGND VPWR VPWR picorv32_core.cpuregs\[8\]\[8\]
+ sky130_fd_sc_hd__dfxtp_1
XFILLER_107_82 VGND VGND VPWR VPWR sky130_fd_sc_hd__fill_1
X_11053_ clknet_leaf_117_clk _00904_ VGND VGND VPWR VPWR picorv32_core.cpuregs\[10\]\[3\]
+ sky130_fd_sc_hd__dfxtp_1
XFILLER_3_39 VPWR VGND VPWR VGND sky130_ef_sc_hd__decap_12
X_10004_ net1576 net206 net315 VGND VGND VPWR VPWR _01481_ sky130_fd_sc_hd__mux2_1
XPHY_EDGE_ROW_73_Right_73 VGND VGND VPWR VPWR sky130_fd_sc_hd__decap_3
XFILLER_49_558 VGND VGND VPWR VPWR sky130_fd_sc_hd__fill_2
XTAP_TAPCELL_ROW_69_1307 VGND VPWR sky130_fd_sc_hd__tapvpwrvgnd_1
XFILLER_64_517 VGND VGND VPWR VPWR sky130_fd_sc_hd__decap_6
XTAP_TAPCELL_ROW_4_370 VGND VPWR sky130_fd_sc_hd__tapvpwrvgnd_1
XFILLER_17_422 VGND VGND VPWR VPWR sky130_fd_sc_hd__fill_1
XFILLER_123_81 VGND VGND VPWR VPWR sky130_fd_sc_hd__decap_4
XFILLER_17_444 VGND VGND VPWR VPWR sky130_fd_sc_hd__decap_4
XFILLER_44_230 VGND VGND VPWR VPWR sky130_fd_sc_hd__fill_1
XFILLER_45_764 VGND VGND VPWR VPWR sky130_fd_sc_hd__decap_4
X_10906_ clknet_leaf_83_clk _00757_ VGND VGND VPWR VPWR picorv32_core.mem_rdata_q\[16\]
+ sky130_fd_sc_hd__dfxtp_1
XFILLER_72_583 VGND VGND VPWR VPWR sky130_fd_sc_hd__decap_4
XFILLER_60_701 VGND VGND VPWR VPWR sky130_fd_sc_hd__fill_1
XFILLER_32_403 VGND VGND VPWR VPWR sky130_fd_sc_hd__fill_1
XTAP_TAPCELL_ROW_43_932 VGND VPWR sky130_fd_sc_hd__tapvpwrvgnd_1
XPHY_EDGE_ROW_82_Right_82 VGND VGND VPWR VPWR sky130_fd_sc_hd__decap_3
X_10837_ clknet_leaf_8_clk _00688_ VGND VGND VPWR VPWR picorv32_core.cpuregs\[17\]\[14\]
+ sky130_fd_sc_hd__dfxtp_1
X_10768_ clknet_leaf_0_clk _00619_ VGND VGND VPWR VPWR picorv32_core.cpuregs\[14\]\[9\]
+ sky130_fd_sc_hd__dfxtp_1
X_10699_ clknet_leaf_4_clk _00550_ VGND VGND VPWR VPWR net135 sky130_fd_sc_hd__dfxtp_1
XFILLER_8_197 VGND VGND VPWR VPWR sky130_fd_sc_hd__fill_2
XPHY_EDGE_ROW_57_Left_199 VGND VGND VPWR VPWR sky130_fd_sc_hd__decap_3
XTAP_TAPCELL_ROW_93_1658 VGND VPWR sky130_fd_sc_hd__tapvpwrvgnd_1
XTAP_TAPCELL_ROW_93_1647 VGND VPWR sky130_fd_sc_hd__tapvpwrvgnd_1
XFILLER_114_769 VPWR VGND VPWR VGND sky130_ef_sc_hd__decap_12
XFILLER_101_408 VGND VGND VPWR VPWR sky130_fd_sc_hd__fill_1
XPHY_EDGE_ROW_91_Right_91 VGND VGND VPWR VPWR sky130_fd_sc_hd__decap_3
X_06930_ _03143_ _03145_ VGND VGND VPWR VPWR _03147_ sky130_fd_sc_hd__nor2_1
XFILLER_67_311 VGND VGND VPWR VPWR sky130_fd_sc_hd__decap_6
XTAP_TAPCELL_ROW_124_2102 VGND VPWR sky130_fd_sc_hd__tapvpwrvgnd_1
X_08600_ net267 net1922 net396 VGND VGND VPWR VPWR _00723_ sky130_fd_sc_hd__mux2_1
X_06861_ _03081_ _03082_ VGND VGND VPWR VPWR _03083_ sky130_fd_sc_hd__nand2_1
XTAP_TAPCELL_ROW_2_329 VGND VPWR sky130_fd_sc_hd__tapvpwrvgnd_1
X_09580_ net777 net547 VGND VGND VPWR VPWR _04761_ sky130_fd_sc_hd__or2_1
XFILLER_55_528 VGND VGND VPWR VPWR sky130_fd_sc_hd__fill_2
X_06792_ net674 _03018_ _03019_ _03014_ VGND VGND VPWR VPWR _03020_ sky130_fd_sc_hd__a31o_1
XFILLER_48_580 VGND VGND VPWR VPWR sky130_fd_sc_hd__decap_8
X_05812_ net813 net965 net573 VGND VGND VPWR VPWR _02292_ sky130_fd_sc_hd__a21oi_1
X_05743_ net777 _02172_ net187 VGND VGND VPWR VPWR _02227_ sky130_fd_sc_hd__or3b_1
X_08531_ net1282 net264 net404 VGND VGND VPWR VPWR _00658_ sky130_fd_sc_hd__mux2_1
XFILLER_36_753 VGND VGND VPWR VPWR sky130_fd_sc_hd__decap_3
X_05674_ _02156_ _02157_ VGND VGND VPWR VPWR _02158_ sky130_fd_sc_hd__nand2_1
XFILLER_35_241 VGND VGND VPWR VPWR sky130_fd_sc_hd__fill_2
X_08462_ net674 picorv32_core.decoded_imm_j\[6\] _04283_ picorv32_core.mem_rdata_q\[26\]
+ net524 VGND VGND VPWR VPWR _04312_ sky130_fd_sc_hd__a221o_1
X_07413_ net903 picorv32_core.cpuregs\[7\]\[31\] net871 VGND VGND VPWR VPWR _03553_
+ sky130_fd_sc_hd__a21bo_1
X_08393_ net2279 net461 _04272_ _03583_ VGND VGND VPWR VPWR _00574_ sky130_fd_sc_hd__o22a_1
XTAP_TAPCELL_ROW_102_1787 VGND VPWR sky130_fd_sc_hd__tapvpwrvgnd_1
X_07344_ _03446_ _03482_ _03445_ VGND VGND VPWR VPWR _03484_ sky130_fd_sc_hd__o21a_1
XFILLER_50_277 VGND VGND VPWR VPWR sky130_fd_sc_hd__decap_3
XTAP_TAPCELL_ROW_21_604 VGND VPWR sky130_fd_sc_hd__tapvpwrvgnd_1
XTAP_TAPCELL_ROW_21_615 VGND VPWR sky130_fd_sc_hd__tapvpwrvgnd_1
X_07275_ _03413_ _03414_ VGND VGND VPWR VPWR _03415_ sky130_fd_sc_hd__nand2_1
XFILLER_12_26 VGND VGND VPWR VPWR sky130_fd_sc_hd__fill_2
XTAP_TAPCELL_ROW_135_2264 VGND VPWR sky130_fd_sc_hd__tapvpwrvgnd_1
XFILLER_128_15 VPWR VGND VPWR VGND sky130_ef_sc_hd__decap_12
X_09014_ net221 net1918 net346 VGND VGND VPWR VPWR _01184_ sky130_fd_sc_hd__mux2_1
X_06226_ picorv32_core.cpuregs\[24\]\[4\] picorv32_core.cpuregs\[25\]\[4\] picorv32_core.cpuregs\[26\]\[4\]
+ picorv32_core.cpuregs\[27\]\[4\] net744 net711 VGND VGND VPWR VPWR _02656_ sky130_fd_sc_hd__mux4_1
Xhold120 picorv32_core.cpuregs\[27\]\[28\] VGND VGND VPWR VPWR net1229 sky130_fd_sc_hd__dlygate4sd3_1
Xhold153 picorv32_core.cpuregs\[24\]\[25\] VGND VGND VPWR VPWR net1262 sky130_fd_sc_hd__dlygate4sd3_1
Xhold131 picorv32_core.cpuregs\[26\]\[24\] VGND VGND VPWR VPWR net1240 sky130_fd_sc_hd__dlygate4sd3_1
Xhold142 picorv32_core.cpuregs\[20\]\[22\] VGND VGND VPWR VPWR net1251 sky130_fd_sc_hd__dlygate4sd3_1
XFILLER_105_725 VGND VGND VPWR VPWR sky130_fd_sc_hd__decap_3
X_06157_ net2301 net14 net520 VGND VGND VPWR VPWR _00760_ sky130_fd_sc_hd__mux2_1
X_06088_ _02519_ _02529_ VGND VGND VPWR VPWR _02546_ sky130_fd_sc_hd__and2_1
Xhold186 picorv32_core.cpuregs\[26\]\[19\] VGND VGND VPWR VPWR net1295 sky130_fd_sc_hd__dlygate4sd3_1
Xhold164 picorv32_core.cpuregs\[17\]\[12\] VGND VGND VPWR VPWR net1273 sky130_fd_sc_hd__dlygate4sd3_1
Xhold175 picorv32_core.cpuregs\[11\]\[7\] VGND VGND VPWR VPWR net1284 sky130_fd_sc_hd__dlygate4sd3_1
X_05108_ _01639_ VGND VGND VPWR VPWR _01640_ sky130_fd_sc_hd__inv_2
Xfanout600 net601 VGND VGND VPWR VPWR net600 sky130_fd_sc_hd__clkbuf_2
Xfanout611 net612 VGND VGND VPWR VPWR net611 sky130_fd_sc_hd__buf_2
X_09916_ net266 net2120 net322 VGND VGND VPWR VPWR _01400_ sky130_fd_sc_hd__mux2_1
Xfanout622 _01621_ VGND VGND VPWR VPWR net622 sky130_fd_sc_hd__buf_4
Xhold197 picorv32_core.cpuregs\[19\]\[2\] VGND VGND VPWR VPWR net1306 sky130_fd_sc_hd__dlygate4sd3_1
Xfanout633 net641 VGND VGND VPWR VPWR net633 sky130_fd_sc_hd__clkbuf_2
Xfanout666 net667 VGND VGND VPWR VPWR net666 sky130_fd_sc_hd__clkbuf_4
XFILLER_58_333 VGND VGND VPWR VPWR sky130_fd_sc_hd__fill_1
Xfanout644 _01618_ VGND VGND VPWR VPWR net644 sky130_fd_sc_hd__clkbuf_4
Xfanout655 net662 VGND VGND VPWR VPWR net655 sky130_fd_sc_hd__clkbuf_4
X_09847_ net660 _05015_ VGND VGND VPWR VPWR _05016_ sky130_fd_sc_hd__or2_1
Xfanout677 net678 VGND VGND VPWR VPWR net677 sky130_fd_sc_hd__buf_2
Xfanout688 net691 VGND VGND VPWR VPWR net688 sky130_fd_sc_hd__buf_4
Xfanout699 net708 VGND VGND VPWR VPWR net699 sky130_fd_sc_hd__clkbuf_4
XFILLER_100_485 VGND VGND VPWR VPWR sky130_fd_sc_hd__fill_1
X_09778_ net611 _04946_ _04948_ _04949_ net487 VGND VGND VPWR VPWR _04950_ sky130_fd_sc_hd__a2111o_1
XFILLER_58_388 VGND VGND VPWR VPWR sky130_fd_sc_hd__fill_2
XTAP_TAPCELL_ROW_29_726 VGND VPWR sky130_fd_sc_hd__tapvpwrvgnd_1
XFILLER_73_369 VGND VGND VPWR VPWR sky130_fd_sc_hd__fill_1
XFILLER_39_591 VGND VGND VPWR VPWR sky130_fd_sc_hd__fill_1
X_08729_ net1312 net426 net378 VGND VGND VPWR VPWR _00877_ sky130_fd_sc_hd__mux2_1
XFILLER_27_797 VPWR VGND VPWR VGND sky130_ef_sc_hd__decap_12
XFILLER_81_391 VGND VGND VPWR VPWR sky130_fd_sc_hd__fill_1
XTAP_TAPCELL_ROW_64_1237 VGND VPWR sky130_fd_sc_hd__tapvpwrvgnd_1
XTAP_TAPCELL_ROW_64_1226 VGND VPWR sky130_fd_sc_hd__tapvpwrvgnd_1
XFILLER_41_222 VGND VGND VPWR VPWR sky130_fd_sc_hd__fill_2
X_11671_ clknet_leaf_50_clk _01502_ VGND VGND VPWR VPWR picorv32_core.cpuregs\[26\]\[20\]
+ sky130_fd_sc_hd__dfxtp_1
XFILLER_14_469 VGND VGND VPWR VPWR sky130_fd_sc_hd__fill_1
X_10622_ clknet_leaf_94_clk _00476_ VGND VGND VPWR VPWR picorv32_core.decoded_imm_j\[6\]
+ sky130_fd_sc_hd__dfxtp_1
X_10553_ clknet_leaf_140_clk _00407_ VGND VGND VPWR VPWR picorv32_core.cpuregs\[25\]\[9\]
+ sky130_fd_sc_hd__dfxtp_1
X_10484_ clknet_leaf_16_clk _00370_ VGND VGND VPWR VPWR net174 sky130_fd_sc_hd__dfxtp_1
XFILLER_123_500 VGND VGND VPWR VPWR sky130_fd_sc_hd__decap_4
XFILLER_5_167 VGND VGND VPWR VPWR sky130_fd_sc_hd__fill_1
XFILLER_135_393 VGND VGND VPWR VPWR sky130_fd_sc_hd__fill_2
XFILLER_135_382 VGND VGND VPWR VPWR sky130_fd_sc_hd__fill_1
XTAP_TAPCELL_ROW_9_440 VGND VPWR sky130_fd_sc_hd__tapvpwrvgnd_1
X_11105_ clknet_leaf_44_clk _00956_ VGND VGND VPWR VPWR picorv32_core.cpuregs\[0\]\[23\]
+ sky130_fd_sc_hd__dfxtp_1
XTAP_TAPCELL_ROW_75_1399 VGND VPWR sky130_fd_sc_hd__tapvpwrvgnd_1
XTAP_TAPCELL_ROW_75_1388 VGND VPWR sky130_fd_sc_hd__tapvpwrvgnd_1
XFILLER_77_642 VPWR VGND VPWR VGND sky130_ef_sc_hd__decap_12
XFILLER_92_601 VPWR VGND VPWR VGND sky130_ef_sc_hd__decap_12
X_11036_ clknet_leaf_20_clk _00887_ VGND VGND VPWR VPWR picorv32_core.cpuregs\[11\]\[18\]
+ sky130_fd_sc_hd__dfxtp_1
XFILLER_76_141 VGND VGND VPWR VPWR sky130_fd_sc_hd__fill_1
XFILLER_92_645 VGND VGND VPWR VPWR sky130_fd_sc_hd__fill_2
XFILLER_18_753 VGND VGND VPWR VPWR sky130_fd_sc_hd__decap_3
XFILLER_17_241 VGND VGND VPWR VPWR sky130_fd_sc_hd__fill_2
X_05390_ _01880_ _01888_ _01892_ VGND VGND VPWR VPWR _01893_ sky130_fd_sc_hd__nand3_1
X_07060_ net933 _02942_ VGND VGND VPWR VPWR _03266_ sky130_fd_sc_hd__xor2_1
XPHY_EDGE_ROW_65_Left_207 VGND VGND VPWR VPWR sky130_fd_sc_hd__decap_3
X_06011_ _02452_ _02463_ VGND VGND VPWR VPWR _02475_ sky130_fd_sc_hd__nor2_1
XFILLER_99_211 VGND VGND VPWR VPWR sky130_fd_sc_hd__fill_1
Xoutput203 net961 VGND VGND VPWR VPWR pcpi_rs2[8] sky130_fd_sc_hd__buf_2
XFILLER_141_374 VGND VGND VPWR VPWR sky130_fd_sc_hd__fill_1
XTAP_TAPCELL_ROW_130_2194 VGND VPWR sky130_fd_sc_hd__tapvpwrvgnd_1
XTAP_TAPCELL_ROW_130_2183 VGND VPWR sky130_fd_sc_hd__tapvpwrvgnd_1
XFILLER_87_417 VGND VGND VPWR VPWR sky130_fd_sc_hd__fill_2
X_09701_ picorv32_core.cpuregs\[12\]\[23\] picorv32_core.cpuregs\[13\]\[23\] picorv32_core.cpuregs\[14\]\[23\]
+ picorv32_core.cpuregs\[15\]\[23\] net898 net865 VGND VGND VPWR VPWR _04877_ sky130_fd_sc_hd__mux4_1
X_07962_ picorv32_core.decoded_imm\[24\] net592 net596 VGND VGND VPWR VPWR _04043_
+ sky130_fd_sc_hd__a21o_1
XFILLER_68_631 VGND VGND VPWR VPWR sky130_fd_sc_hd__decap_3
X_07893_ picorv32_core.cpuregs\[16\]\[21\] picorv32_core.cpuregs\[17\]\[21\] picorv32_core.cpuregs\[18\]\[21\]
+ picorv32_core.cpuregs\[19\]\[21\] net755 net722 VGND VGND VPWR VPWR _03977_ sky130_fd_sc_hd__mux4_1
X_06913_ picorv32_core.decoded_imm_j\[18\] _02930_ VGND VGND VPWR VPWR _03131_ sky130_fd_sc_hd__nand2_1
XPHY_EDGE_ROW_74_Left_216 VGND VGND VPWR VPWR sky130_fd_sc_hd__decap_3
XFILLER_68_664 VGND VGND VPWR VPWR sky130_fd_sc_hd__decap_3
XFILLER_68_642 VGND VGND VPWR VPWR sky130_fd_sc_hd__fill_2
X_09632_ picorv32_core.cpuregs\[8\]\[20\] picorv32_core.cpuregs\[9\]\[20\] picorv32_core.cpuregs\[10\]\[20\]
+ picorv32_core.cpuregs\[11\]\[20\] net892 net858 VGND VGND VPWR VPWR _04811_ sky130_fd_sc_hd__mux4_1
XFILLER_83_623 VGND VGND VPWR VPWR sky130_fd_sc_hd__fill_2
X_06844_ picorv32_core.decoded_imm_j\[13\] _02925_ VGND VGND VPWR VPWR _03067_ sky130_fd_sc_hd__or2_1
X_09563_ picorv32_core.cpuregs\[4\]\[17\] picorv32_core.cpuregs\[5\]\[17\] picorv32_core.cpuregs\[6\]\[17\]
+ picorv32_core.cpuregs\[7\]\[17\] net889 net855 VGND VGND VPWR VPWR _04745_ sky130_fd_sc_hd__mux4_1
XFILLER_130_27 VGND VGND VPWR VPWR sky130_fd_sc_hd__fill_1
XTAP_TAPCELL_ROW_104_1816 VGND VPWR sky130_fd_sc_hd__tapvpwrvgnd_1
X_06775_ _03000_ _03001_ _03003_ VGND VGND VPWR VPWR _03004_ sky130_fd_sc_hd__a21oi_1
X_08514_ _04322_ _04325_ VGND VGND VPWR VPWR _04326_ sky130_fd_sc_hd__nor2_2
XFILLER_24_701 VGND VGND VPWR VPWR sky130_fd_sc_hd__fill_2
XFILLER_36_561 VGND VGND VPWR VPWR sky130_fd_sc_hd__fill_1
X_09494_ picorv32_core.cpuregs\[4\]\[14\] picorv32_core.cpuregs\[5\]\[14\] picorv32_core.cpuregs\[6\]\[14\]
+ picorv32_core.cpuregs\[7\]\[14\] net879 net846 VGND VGND VPWR VPWR _04679_ sky130_fd_sc_hd__mux4_1
X_05726_ net819 _01603_ _02134_ VGND VGND VPWR VPWR _02210_ sky130_fd_sc_hd__o21a_1
X_08445_ net676 picorv32_core.decoded_imm_j\[14\] net615 net929 VGND VGND VPWR VPWR
+ _04303_ sky130_fd_sc_hd__a22o_1
X_05657_ _02129_ _02133_ _02140_ _02130_ VGND VGND VPWR VPWR _02141_ sky130_fd_sc_hd__or4b_1
X_05588_ _02032_ _02042_ VGND VGND VPWR VPWR _02076_ sky130_fd_sc_hd__nand2b_1
X_08376_ net191 net581 net452 _04241_ VGND VGND VPWR VPWR _04263_ sky130_fd_sc_hd__a211o_2
XPHY_EDGE_ROW_83_Left_225 VGND VGND VPWR VPWR sky130_fd_sc_hd__decap_3
XTAP_TAPCELL_ROW_34_795 VGND VPWR sky130_fd_sc_hd__tapvpwrvgnd_1
X_07327_ _03457_ _03464_ _03466_ VGND VGND VPWR VPWR _03467_ sky130_fd_sc_hd__a21o_1
XFILLER_139_69 VPWR VGND VPWR VGND sky130_ef_sc_hd__decap_12
XFILLER_125_809 VPWR VGND VPWR VGND sky130_ef_sc_hd__decap_12
X_07258_ net764 picorv32_core.decoded_imm\[30\] VGND VGND VPWR VPWR _03398_ sky130_fd_sc_hd__or2_1
X_07189_ _03349_ _03350_ VGND VGND VPWR VPWR _00303_ sky130_fd_sc_hd__nor2_1
X_06209_ net688 _02635_ _02639_ VGND VGND VPWR VPWR _02640_ sky130_fd_sc_hd__a21o_1
XTAP_TAPCELL_ROW_115_1978 VGND VPWR sky130_fd_sc_hd__tapvpwrvgnd_1
XTAP_TAPCELL_ROW_115_1967 VGND VPWR sky130_fd_sc_hd__tapvpwrvgnd_1
XFILLER_105_577 VPWR VGND VPWR VGND sky130_ef_sc_hd__decap_12
XPHY_EDGE_ROW_92_Left_234 VGND VGND VPWR VPWR sky130_fd_sc_hd__decap_3
Xfanout441 _02599_ VGND VGND VPWR VPWR net441 sky130_fd_sc_hd__buf_2
Xfanout430 net432 VGND VGND VPWR VPWR net430 sky130_fd_sc_hd__clkbuf_2
XFILLER_120_569 VGND VGND VPWR VPWR sky130_fd_sc_hd__fill_2
Xfanout463 net464 VGND VGND VPWR VPWR net463 sky130_fd_sc_hd__buf_4
Xfanout452 net453 VGND VGND VPWR VPWR net452 sky130_fd_sc_hd__clkbuf_2
XFILLER_58_141 VGND VGND VPWR VPWR sky130_fd_sc_hd__fill_1
Xfanout474 _01690_ VGND VGND VPWR VPWR net474 sky130_fd_sc_hd__clkbuf_4
XFILLER_47_815 VGND VGND VPWR VPWR sky130_fd_sc_hd__fill_2
XFILLER_48_55 VGND VGND VPWR VPWR sky130_fd_sc_hd__fill_1
Xfanout496 _02674_ VGND VGND VPWR VPWR net496 sky130_fd_sc_hd__clkbuf_2
Xfanout485 net486 VGND VGND VPWR VPWR net485 sky130_fd_sc_hd__buf_2
XFILLER_74_645 VGND VGND VPWR VPWR sky130_fd_sc_hd__fill_2
XFILLER_62_807 VGND VGND VPWR VPWR sky130_fd_sc_hd__fill_1
XFILLER_0_29 VPWR VGND VPWR VGND sky130_ef_sc_hd__decap_12
XFILLER_42_531 VGND VGND VPWR VPWR sky130_fd_sc_hd__fill_1
X_11654_ clknet_leaf_118_clk _01485_ VGND VGND VPWR VPWR picorv32_core.cpuregs\[26\]\[3\]
+ sky130_fd_sc_hd__dfxtp_1
XFILLER_30_748 VGND VGND VPWR VPWR sky130_fd_sc_hd__decap_8
XFILLER_42_575 VGND VGND VPWR VPWR sky130_fd_sc_hd__decap_4
X_10605_ clknet_leaf_97_clk _00459_ VGND VGND VPWR VPWR picorv32_core.instr_sub sky130_fd_sc_hd__dfxtp_1
XFILLER_127_113 VGND VGND VPWR VPWR sky130_fd_sc_hd__fill_2
XTAP_TAPCELL_ROW_12_478 VGND VPWR sky130_fd_sc_hd__tapvpwrvgnd_1
X_11585_ clknet_leaf_121_clk net2289 VGND VGND VPWR VPWR picorv32_core.reg_sh\[0\]
+ sky130_fd_sc_hd__dfxtp_1
X_10536_ clknet_leaf_47_clk picorv32_core.alu_out\[24\] VGND VGND VPWR VPWR picorv32_core.alu_out_q\[24\]
+ sky130_fd_sc_hd__dfxtp_1
XTAP_TAPCELL_ROW_77_1428 VGND VPWR sky130_fd_sc_hd__tapvpwrvgnd_1
XTAP_TAPCELL_ROW_77_1417 VGND VPWR sky130_fd_sc_hd__tapvpwrvgnd_1
XFILLER_6_432 VGND VGND VPWR VPWR sky130_fd_sc_hd__decap_4
XFILLER_6_421 VGND VGND VPWR VPWR sky130_fd_sc_hd__fill_2
XPHY_EDGE_ROW_108_Right_108 VGND VGND VPWR VPWR sky130_fd_sc_hd__decap_3
X_10467_ clknet_leaf_73_clk _00354_ VGND VGND VPWR VPWR net60 sky130_fd_sc_hd__dfxtp_1
XFILLER_108_393 VGND VGND VPWR VPWR sky130_fd_sc_hd__decap_3
XTAP_TAPCELL_ROW_90_1606 VGND VPWR sky130_fd_sc_hd__tapvpwrvgnd_1
X_10398_ clknet_leaf_77_clk _00317_ VGND VGND VPWR VPWR picorv32_core.count_cycle\[56\]
+ sky130_fd_sc_hd__dfxtp_1
XTAP_TAPCELL_ROW_90_1617 VGND VPWR sky130_fd_sc_hd__tapvpwrvgnd_1
XFILLER_111_514 VGND VGND VPWR VPWR sky130_fd_sc_hd__fill_2
XFILLER_111_569 VPWR VGND VPWR VGND sky130_ef_sc_hd__decap_12
XFILLER_1_181 VPWR VGND VPWR VGND sky130_ef_sc_hd__decap_12
X_11019_ clknet_leaf_114_clk _00870_ VGND VGND VPWR VPWR picorv32_core.cpuregs\[11\]\[1\]
+ sky130_fd_sc_hd__dfxtp_1
XFILLER_65_645 VGND VGND VPWR VPWR sky130_fd_sc_hd__fill_2
XFILLER_92_464 VGND VGND VPWR VPWR sky130_fd_sc_hd__fill_1
XTAP_TAPCELL_ROW_88_1579 VGND VPWR sky130_fd_sc_hd__tapvpwrvgnd_1
XFILLER_64_166 VGND VGND VPWR VPWR sky130_fd_sc_hd__decap_3
X_06560_ picorv32_core.count_instr\[33\] _02854_ _02856_ VGND VGND VPWR VPWR _00168_
+ sky130_fd_sc_hd__o21a_1
X_05511_ picorv32_core.reg_pc\[22\] picorv32_core.decoded_imm\[22\] VGND VGND VPWR
+ VPWR _02005_ sky130_fd_sc_hd__or2_1
X_06491_ picorv32_core.count_instr\[8\] _02810_ _02812_ VGND VGND VPWR VPWR _00143_
+ sky130_fd_sc_hd__o21a_1
X_05442_ _01936_ _01940_ _01941_ VGND VGND VPWR VPWR _01554_ sky130_fd_sc_hd__or3_1
X_08230_ _04195_ _04214_ _04215_ _04216_ VGND VGND VPWR VPWR _04217_ sky130_fd_sc_hd__or4_1
XFILLER_21_726 VGND VGND VPWR VPWR sky130_fd_sc_hd__fill_2
XFILLER_33_586 VGND VGND VPWR VPWR sky130_fd_sc_hd__decap_6
XTAP_TAPCELL_ROW_119_2034 VGND VPWR sky130_fd_sc_hd__tapvpwrvgnd_1
X_05373_ net944 picorv32_core.count_cycle\[44\] picorv32_core.count_cycle\[12\] net605
+ _01876_ VGND VGND VPWR VPWR _01877_ sky130_fd_sc_hd__a221o_1
X_08161_ net930 _01594_ net929 VGND VGND VPWR VPWR _04186_ sky130_fd_sc_hd__and3b_1
XTAP_TAPCELL_ROW_31_754 VGND VPWR sky130_fd_sc_hd__tapvpwrvgnd_1
XTAP_TAPCELL_ROW_132_2212 VGND VPWR sky130_fd_sc_hd__tapvpwrvgnd_1
X_07112_ picorv32_core.count_cycle\[13\] _03299_ picorv32_core.count_cycle\[14\] VGND
+ VGND VPWR VPWR _03302_ sky130_fd_sc_hd__a21o_1
X_08092_ net920 net924 VGND VGND VPWR VPWR _04165_ sky130_fd_sc_hd__nor2_1
XTAP_TAPCELL_ROW_132_2223 VGND VPWR sky130_fd_sc_hd__tapvpwrvgnd_1
Xclkload62 clknet_leaf_40_clk VGND VGND VPWR VPWR clkload62/X sky130_fd_sc_hd__clkbuf_8
X_07043_ net587 _03250_ VGND VGND VPWR VPWR _03251_ sky130_fd_sc_hd__nor2_1
Xclkload51 clknet_leaf_28_clk VGND VGND VPWR VPWR clkload51/Y sky130_fd_sc_hd__clkinv_8
Xclkload40 clknet_leaf_15_clk VGND VGND VPWR VPWR clkload40/Y sky130_fd_sc_hd__inv_8
Xclkload73 clknet_leaf_44_clk VGND VGND VPWR VPWR clkload73/Y sky130_fd_sc_hd__clkinv_8
Xclkload84 clknet_leaf_116_clk VGND VGND VPWR VPWR clkload84/Y sky130_fd_sc_hd__inv_6
Xclkload95 clknet_leaf_124_clk VGND VGND VPWR VPWR clkload95/Y sky130_fd_sc_hd__inv_12
XFILLER_125_27 VPWR VGND VPWR VGND sky130_ef_sc_hd__decap_12
X_08994_ net429 net1565 net344 VGND VGND VPWR VPWR _01164_ sky130_fd_sc_hd__mux2_1
XFILLER_141_193 VGND VGND VPWR VPWR sky130_fd_sc_hd__decap_3
X_07945_ picorv32_core.cpuregs\[20\]\[24\] picorv32_core.cpuregs\[21\]\[24\] picorv32_core.cpuregs\[22\]\[24\]
+ picorv32_core.cpuregs\[23\]\[24\] net752 net719 VGND VGND VPWR VPWR _04026_ sky130_fd_sc_hd__mux4_1
XFILLER_87_247 VGND VGND VPWR VPWR sky130_fd_sc_hd__decap_4
XTAP_TAPCELL_ROW_110_1897 VGND VPWR sky130_fd_sc_hd__tapvpwrvgnd_1
XFILLER_96_781 VGND VGND VPWR VPWR sky130_fd_sc_hd__decap_3
XFILLER_141_15 VPWR VGND VPWR VGND sky130_ef_sc_hd__decap_12
X_07876_ picorv32_core.cpuregs\[16\]\[20\] picorv32_core.cpuregs\[17\]\[20\] picorv32_core.cpuregs\[18\]\[20\]
+ picorv32_core.cpuregs\[19\]\[20\] net755 net722 VGND VGND VPWR VPWR _03961_ sky130_fd_sc_hd__mux4_1
X_09615_ picorv32_core.cpuregs\[8\]\[19\] picorv32_core.cpuregs\[9\]\[19\] picorv32_core.cpuregs\[10\]\[19\]
+ picorv32_core.cpuregs\[11\]\[19\] net891 net857 VGND VGND VPWR VPWR _04795_ sky130_fd_sc_hd__mux4_1
XFILLER_55_111 VGND VGND VPWR VPWR sky130_fd_sc_hd__fill_1
X_06827_ _02923_ _03040_ VGND VGND VPWR VPWR _03052_ sky130_fd_sc_hd__nand2_1
XTAP_TAPCELL_ROW_48_1007 VGND VPWR sky130_fd_sc_hd__tapvpwrvgnd_1
XTAP_TAPCELL_ROW_39_865 VGND VPWR sky130_fd_sc_hd__tapvpwrvgnd_1
XTAP_TAPCELL_ROW_39_876 VGND VPWR sky130_fd_sc_hd__tapvpwrvgnd_1
X_09546_ _04720_ _04721_ _04725_ _04726_ net657 net645 VGND VGND VPWR VPWR _04729_
+ sky130_fd_sc_hd__mux4_1
XFILLER_36_380 VPWR VGND VPWR VGND sky130_ef_sc_hd__decap_12
X_06758_ picorv32_core.decoded_imm_j\[6\] _02918_ VGND VGND VPWR VPWR _02988_ sky130_fd_sc_hd__or2_1
X_05709_ _02191_ _02192_ _02187_ _02190_ VGND VGND VPWR VPWR _02193_ sky130_fd_sc_hd__a211o_1
X_09477_ picorv32_core.cpuregs\[20\]\[13\] picorv32_core.cpuregs\[21\]\[13\] picorv32_core.cpuregs\[22\]\[13\]
+ picorv32_core.cpuregs\[23\]\[13\] net882 net849 VGND VGND VPWR VPWR _04663_ sky130_fd_sc_hd__mux4_1
X_06689_ _02753_ picorv32_core.reg_next_pc\[22\] net561 VGND VGND VPWR VPWR _02934_
+ sky130_fd_sc_hd__mux2_2
X_08428_ picorv32_core.decoded_imm\[23\] net528 net442 _04294_ VGND VGND VPWR VPWR
+ _00587_ sky130_fd_sc_hd__o22a_1
XFILLER_51_372 VGND VGND VPWR VPWR sky130_fd_sc_hd__decap_6
X_08359_ net1153 _04254_ net456 VGND VGND VPWR VPWR _00558_ sky130_fd_sc_hd__mux2_1
Xclkload1 clknet_4_1_0_clk VGND VGND VPWR VPWR clkload1/X sky130_fd_sc_hd__clkbuf_8
X_11370_ clknet_leaf_34_clk _01211_ VGND VGND VPWR VPWR picorv32_core.cpuregs\[18\]\[22\]
+ sky130_fd_sc_hd__dfxtp_1
XFILLER_20_781 VPWR VGND VPWR VGND sky130_ef_sc_hd__decap_12
XFILLER_119_3 VPWR VGND VPWR VGND sky130_ef_sc_hd__decap_12
X_10321_ clknet_leaf_90_clk _00240_ VGND VGND VPWR VPWR picorv32_core.reg_next_pc\[11\]
+ sky130_fd_sc_hd__dfxtp_1
XTAP_TAPCELL_ROW_59_1158 VGND VPWR sky130_fd_sc_hd__tapvpwrvgnd_1
XFILLER_140_609 VGND VGND VPWR VPWR sky130_fd_sc_hd__fill_2
XFILLER_105_352 VGND VGND VPWR VPWR sky130_fd_sc_hd__decap_3
X_10252_ clknet_leaf_103_clk _00171_ VGND VGND VPWR VPWR picorv32_core.count_instr\[36\]
+ sky130_fd_sc_hd__dfxtp_1
X_10183_ clknet_leaf_67_clk _00102_ VGND VGND VPWR VPWR picorv32_core.cpuregs\[21\]\[31\]
+ sky130_fd_sc_hd__dfxtp_1
XTAP_TAPCELL_ROW_72_1347 VGND VPWR sky130_fd_sc_hd__tapvpwrvgnd_1
XFILLER_59_87 VGND VGND VPWR VPWR sky130_fd_sc_hd__fill_1
XFILLER_120_388 VGND VGND VPWR VPWR sky130_fd_sc_hd__decap_4
XFILLER_115_82 VGND VGND VPWR VPWR sky130_fd_sc_hd__fill_1
Xfanout260 net262 VGND VGND VPWR VPWR net260 sky130_fd_sc_hd__clkbuf_2
Xfanout271 _02728_ VGND VGND VPWR VPWR net271 sky130_fd_sc_hd__buf_1
XFILLER_59_461 VGND VGND VPWR VPWR sky130_fd_sc_hd__decap_8
Xfanout282 _03394_ VGND VGND VPWR VPWR net282 sky130_fd_sc_hd__clkbuf_4
Xfanout293 _02712_ VGND VGND VPWR VPWR net293 sky130_fd_sc_hd__clkbuf_2
XFILLER_46_122 VGND VGND VPWR VPWR sky130_fd_sc_hd__fill_2
XFILLER_131_81 VPWR VGND VPWR VGND sky130_ef_sc_hd__decap_12
XFILLER_61_169 VGND VGND VPWR VPWR sky130_fd_sc_hd__fill_2
XTAP_TAPCELL_ROW_17_548 VGND VPWR sky130_fd_sc_hd__tapvpwrvgnd_1
XFILLER_27_391 VGND VGND VPWR VPWR sky130_fd_sc_hd__fill_1
X_11706_ clknet_leaf_46_clk _01537_ VGND VGND VPWR VPWR picorv32_core.cpuregs\[27\]\[23\]
+ sky130_fd_sc_hd__dfxtp_1
X_11637_ clknet_leaf_51_clk _01468_ VGND VGND VPWR VPWR picorv32_core.cpuregs\[28\]\[18\]
+ sky130_fd_sc_hd__dfxtp_1
X_11568_ clknet_leaf_18_clk _01399_ VGND VGND VPWR VPWR picorv32_core.cpuregs\[2\]\[15\]
+ sky130_fd_sc_hd__dfxtp_1
XFILLER_7_741 VPWR VGND VPWR VGND sky130_ef_sc_hd__decap_12
Xhold719 picorv32_core.cpuregs\[12\]\[18\] VGND VGND VPWR VPWR net1828 sky130_fd_sc_hd__dlygate4sd3_1
Xhold708 picorv32_core.cpuregs\[13\]\[15\] VGND VGND VPWR VPWR net1817 sky130_fd_sc_hd__dlygate4sd3_1
XFILLER_7_785 VPWR VGND VPWR VGND sky130_ef_sc_hd__decap_12
X_10519_ clknet_leaf_127_clk picorv32_core.alu_out\[7\] VGND VGND VPWR VPWR picorv32_core.alu_out_q\[7\]
+ sky130_fd_sc_hd__dfxtp_1
X_11499_ clknet_leaf_56_clk _01335_ VGND VGND VPWR VPWR net148 sky130_fd_sc_hd__dfxtp_2
XFILLER_6_284 VGND VGND VPWR VPWR sky130_fd_sc_hd__fill_1
XFILLER_108_190 VGND VGND VPWR VPWR sky130_fd_sc_hd__fill_2
XFILLER_69_225 VGND VGND VPWR VPWR sky130_fd_sc_hd__decap_4
XFILLER_34_3 VPWR VGND VPWR VGND sky130_ef_sc_hd__decap_12
XFILLER_85_718 VGND VGND VPWR VPWR sky130_fd_sc_hd__decap_6
XFILLER_57_409 VGND VGND VPWR VPWR sky130_fd_sc_hd__decap_3
X_05991_ _02145_ _02455_ _02456_ VGND VGND VPWR VPWR _02457_ sky130_fd_sc_hd__a21o_1
X_07730_ picorv32_core.cpuregs\[16\]\[12\] picorv32_core.cpuregs\[17\]\[12\] picorv32_core.cpuregs\[18\]\[12\]
+ picorv32_core.cpuregs\[19\]\[12\] net736 net703 VGND VGND VPWR VPWR _03823_ sky130_fd_sc_hd__mux4_1
XFILLER_38_634 VGND VGND VPWR VPWR sky130_fd_sc_hd__decap_6
XFILLER_38_645 VGND VGND VPWR VPWR sky130_fd_sc_hd__decap_8
XFILLER_38_656 VGND VGND VPWR VPWR sky130_fd_sc_hd__decap_4
XFILLER_93_773 VGND VGND VPWR VPWR sky130_fd_sc_hd__fill_2
X_07661_ net630 _03757_ VGND VGND VPWR VPWR _03758_ sky130_fd_sc_hd__or2_1
X_06612_ net996 _02888_ _02889_ VGND VGND VPWR VPWR _00187_ sky130_fd_sc_hd__and3_1
X_09400_ net802 net281 VGND VGND VPWR VPWR _04589_ sky130_fd_sc_hd__and2_1
X_07592_ picorv32_core.decoded_imm\[3\] _01682_ net510 VGND VGND VPWR VPWR _03694_
+ sky130_fd_sc_hd__o21a_1
XTAP_TAPCELL_ROW_36_824 VGND VPWR sky130_fd_sc_hd__tapvpwrvgnd_1
X_06543_ picorv32_core.count_instr\[27\] _02844_ net978 VGND VGND VPWR VPWR _02846_
+ sky130_fd_sc_hd__a21oi_1
X_09331_ net810 net281 _04523_ VGND VGND VPWR VPWR _01325_ sky130_fd_sc_hd__a21o_1
XFILLER_80_489 VGND VGND VPWR VPWR sky130_fd_sc_hd__fill_1
X_09262_ net469 _04455_ _04456_ net474 VGND VGND VPWR VPWR _04457_ sky130_fd_sc_hd__a22o_1
X_06474_ picorv32_core.count_instr\[2\] _02801_ net972 VGND VGND VPWR VPWR _02802_
+ sky130_fd_sc_hd__a21oi_1
XFILLER_119_422 VPWR VGND VPWR VGND sky130_ef_sc_hd__decap_12
X_05425_ net918 net792 _01918_ net923 _01925_ VGND VGND VPWR VPWR _01926_ sky130_fd_sc_hd__a221o_1
X_08213_ picorv32_core.instr_sub net475 _04182_ _04209_ VGND VGND VPWR VPWR _00459_
+ sky130_fd_sc_hd__a22o_1
X_09193_ picorv32_core.cpuregs\[4\]\[1\] picorv32_core.cpuregs\[5\]\[1\] net887 VGND
+ VGND VPWR VPWR _04391_ sky130_fd_sc_hd__mux2_1
XFILLER_21_578 VGND VGND VPWR VPWR sky130_fd_sc_hd__fill_2
X_05356_ _01859_ _01860_ VGND VGND VPWR VPWR _01861_ sky130_fd_sc_hd__nand2b_1
X_08144_ net2366 net30 net521 VGND VGND VPWR VPWR _00745_ sky130_fd_sc_hd__mux2_1
Xpicorv32_axi_1107 VGND VGND VPWR VPWR picorv32_axi_1107/HI trace_data[34] sky130_fd_sc_hd__conb_1
Xclkload140 clknet_leaf_75_clk VGND VGND VPWR VPWR clkload140/Y sky130_fd_sc_hd__inv_6
XFILLER_107_617 VPWR VGND VPWR VGND sky130_ef_sc_hd__decap_12
XFILLER_136_15 VPWR VGND VPWR VGND sky130_ef_sc_hd__decap_12
XFILLER_119_499 VGND VGND VPWR VPWR sky130_fd_sc_hd__decap_4
X_08075_ _00002_ _04148_ VGND VGND VPWR VPWR _04149_ sky130_fd_sc_hd__or2_1
X_05287_ net27 net821 VGND VGND VPWR VPWR _01797_ sky130_fd_sc_hd__nand2b_1
XFILLER_20_26 VGND VGND VPWR VPWR sky130_fd_sc_hd__fill_2
XTAP_TAPCELL_ROW_112_1926 VGND VPWR sky130_fd_sc_hd__tapvpwrvgnd_1
XFILLER_103_801 VGND VGND VPWR VPWR sky130_fd_sc_hd__fill_1
X_07026_ _03233_ _03234_ _03232_ VGND VGND VPWR VPWR _03235_ sky130_fd_sc_hd__o21ai_1
XFILLER_115_694 VGND VGND VPWR VPWR sky130_fd_sc_hd__fill_1
XFILLER_103_812 VGND VGND VPWR VPWR sky130_fd_sc_hd__decap_6
XFILLER_102_333 VGND VGND VPWR VPWR sky130_fd_sc_hd__fill_2
Xhold13 picorv32_core.cpuregs\[0\]\[14\] VGND VGND VPWR VPWR net1122 sky130_fd_sc_hd__dlygate4sd3_1
X_08977_ net1908 net232 net350 VGND VGND VPWR VPWR _01149_ sky130_fd_sc_hd__mux2_1
Xhold46 net111 VGND VGND VPWR VPWR net1155 sky130_fd_sc_hd__dlygate4sd3_1
XFILLER_88_589 VPWR VGND VPWR VGND sky130_ef_sc_hd__decap_12
Xhold35 picorv32_core.instr_slti VGND VGND VPWR VPWR net1144 sky130_fd_sc_hd__dlygate4sd3_1
XTAP_TAPCELL_ROW_54_1088 VGND VPWR sky130_fd_sc_hd__tapvpwrvgnd_1
XFILLER_29_57 VGND VGND VPWR VPWR sky130_fd_sc_hd__fill_2
Xhold24 picorv32_core.reg_next_pc\[1\] VGND VGND VPWR VPWR net1133 sky130_fd_sc_hd__dlygate4sd3_1
X_07928_ picorv32_core.decoded_imm\[22\] net591 net597 VGND VGND VPWR VPWR _04011_
+ sky130_fd_sc_hd__a21o_1
Xhold68 net123 VGND VGND VPWR VPWR net1177 sky130_fd_sc_hd__dlygate4sd3_1
Xhold57 picorv32_core.instr_sltiu VGND VGND VPWR VPWR net1166 sky130_fd_sc_hd__dlygate4sd3_1
Xhold79 net104 VGND VGND VPWR VPWR net1188 sky130_fd_sc_hd__dlygate4sd3_1
X_07859_ picorv32_core.cpuregs\[4\]\[19\] picorv32_core.cpuregs\[5\]\[19\] picorv32_core.cpuregs\[6\]\[19\]
+ picorv32_core.cpuregs\[7\]\[19\] net748 net715 VGND VGND VPWR VPWR _03945_ sky130_fd_sc_hd__mux4_1
XFILLER_56_475 VGND VGND VPWR VPWR sky130_fd_sc_hd__fill_1
XFILLER_56_464 VGND VGND VPWR VPWR sky130_fd_sc_hd__decap_4
X_10870_ clknet_leaf_9_clk _00721_ VGND VGND VPWR VPWR picorv32_core.cpuregs\[16\]\[14\]
+ sky130_fd_sc_hd__dfxtp_1
X_09529_ net832 _04709_ _04712_ net480 VGND VGND VPWR VPWR _04713_ sky130_fd_sc_hd__o211a_1
XTAP_TAPCELL_ROW_14_507 VGND VPWR sky130_fd_sc_hd__tapvpwrvgnd_1
XFILLER_12_589 VGND VGND VPWR VPWR sky130_fd_sc_hd__decap_4
X_11422_ clknet_leaf_137_clk _01258_ VGND VGND VPWR VPWR picorv32_core.cpuregs\[1\]\[5\]
+ sky130_fd_sc_hd__dfxtp_1
XFILLER_137_263 VGND VGND VPWR VPWR sky130_fd_sc_hd__fill_1
X_11353_ clknet_leaf_142_clk _01194_ VGND VGND VPWR VPWR picorv32_core.cpuregs\[18\]\[5\]
+ sky130_fd_sc_hd__dfxtp_1
XFILLER_125_458 VGND VGND VPWR VPWR sky130_fd_sc_hd__decap_3
X_10304_ clknet_leaf_60_clk _00223_ VGND VGND VPWR VPWR picorv32_core.reg_pc\[25\]
+ sky130_fd_sc_hd__dfxtp_1
XFILLER_98_309 VGND VGND VPWR VPWR sky130_fd_sc_hd__fill_1
XFILLER_4_755 VGND VGND VPWR VPWR sky130_fd_sc_hd__fill_1
X_11284_ clknet_leaf_140_clk _01132_ VGND VGND VPWR VPWR picorv32_core.cpuregs\[3\]\[7\]
+ sky130_fd_sc_hd__dfxtp_1
X_10235_ clknet_leaf_80_clk _00154_ VGND VGND VPWR VPWR picorv32_core.count_instr\[19\]
+ sky130_fd_sc_hd__dfxtp_1
XFILLER_79_523 VGND VGND VPWR VPWR sky130_fd_sc_hd__decap_4
XFILLER_120_163 VGND VGND VPWR VPWR sky130_fd_sc_hd__decap_4
XFILLER_120_141 VGND VGND VPWR VPWR sky130_fd_sc_hd__decap_6
XFILLER_67_718 VGND VGND VPWR VPWR sky130_fd_sc_hd__fill_2
X_10166_ clknet_leaf_7_clk _00085_ VGND VGND VPWR VPWR picorv32_core.cpuregs\[21\]\[14\]
+ sky130_fd_sc_hd__dfxtp_1
XFILLER_86_85 VGND VGND VPWR VPWR sky130_fd_sc_hd__decap_4
X_10097_ net1122 VGND VGND VPWR VPWR _00947_ sky130_fd_sc_hd__clkbuf_1
XFILLER_47_464 VGND VGND VPWR VPWR sky130_fd_sc_hd__fill_2
XTAP_TAPCELL_ROW_85_1538 VGND VPWR sky130_fd_sc_hd__tapvpwrvgnd_1
XFILLER_35_615 VGND VGND VPWR VPWR sky130_fd_sc_hd__fill_1
XFILLER_62_489 VGND VGND VPWR VPWR sky130_fd_sc_hd__decap_3
X_10999_ clknet_leaf_129_clk _00850_ VGND VGND VPWR VPWR picorv32_core.cpuregs\[12\]\[13\]
+ sky130_fd_sc_hd__dfxtp_1
XFILLER_22_309 VGND VGND VPWR VPWR sky130_fd_sc_hd__fill_2
XFILLER_31_832 VGND VGND VPWR VPWR sky130_fd_sc_hd__fill_1
X_05210_ net922 net916 net910 VGND VGND VPWR VPWR _01726_ sky130_fd_sc_hd__nor3_2
X_06190_ _02621_ picorv32_core.decoded_imm_j\[2\] picorv32_core.is_slli_srli_srai
+ VGND VGND VPWR VPWR _02622_ sky130_fd_sc_hd__mux2_1
XTAP_TAPCELL_ROW_41_893 VGND VPWR sky130_fd_sc_hd__tapvpwrvgnd_1
XFILLER_129_797 VPWR VGND VPWR VGND sky130_ef_sc_hd__decap_12
X_05141_ picorv32_core.mem_do_rinst picorv32_core.reg_pc\[1\] net980 _01670_ VGND
+ VGND VPWR VPWR _01671_ sky130_fd_sc_hd__a31oi_2
Xhold516 picorv32_core.cpuregs\[28\]\[28\] VGND VGND VPWR VPWR net1625 sky130_fd_sc_hd__dlygate4sd3_1
Xhold527 picorv32_core.cpuregs\[26\]\[31\] VGND VGND VPWR VPWR net1636 sky130_fd_sc_hd__dlygate4sd3_1
Xhold505 picorv32_core.cpuregs\[13\]\[18\] VGND VGND VPWR VPWR net1614 sky130_fd_sc_hd__dlygate4sd3_1
XFILLER_7_593 VGND VGND VPWR VPWR sky130_fd_sc_hd__fill_2
XFILLER_7_582 VGND VGND VPWR VPWR sky130_fd_sc_hd__fill_2
Xhold549 picorv32_core.cpuregs\[4\]\[26\] VGND VGND VPWR VPWR net1658 sky130_fd_sc_hd__dlygate4sd3_1
Xhold538 picorv32_core.cpuregs\[11\]\[26\] VGND VGND VPWR VPWR net1647 sky130_fd_sc_hd__dlygate4sd3_1
X_05072_ net962 VGND VGND VPWR VPWR _01607_ sky130_fd_sc_hd__inv_2
X_09880_ net1340 net256 net326 VGND VGND VPWR VPWR _01368_ sky130_fd_sc_hd__mux2_1
X_08900_ net279 net1420 net358 VGND VGND VPWR VPWR _01074_ sky130_fd_sc_hd__mux2_1
XFILLER_106_29 VGND VGND VPWR VPWR sky130_fd_sc_hd__decap_6
X_08831_ net1476 net294 net366 VGND VGND VPWR VPWR _01007_ sky130_fd_sc_hd__mux2_1
XFILLER_111_141 VGND VGND VPWR VPWR sky130_fd_sc_hd__fill_1
Xhold1216 picorv32_core.mem_rdata_q\[15\] VGND VGND VPWR VPWR net2325 sky130_fd_sc_hd__dlygate4sd3_1
Xhold1205 picorv32_core.reg_sh\[2\] VGND VGND VPWR VPWR net2314 sky130_fd_sc_hd__dlygate4sd3_1
XTAP_TAPCELL_ROW_127_2144 VGND VPWR sky130_fd_sc_hd__tapvpwrvgnd_1
XFILLER_111_185 VGND VGND VPWR VPWR sky130_fd_sc_hd__decap_4
Xhold1227 picorv32_core.reg_pc\[20\] VGND VGND VPWR VPWR net2336 sky130_fd_sc_hd__dlygate4sd3_1
Xhold1249 picorv32_core.decoded_imm_j\[18\] VGND VGND VPWR VPWR net2358 sky130_fd_sc_hd__dlygate4sd3_1
X_05974_ net787 _02438_ VGND VGND VPWR VPWR _02441_ sky130_fd_sc_hd__nor2_1
Xhold1238 picorv32_core.count_cycle\[46\] VGND VGND VPWR VPWR net2347 sky130_fd_sc_hd__dlygate4sd3_1
XFILLER_66_740 VPWR VGND VPWR VGND sky130_ef_sc_hd__decap_12
X_08762_ net426 net1718 net374 VGND VGND VPWR VPWR _00909_ sky130_fd_sc_hd__mux2_1
X_07713_ picorv32_core.cpuregs\[24\]\[11\] picorv32_core.cpuregs\[25\]\[11\] picorv32_core.cpuregs\[26\]\[11\]
+ picorv32_core.cpuregs\[27\]\[11\] net736 net703 VGND VGND VPWR VPWR _03807_ sky130_fd_sc_hd__mux4_1
X_08693_ net2140 net448 net382 VGND VGND VPWR VPWR _00842_ sky130_fd_sc_hd__mux2_1
XTAP_TAPCELL_ROW_140_2333 VGND VPWR sky130_fd_sc_hd__tapvpwrvgnd_1
X_07644_ net628 _03736_ net617 VGND VGND VPWR VPWR _03742_ sky130_fd_sc_hd__o21a_1
XFILLER_53_434 VGND VGND VPWR VPWR sky130_fd_sc_hd__fill_1
XFILLER_80_253 VGND VGND VPWR VPWR sky130_fd_sc_hd__decap_4
X_07575_ net688 _03678_ net683 VGND VGND VPWR VPWR _03679_ sky130_fd_sc_hd__a21o_1
XFILLER_41_629 VGND VGND VPWR VPWR sky130_fd_sc_hd__fill_2
X_06526_ picorv32_core.count_instr\[21\] _02833_ VGND VGND VPWR VPWR _02835_ sky130_fd_sc_hd__and2_1
X_09314_ net610 _03474_ _04502_ _04506_ VGND VGND VPWR VPWR _04507_ sky130_fd_sc_hd__a31o_1
X_06457_ net247 net1651 net420 VGND VGND VPWR VPWR _00123_ sky130_fd_sc_hd__mux2_1
X_09245_ picorv32_core.cpuregs\[20\]\[3\] picorv32_core.cpuregs\[21\]\[3\] picorv32_core.cpuregs\[22\]\[3\]
+ picorv32_core.cpuregs\[23\]\[3\] net884 net852 VGND VGND VPWR VPWR _04441_ sky130_fd_sc_hd__mux4_1
X_05408_ picorv32_core.reg_pc\[14\] picorv32_core.decoded_imm\[14\] VGND VGND VPWR
+ VPWR _01910_ sky130_fd_sc_hd__nand2_1
X_06388_ _02783_ _02784_ VGND VGND VPWR VPWR _02785_ sky130_fd_sc_hd__nor2_1
X_09176_ picorv32_core.cpuregs\[30\]\[1\] picorv32_core.cpuregs\[31\]\[1\] net888
+ VGND VGND VPWR VPWR _04374_ sky130_fd_sc_hd__mux2_1
X_08127_ net243 net1681 net416 VGND VGND VPWR VPWR _00420_ sky130_fd_sc_hd__mux2_1
X_05339_ net914 net803 _01842_ net909 _01845_ VGND VGND VPWR VPWR _01846_ sky130_fd_sc_hd__a221o_1
X_08058_ picorv32_core.cpuregs\[0\]\[30\] picorv32_core.cpuregs\[1\]\[30\] picorv32_core.cpuregs\[2\]\[30\]
+ picorv32_core.cpuregs\[3\]\[30\] net759 net726 VGND VGND VPWR VPWR _04133_ sky130_fd_sc_hd__mux4_1
XTAP_TAPCELL_ROW_56_1117 VGND VPWR sky130_fd_sc_hd__tapvpwrvgnd_1
XFILLER_134_288 VGND VGND VPWR VPWR sky130_fd_sc_hd__decap_4
Xoutput58 net58 VGND VGND VPWR VPWR mem_axi_araddr[29] sky130_fd_sc_hd__buf_2
Xoutput47 net47 VGND VGND VPWR VPWR mem_axi_araddr[18] sky130_fd_sc_hd__buf_2
X_07009_ _03218_ _03219_ VGND VGND VPWR VPWR _03220_ sky130_fd_sc_hd__nor2_1
XFILLER_103_653 VPWR VGND VPWR VGND sky130_ef_sc_hd__decap_12
X_10020_ net1430 net275 net310 VGND VGND VPWR VPWR _01496_ sky130_fd_sc_hd__mux2_1
Xoutput69 net69 VGND VGND VPWR VPWR mem_axi_arprot[2] sky130_fd_sc_hd__buf_2
XFILLER_84_570 VGND VGND VPWR VPWR sky130_fd_sc_hd__decap_6
XFILLER_72_721 VGND VGND VPWR VPWR sky130_fd_sc_hd__fill_1
XFILLER_56_272 VGND VGND VPWR VPWR sky130_fd_sc_hd__decap_3
X_10922_ clknet_leaf_134_clk _00773_ VGND VGND VPWR VPWR picorv32_core.cpuregs\[19\]\[0\]
+ sky130_fd_sc_hd__dfxtp_1
X_10853_ clknet_leaf_66_clk _00704_ VGND VGND VPWR VPWR picorv32_core.cpuregs\[17\]\[30\]
+ sky130_fd_sc_hd__dfxtp_1
XTAP_TAPCELL_ROW_67_1279 VGND VPWR sky130_fd_sc_hd__tapvpwrvgnd_1
X_10784_ clknet_leaf_67_clk _00635_ VGND VGND VPWR VPWR picorv32_core.cpuregs\[14\]\[25\]
+ sky130_fd_sc_hd__dfxtp_1
XFILLER_13_821 VPWR VGND VPWR VGND sky130_ef_sc_hd__decap_12
XTAP_TAPCELL_ROW_27_698 VGND VPWR sky130_fd_sc_hd__tapvpwrvgnd_1
XTAP_TAPCELL_ROW_80_1468 VGND VPWR sky130_fd_sc_hd__tapvpwrvgnd_1
X_11405_ clknet_leaf_32_clk _01241_ VGND VGND VPWR VPWR picorv32_core.cpuregs\[31\]\[20\]
+ sky130_fd_sc_hd__dfxtp_1
X_11336_ clknet_leaf_32_clk _01177_ VGND VGND VPWR VPWR picorv32_core.cpuregs\[29\]\[20\]
+ sky130_fd_sc_hd__dfxtp_1
XFILLER_141_748 VGND VGND VPWR VPWR sky130_fd_sc_hd__decap_4
XFILLER_125_288 VGND VGND VPWR VPWR sky130_fd_sc_hd__decap_6
XFILLER_98_106 VGND VGND VPWR VPWR sky130_fd_sc_hd__decap_3
X_11267_ clknet_leaf_30_clk _01115_ VGND VGND VPWR VPWR picorv32_core.cpuregs\[4\]\[22\]
+ sky130_fd_sc_hd__dfxtp_1
XFILLER_140_269 VGND VGND VPWR VPWR sky130_fd_sc_hd__fill_2
X_11198_ clknet_leaf_32_clk _01049_ VGND VGND VPWR VPWR picorv32_core.cpuregs\[6\]\[20\]
+ sky130_fd_sc_hd__dfxtp_1
X_10218_ clknet_leaf_103_clk _00137_ VGND VGND VPWR VPWR picorv32_core.count_instr\[2\]
+ sky130_fd_sc_hd__dfxtp_1
X_10149_ clknet_leaf_121_clk _00034_ VGND VGND VPWR VPWR picorv32_core.reg_sh\[2\]
+ sky130_fd_sc_hd__dfxtp_1
X_05690_ net777 net187 VGND VGND VPWR VPWR _02174_ sky130_fd_sc_hd__nand2_1
XTAP_TAPCELL_ROW_122_2074 VGND VPWR sky130_fd_sc_hd__tapvpwrvgnd_1
XFILLER_62_275 VGND VGND VPWR VPWR sky130_fd_sc_hd__fill_1
XFILLER_62_253 VGND VGND VPWR VPWR sky130_fd_sc_hd__fill_1
XTAP_TAPCELL_ROW_46_974 VGND VPWR sky130_fd_sc_hd__tapvpwrvgnd_1
X_07360_ net789 picorv32_core.decoded_imm\[16\] _03421_ _03422_ VGND VGND VPWR VPWR
+ _03500_ sky130_fd_sc_hd__a31o_1
XFILLER_50_448 VGND VGND VPWR VPWR sky130_fd_sc_hd__decap_3
X_06311_ _02721_ _02722_ net565 VGND VGND VPWR VPWR _02723_ sky130_fd_sc_hd__mux2_2
XTAP_TAPCELL_ROW_98_1729 VGND VPWR sky130_fd_sc_hd__tapvpwrvgnd_1
X_07291_ net798 picorv32_core.decoded_imm\[12\] VGND VGND VPWR VPWR _03431_ sky130_fd_sc_hd__or2_1
XFILLER_31_673 VGND VGND VPWR VPWR sky130_fd_sc_hd__fill_2
XFILLER_31_684 VGND VGND VPWR VPWR sky130_fd_sc_hd__fill_2
X_09030_ net294 net2171 net340 VGND VGND VPWR VPWR _01199_ sky130_fd_sc_hd__mux2_1
X_06242_ picorv32_core.latched_branch picorv32_core.latched_store VGND VGND VPWR VPWR
+ _02668_ sky130_fd_sc_hd__nand2b_1
Xhold302 picorv32_core.cpuregs\[19\]\[15\] VGND VGND VPWR VPWR net1411 sky130_fd_sc_hd__dlygate4sd3_1
X_06173_ net688 _02604_ VGND VGND VPWR VPWR _02605_ sky130_fd_sc_hd__nand2_1
Xhold335 picorv32_core.cpuregs\[23\]\[30\] VGND VGND VPWR VPWR net1444 sky130_fd_sc_hd__dlygate4sd3_1
X_05124_ picorv32_core.instr_sra picorv32_core.instr_srl picorv32_core.instr_xor picorv32_core.instr_sll
+ VGND VGND VPWR VPWR _01655_ sky130_fd_sc_hd__or4_1
XFILLER_7_390 VGND VGND VPWR VPWR sky130_fd_sc_hd__fill_2
XFILLER_7_93 VPWR VGND VPWR VGND sky130_ef_sc_hd__decap_12
Xhold313 picorv32_core.cpuregs\[31\]\[1\] VGND VGND VPWR VPWR net1422 sky130_fd_sc_hd__dlygate4sd3_1
Xhold324 picorv32_core.cpuregs\[19\]\[8\] VGND VGND VPWR VPWR net1433 sky130_fd_sc_hd__dlygate4sd3_1
XFILLER_104_417 VGND VGND VPWR VPWR sky130_fd_sc_hd__decap_3
Xhold368 picorv32_core.cpuregs\[30\]\[13\] VGND VGND VPWR VPWR net1477 sky130_fd_sc_hd__dlygate4sd3_1
Xhold346 picorv32_core.cpuregs\[26\]\[13\] VGND VGND VPWR VPWR net1455 sky130_fd_sc_hd__dlygate4sd3_1
Xhold357 picorv32_core.cpuregs\[13\]\[3\] VGND VGND VPWR VPWR net1466 sky130_fd_sc_hd__dlygate4sd3_1
X_09932_ picorv32_core.reg_sh\[0\] _01706_ VGND VGND VPWR VPWR _05034_ sky130_fd_sc_hd__nor2_1
X_05055_ picorv32_core.cpu_state\[2\] VGND VGND VPWR VPWR _01590_ sky130_fd_sc_hd__inv_2
XFILLER_131_225 VGND VGND VPWR VPWR sky130_fd_sc_hd__fill_1
Xfanout804 net172 VGND VGND VPWR VPWR net804 sky130_fd_sc_hd__clkbuf_4
Xhold379 picorv32_core.cpuregs\[30\]\[0\] VGND VGND VPWR VPWR net1488 sky130_fd_sc_hd__dlygate4sd3_1
Xfanout815 net816 VGND VGND VPWR VPWR net815 sky130_fd_sc_hd__buf_2
XFILLER_100_601 VPWR VGND VPWR VGND sky130_ef_sc_hd__decap_12
XFILLER_98_673 VGND VGND VPWR VPWR sky130_fd_sc_hd__fill_1
Xfanout826 net827 VGND VGND VPWR VPWR net826 sky130_fd_sc_hd__buf_2
Xfanout848 net850 VGND VGND VPWR VPWR net848 sky130_fd_sc_hd__clkbuf_4
X_09863_ net1605 net501 net325 VGND VGND VPWR VPWR _01351_ sky130_fd_sc_hd__mux2_1
Xfanout837 _00007_ VGND VGND VPWR VPWR net837 sky130_fd_sc_hd__buf_4
XFILLER_140_781 VPWR VGND VPWR VGND sky130_ef_sc_hd__decap_12
XFILLER_133_27 VPWR VGND VPWR VGND sky130_ef_sc_hd__decap_12
X_08814_ net221 net2178 net372 VGND VGND VPWR VPWR _00992_ sky130_fd_sc_hd__mux2_1
Xhold1013 picorv32_core.cpuregs\[21\]\[20\] VGND VGND VPWR VPWR net2122 sky130_fd_sc_hd__dlygate4sd3_1
X_09794_ net284 _04950_ _04965_ _04945_ VGND VGND VPWR VPWR _01346_ sky130_fd_sc_hd__a31o_1
Xhold1024 picorv32_core.cpuregs\[10\]\[20\] VGND VGND VPWR VPWR net2133 sky130_fd_sc_hd__dlygate4sd3_1
Xhold1002 picorv32_core.cpuregs\[29\]\[19\] VGND VGND VPWR VPWR net2111 sky130_fd_sc_hd__dlygate4sd3_1
Xfanout859 net866 VGND VGND VPWR VPWR net859 sky130_fd_sc_hd__clkbuf_4
XTAP_TAPCELL_ROW_51_1047 VGND VPWR sky130_fd_sc_hd__tapvpwrvgnd_1
X_08745_ net1545 net234 net379 VGND VGND VPWR VPWR _00893_ sky130_fd_sc_hd__mux2_1
Xhold1046 picorv32_core.cpuregs\[7\]\[31\] VGND VGND VPWR VPWR net2155 sky130_fd_sc_hd__dlygate4sd3_1
Xhold1057 picorv32_core.cpuregs\[14\]\[21\] VGND VGND VPWR VPWR net2166 sky130_fd_sc_hd__dlygate4sd3_1
Xhold1035 picorv32_core.cpuregs\[10\]\[14\] VGND VGND VPWR VPWR net2144 sky130_fd_sc_hd__dlygate4sd3_1
XFILLER_39_762 VGND VGND VPWR VPWR sky130_fd_sc_hd__decap_6
X_05957_ _02379_ _02393_ _02404_ _02416_ VGND VGND VPWR VPWR _02425_ sky130_fd_sc_hd__or4_1
Xhold1068 picorv32_core.cpuregs\[4\]\[2\] VGND VGND VPWR VPWR net2177 sky130_fd_sc_hd__dlygate4sd3_1
Xhold1079 picorv32_core.cpuregs\[21\]\[11\] VGND VGND VPWR VPWR net2188 sky130_fd_sc_hd__dlygate4sd3_1
X_08676_ net244 net1660 net388 VGND VGND VPWR VPWR _00826_ sky130_fd_sc_hd__mux2_1
XTAP_TAPCELL_ROW_107_1858 VGND VPWR sky130_fd_sc_hd__tapvpwrvgnd_1
XFILLER_66_592 VGND VGND VPWR VPWR sky130_fd_sc_hd__fill_1
X_05888_ _02197_ _02360_ _02361_ VGND VGND VPWR VPWR _02362_ sky130_fd_sc_hd__a21o_1
XFILLER_54_754 VGND VGND VPWR VPWR sky130_fd_sc_hd__fill_2
XFILLER_53_275 VGND VGND VPWR VPWR sky130_fd_sc_hd__decap_4
X_07627_ _03716_ _03724_ _03725_ net617 net687 VGND VGND VPWR VPWR _03726_ sky130_fd_sc_hd__a221o_1
XFILLER_53_297 VGND VGND VPWR VPWR sky130_fd_sc_hd__fill_1
X_07558_ picorv32_core.cpuregs\[28\]\[0\] picorv32_core.cpuregs\[29\]\[0\] picorv32_core.cpuregs\[30\]\[0\]
+ picorv32_core.cpuregs\[31\]\[0\] net742 net709 VGND VGND VPWR VPWR _03663_ sky130_fd_sc_hd__mux4_1
X_06509_ picorv32_core.count_instr\[15\] picorv32_core.count_instr\[14\] _02820_ VGND
+ VGND VPWR VPWR _02824_ sky130_fd_sc_hd__and3_1
XTAP_TAPCELL_ROW_24_646 VGND VPWR sky130_fd_sc_hd__tapvpwrvgnd_1
XTAP_TAPCELL_ROW_24_657 VGND VPWR sky130_fd_sc_hd__tapvpwrvgnd_1
X_07489_ net148 _03613_ net533 VGND VGND VPWR VPWR _03614_ sky130_fd_sc_hd__mux2_1
XTAP_TAPCELL_ROW_62_1198 VGND VPWR sky130_fd_sc_hd__tapvpwrvgnd_1
XFILLER_10_813 VPWR VGND VPWR VGND sky130_ef_sc_hd__decap_12
X_09228_ picorv32_core.reg_pc\[2\] net485 net536 VGND VGND VPWR VPWR _04425_ sky130_fd_sc_hd__and3_1
XFILLER_108_723 VGND VGND VPWR VPWR sky130_fd_sc_hd__fill_1
X_09159_ net835 _04355_ _04357_ net830 VGND VGND VPWR VPWR _04358_ sky130_fd_sc_hd__o211a_1
XFILLER_108_789 VGND VGND VPWR VPWR sky130_fd_sc_hd__decap_3
XFILLER_101_3 VPWR VGND VPWR VGND sky130_ef_sc_hd__decap_12
X_11121_ clknet_leaf_132_clk _00972_ VGND VGND VPWR VPWR picorv32_core.cpuregs\[8\]\[7\]
+ sky130_fd_sc_hd__dfxtp_1
XFILLER_107_299 VGND VGND VPWR VPWR sky130_fd_sc_hd__fill_2
Xhold880 picorv32_core.cpuregs\[18\]\[16\] VGND VGND VPWR VPWR net1989 sky130_fd_sc_hd__dlygate4sd3_1
Xhold891 picorv32_core.cpuregs\[6\]\[5\] VGND VGND VPWR VPWR net2000 sky130_fd_sc_hd__dlygate4sd3_1
XFILLER_67_32 VGND VGND VPWR VPWR sky130_fd_sc_hd__fill_1
X_11052_ clknet_leaf_136_clk _00903_ VGND VGND VPWR VPWR picorv32_core.cpuregs\[10\]\[2\]
+ sky130_fd_sc_hd__dfxtp_1
X_10003_ net1822 net210 net315 VGND VGND VPWR VPWR _01480_ sky130_fd_sc_hd__mux2_1
XTAP_TAPCELL_ROW_69_1308 VGND VPWR sky130_fd_sc_hd__tapvpwrvgnd_1
XTAP_TAPCELL_ROW_4_360 VGND VPWR sky130_fd_sc_hd__tapvpwrvgnd_1
XFILLER_57_581 VGND VGND VPWR VPWR sky130_fd_sc_hd__decap_6
XFILLER_83_53 VGND VGND VPWR VPWR sky130_fd_sc_hd__decap_3
XPHY_EDGE_ROW_103_Left_245 VGND VGND VPWR VPWR sky130_fd_sc_hd__decap_3
X_10905_ clknet_leaf_83_clk _00756_ VGND VGND VPWR VPWR picorv32_core.mem_rdata_q\[15\]
+ sky130_fd_sc_hd__dfxtp_1
X_10836_ clknet_leaf_14_clk _00687_ VGND VGND VPWR VPWR picorv32_core.cpuregs\[17\]\[13\]
+ sky130_fd_sc_hd__dfxtp_1
XFILLER_32_437 VGND VGND VPWR VPWR sky130_fd_sc_hd__decap_3
XTAP_TAPCELL_ROW_43_922 VGND VPWR sky130_fd_sc_hd__tapvpwrvgnd_1
XTAP_TAPCELL_ROW_43_933 VGND VPWR sky130_fd_sc_hd__tapvpwrvgnd_1
XFILLER_60_768 VGND VGND VPWR VPWR sky130_fd_sc_hd__fill_1
XFILLER_8_121 VPWR VGND VPWR VGND sky130_ef_sc_hd__decap_12
X_10767_ clknet_leaf_12_clk _00618_ VGND VGND VPWR VPWR picorv32_core.cpuregs\[14\]\[8\]
+ sky130_fd_sc_hd__dfxtp_1
X_10698_ clknet_leaf_6_clk _00549_ VGND VGND VPWR VPWR net134 sky130_fd_sc_hd__dfxtp_1
XFILLER_126_531 VGND VGND VPWR VPWR sky130_fd_sc_hd__fill_1
XPHY_EDGE_ROW_112_Left_254 VGND VGND VPWR VPWR sky130_fd_sc_hd__decap_3
XFILLER_99_415 VGND VGND VPWR VPWR sky130_fd_sc_hd__fill_2
XTAP_TAPCELL_ROW_93_1659 VGND VPWR sky130_fd_sc_hd__tapvpwrvgnd_1
XTAP_TAPCELL_ROW_93_1648 VGND VPWR sky130_fd_sc_hd__tapvpwrvgnd_1
XFILLER_113_236 VGND VGND VPWR VPWR sky130_fd_sc_hd__fill_1
XFILLER_99_437 VGND VGND VPWR VPWR sky130_fd_sc_hd__decap_4
X_11319_ clknet_leaf_115_clk _01160_ VGND VGND VPWR VPWR picorv32_core.cpuregs\[29\]\[3\]
+ sky130_fd_sc_hd__dfxtp_1
XFILLER_122_781 VPWR VGND VPWR VGND sky130_ef_sc_hd__decap_12
X_06860_ picorv32_core.decoded_imm_j\[14\] _02926_ VGND VGND VPWR VPWR _03082_ sky130_fd_sc_hd__nand2_1
XFILLER_68_835 VGND VGND VPWR VPWR sky130_fd_sc_hd__fill_2
XFILLER_67_334 VGND VGND VPWR VPWR sky130_fd_sc_hd__fill_2
XTAP_TAPCELL_ROW_124_2103 VGND VPWR sky130_fd_sc_hd__tapvpwrvgnd_1
X_05811_ _02284_ _02289_ _02290_ net506 VGND VGND VPWR VPWR _02291_ sky130_fd_sc_hd__o211a_1
X_06791_ _03015_ _03017_ _02999_ _03005_ VGND VGND VPWR VPWR _03019_ sky130_fd_sc_hd__a211o_1
XPHY_EDGE_ROW_121_Left_263 VGND VGND VPWR VPWR sky130_fd_sc_hd__decap_3
XFILLER_94_197 VGND VGND VPWR VPWR sky130_fd_sc_hd__fill_1
XFILLER_82_348 VGND VGND VPWR VPWR sky130_fd_sc_hd__fill_2
X_08530_ net1521 net268 net402 VGND VGND VPWR VPWR _00657_ sky130_fd_sc_hd__mux2_1
X_05742_ _02224_ _02225_ _02193_ VGND VGND VPWR VPWR _02226_ sky130_fd_sc_hd__a21o_1
X_05673_ net771 net190 VGND VGND VPWR VPWR _02157_ sky130_fd_sc_hd__xnor2_1
X_08461_ net2361 net526 _04311_ VGND VGND VPWR VPWR _00603_ sky130_fd_sc_hd__o21a_1
X_07412_ net903 picorv32_core.cpuregs\[6\]\[31\] VGND VGND VPWR VPWR _03552_ sky130_fd_sc_hd__and2b_1
XFILLER_50_201 VGND VGND VPWR VPWR sky130_fd_sc_hd__fill_1
X_08392_ _01721_ _04271_ _04270_ VGND VGND VPWR VPWR _04272_ sky130_fd_sc_hd__a21oi_1
XTAP_TAPCELL_ROW_102_1788 VGND VPWR sky130_fd_sc_hd__tapvpwrvgnd_1
XTAP_TAPCELL_ROW_102_1777 VGND VPWR sky130_fd_sc_hd__tapvpwrvgnd_1
X_07343_ _03442_ _03482_ VGND VGND VPWR VPWR _03483_ sky130_fd_sc_hd__nand2_1
XTAP_TAPCELL_ROW_21_605 VGND VPWR sky130_fd_sc_hd__tapvpwrvgnd_1
XTAP_TAPCELL_ROW_21_616 VGND VPWR sky130_fd_sc_hd__tapvpwrvgnd_1
X_07274_ net777 picorv32_core.decoded_imm\[22\] VGND VGND VPWR VPWR _03414_ sky130_fd_sc_hd__or2_1
XTAP_TAPCELL_ROW_135_2265 VGND VPWR sky130_fd_sc_hd__tapvpwrvgnd_1
XPHY_EDGE_ROW_130_Left_272 VGND VGND VPWR VPWR sky130_fd_sc_hd__decap_3
XFILLER_128_27 VGND VGND VPWR VPWR sky130_fd_sc_hd__fill_1
X_09013_ net225 net1804 net347 VGND VGND VPWR VPWR _01183_ sky130_fd_sc_hd__mux2_1
X_06225_ picorv32_core.cpuregs\[28\]\[4\] picorv32_core.cpuregs\[29\]\[4\] picorv32_core.cpuregs\[30\]\[4\]
+ picorv32_core.cpuregs\[31\]\[4\] net746 net713 VGND VGND VPWR VPWR _02655_ sky130_fd_sc_hd__mux4_1
XFILLER_129_391 VGND VGND VPWR VPWR sky130_fd_sc_hd__fill_1
Xhold110 picorv32_core.cpuregs\[31\]\[18\] VGND VGND VPWR VPWR net1219 sky130_fd_sc_hd__dlygate4sd3_1
XFILLER_3_809 VPWR VGND VPWR VGND sky130_ef_sc_hd__decap_12
Xhold132 picorv32_core.cpuregs\[23\]\[20\] VGND VGND VPWR VPWR net1241 sky130_fd_sc_hd__dlygate4sd3_1
Xhold121 picorv32_core.cpuregs\[26\]\[16\] VGND VGND VPWR VPWR net1230 sky130_fd_sc_hd__dlygate4sd3_1
X_06156_ net2358 _00759_ net440 VGND VGND VPWR VPWR _00028_ sky130_fd_sc_hd__mux2_1
Xhold143 picorv32_core.cpuregs\[7\]\[4\] VGND VGND VPWR VPWR net1252 sky130_fd_sc_hd__dlygate4sd3_1
X_06087_ _02543_ _02544_ VGND VGND VPWR VPWR _02545_ sky130_fd_sc_hd__and2_1
Xhold176 picorv32_core.cpuregs\[22\]\[19\] VGND VGND VPWR VPWR net1285 sky130_fd_sc_hd__dlygate4sd3_1
Xhold154 picorv32_core.cpuregs\[19\]\[18\] VGND VGND VPWR VPWR net1263 sky130_fd_sc_hd__dlygate4sd3_1
Xhold165 picorv32_core.cpuregs\[22\]\[0\] VGND VGND VPWR VPWR net1274 sky130_fd_sc_hd__dlygate4sd3_1
X_05107_ picorv32_core.mem_do_rdata _01631_ net909 net984 VGND VGND VPWR VPWR _01639_
+ sky130_fd_sc_hd__and4bb_2
XFILLER_132_589 VGND VGND VPWR VPWR sky130_fd_sc_hd__fill_1
Xhold187 picorv32_core.cpuregs\[19\]\[22\] VGND VGND VPWR VPWR net1296 sky130_fd_sc_hd__dlygate4sd3_1
Xfanout601 _01652_ VGND VGND VPWR VPWR net601 sky130_fd_sc_hd__buf_2
Xhold198 picorv32_core.cpuregs\[11\]\[18\] VGND VGND VPWR VPWR net1307 sky130_fd_sc_hd__dlygate4sd3_1
XFILLER_77_109 VGND VGND VPWR VPWR sky130_fd_sc_hd__decap_3
X_09915_ net271 net1354 net322 VGND VGND VPWR VPWR _01399_ sky130_fd_sc_hd__mux2_1
Xfanout612 net613 VGND VGND VPWR VPWR net612 sky130_fd_sc_hd__clkbuf_2
Xfanout623 net624 VGND VGND VPWR VPWR net623 sky130_fd_sc_hd__buf_4
X_09846_ picorv32_core.cpuregs\[28\]\[30\] picorv32_core.cpuregs\[29\]\[30\] picorv32_core.cpuregs\[30\]\[30\]
+ picorv32_core.cpuregs\[31\]\[30\] net901 net867 VGND VGND VPWR VPWR _05015_ sky130_fd_sc_hd__mux4_1
Xfanout645 net646 VGND VGND VPWR VPWR net645 sky130_fd_sc_hd__buf_4
Xfanout634 net635 VGND VGND VPWR VPWR net634 sky130_fd_sc_hd__clkbuf_4
Xfanout667 net668 VGND VGND VPWR VPWR net667 sky130_fd_sc_hd__clkbuf_4
XFILLER_59_835 VGND VGND VPWR VPWR sky130_fd_sc_hd__fill_2
Xfanout656 net662 VGND VGND VPWR VPWR net656 sky130_fd_sc_hd__buf_4
Xfanout689 net691 VGND VGND VPWR VPWR net689 sky130_fd_sc_hd__buf_4
Xfanout678 net679 VGND VGND VPWR VPWR net678 sky130_fd_sc_hd__buf_2
XFILLER_46_507 VGND VGND VPWR VPWR sky130_fd_sc_hd__decap_8
X_09777_ net769 net543 _04888_ net471 VGND VGND VPWR VPWR _04949_ sky130_fd_sc_hd__o211a_1
X_06989_ _03191_ _03193_ _03199_ net664 VGND VGND VPWR VPWR _03201_ sky130_fd_sc_hd__a31o_1
XTAP_TAPCELL_ROW_29_727 VGND VPWR sky130_fd_sc_hd__tapvpwrvgnd_1
XFILLER_37_57 VGND VGND VPWR VPWR sky130_fd_sc_hd__fill_2
XFILLER_27_754 VPWR VGND VPWR VGND sky130_ef_sc_hd__decap_12
X_08728_ net1284 net432 net378 VGND VGND VPWR VPWR _00876_ sky130_fd_sc_hd__mux2_1
X_08659_ net465 net1384 net387 VGND VGND VPWR VPWR _00809_ sky130_fd_sc_hd__mux2_1
XTAP_TAPCELL_ROW_64_1238 VGND VPWR sky130_fd_sc_hd__tapvpwrvgnd_1
XTAP_TAPCELL_ROW_64_1227 VGND VPWR sky130_fd_sc_hd__tapvpwrvgnd_1
XFILLER_54_584 VGND VGND VPWR VPWR sky130_fd_sc_hd__decap_4
XFILLER_41_212 VGND VGND VPWR VPWR sky130_fd_sc_hd__fill_1
X_11670_ clknet_leaf_31_clk _01501_ VGND VGND VPWR VPWR picorv32_core.cpuregs\[26\]\[19\]
+ sky130_fd_sc_hd__dfxtp_1
XFILLER_42_757 VGND VGND VPWR VPWR sky130_fd_sc_hd__fill_2
XFILLER_139_111 VGND VGND VPWR VPWR sky130_fd_sc_hd__fill_1
XFILLER_41_278 VGND VGND VPWR VPWR sky130_fd_sc_hd__fill_2
X_10621_ clknet_leaf_94_clk _00475_ VGND VGND VPWR VPWR picorv32_core.decoded_imm_j\[5\]
+ sky130_fd_sc_hd__dfxtp_1
XFILLER_10_654 VGND VGND VPWR VPWR sky130_fd_sc_hd__fill_2
X_10552_ clknet_leaf_129_clk _00406_ VGND VGND VPWR VPWR picorv32_core.cpuregs\[25\]\[8\]
+ sky130_fd_sc_hd__dfxtp_1
XFILLER_139_199 VGND VGND VPWR VPWR sky130_fd_sc_hd__fill_1
XFILLER_5_113 VPWR VGND VPWR VGND sky130_ef_sc_hd__decap_12
X_10483_ clknet_leaf_127_clk _00369_ VGND VGND VPWR VPWR net204 sky130_fd_sc_hd__dfxtp_2
XFILLER_123_523 VGND VGND VPWR VPWR sky130_fd_sc_hd__fill_1
XTAP_TAPCELL_ROW_9_441 VGND VPWR sky130_fd_sc_hd__tapvpwrvgnd_1
XTAP_TAPCELL_ROW_9_430 VGND VPWR sky130_fd_sc_hd__tapvpwrvgnd_1
XFILLER_111_729 VPWR VGND VPWR VGND sky130_ef_sc_hd__decap_12
XFILLER_111_718 VGND VGND VPWR VPWR sky130_fd_sc_hd__decap_8
X_11104_ clknet_leaf_34_clk _00955_ VGND VGND VPWR VPWR picorv32_core.cpuregs\[0\]\[22\]
+ sky130_fd_sc_hd__dfxtp_1
XTAP_TAPCELL_ROW_75_1389 VGND VPWR sky130_fd_sc_hd__tapvpwrvgnd_1
X_11035_ clknet_leaf_25_clk _00886_ VGND VGND VPWR VPWR picorv32_core.cpuregs\[11\]\[17\]
+ sky130_fd_sc_hd__dfxtp_1
XFILLER_77_654 VGND VGND VPWR VPWR sky130_fd_sc_hd__decap_4
XFILLER_92_613 VPWR VGND VPWR VGND sky130_ef_sc_hd__decap_12
XFILLER_94_85 VGND VGND VPWR VPWR sky130_fd_sc_hd__decap_4
XFILLER_45_551 VGND VGND VPWR VPWR sky130_fd_sc_hd__decap_8
X_10819_ clknet_leaf_36_clk _00670_ VGND VGND VPWR VPWR picorv32_core.cpuregs\[15\]\[28\]
+ sky130_fd_sc_hd__dfxtp_1
X_06010_ _02472_ _02473_ VGND VGND VPWR VPWR _02474_ sky130_fd_sc_hd__nand2_1
Xoutput204 net204 VGND VGND VPWR VPWR pcpi_rs2[9] sky130_fd_sc_hd__buf_2
XTAP_TAPCELL_ROW_130_2195 VGND VPWR sky130_fd_sc_hd__tapvpwrvgnd_1
XTAP_TAPCELL_ROW_130_2184 VGND VPWR sky130_fd_sc_hd__tapvpwrvgnd_1
X_07961_ _04040_ _04041_ net458 _04038_ VGND VGND VPWR VPWR _04042_ sky130_fd_sc_hd__o211a_1
X_09700_ picorv32_core.cpuregs\[8\]\[23\] picorv32_core.cpuregs\[9\]\[23\] picorv32_core.cpuregs\[10\]\[23\]
+ picorv32_core.cpuregs\[11\]\[23\] net898 net864 VGND VGND VPWR VPWR _04876_ sky130_fd_sc_hd__mux4_1
XFILLER_114_589 VGND VGND VPWR VPWR sky130_fd_sc_hd__decap_6
X_06912_ picorv32_core.decoded_imm_j\[18\] _02930_ VGND VGND VPWR VPWR _03130_ sky130_fd_sc_hd__or2_1
XFILLER_4_83 VGND VGND VPWR VPWR sky130_fd_sc_hd__fill_1
XFILLER_114_29 VGND VGND VPWR VPWR sky130_fd_sc_hd__fill_2
X_07892_ picorv32_core.cpuregs\[20\]\[21\] picorv32_core.cpuregs\[21\]\[21\] picorv32_core.cpuregs\[22\]\[21\]
+ picorv32_core.cpuregs\[23\]\[21\] net755 net722 VGND VGND VPWR VPWR _03976_ sky130_fd_sc_hd__mux4_1
X_09631_ picorv32_core.cpuregs\[24\]\[20\] picorv32_core.cpuregs\[25\]\[20\] picorv32_core.cpuregs\[26\]\[20\]
+ picorv32_core.cpuregs\[27\]\[20\] net892 net858 VGND VGND VPWR VPWR _04810_ sky130_fd_sc_hd__mux4_1
X_06843_ net975 _03066_ VGND VGND VPWR VPWR _00241_ sky130_fd_sc_hd__nor2_1
XFILLER_28_518 VGND VGND VPWR VPWR sky130_fd_sc_hd__decap_3
XFILLER_95_495 VGND VGND VPWR VPWR sky130_fd_sc_hd__decap_8
X_09562_ picorv32_core.cpuregs\[24\]\[17\] picorv32_core.cpuregs\[25\]\[17\] picorv32_core.cpuregs\[26\]\[17\]
+ picorv32_core.cpuregs\[27\]\[17\] net889 net855 VGND VGND VPWR VPWR _04744_ sky130_fd_sc_hd__mux4_1
X_06774_ _02988_ _03002_ VGND VGND VPWR VPWR _03003_ sky130_fd_sc_hd__and2_1
XTAP_TAPCELL_ROW_104_1806 VGND VPWR sky130_fd_sc_hd__tapvpwrvgnd_1
X_05725_ _01600_ net193 _02152_ _02208_ VGND VGND VPWR VPWR _02209_ sky130_fd_sc_hd__a31o_1
XFILLER_70_318 VGND VGND VPWR VPWR sky130_fd_sc_hd__fill_1
X_08513_ _02665_ _04324_ VGND VGND VPWR VPWR _04325_ sky130_fd_sc_hd__or2_4
XTAP_TAPCELL_ROW_104_1817 VGND VPWR sky130_fd_sc_hd__tapvpwrvgnd_1
X_09493_ net612 _03489_ _04674_ _04677_ VGND VGND VPWR VPWR _04678_ sky130_fd_sc_hd__a31o_1
XFILLER_63_381 VGND VGND VPWR VPWR sky130_fd_sc_hd__decap_8
X_08444_ picorv32_core.decoded_imm\[15\] net530 _04284_ _04302_ VGND VGND VPWR VPWR
+ _00595_ sky130_fd_sc_hd__o22a_1
XFILLER_24_757 VPWR VGND VPWR VGND sky130_ef_sc_hd__decap_12
X_05656_ _02138_ _02139_ _02137_ VGND VGND VPWR VPWR _02140_ sky130_fd_sc_hd__a21o_1
X_05587_ _02044_ _02055_ _02066_ VGND VGND VPWR VPWR _02075_ sky130_fd_sc_hd__or3_1
XFILLER_23_15 VPWR VGND VPWR VGND sky130_ef_sc_hd__decap_12
X_08375_ net1154 net456 _04262_ VGND VGND VPWR VPWR _00566_ sky130_fd_sc_hd__o21a_1
XFILLER_139_15 VPWR VGND VPWR VGND sky130_ef_sc_hd__decap_12
X_07326_ _03456_ _03465_ VGND VGND VPWR VPWR _03466_ sky130_fd_sc_hd__nand2_1
XTAP_TAPCELL_ROW_34_796 VGND VPWR sky130_fd_sc_hd__tapvpwrvgnd_1
XFILLER_137_615 VGND VGND VPWR VPWR sky130_fd_sc_hd__fill_1
X_07257_ net764 picorv32_core.decoded_imm\[30\] VGND VGND VPWR VPWR _03397_ sky130_fd_sc_hd__nand2_1
XFILLER_133_821 VPWR VGND VPWR VGND sky130_ef_sc_hd__decap_12
X_07188_ net2262 _03348_ net987 VGND VGND VPWR VPWR _03350_ sky130_fd_sc_hd__o21ai_1
X_06208_ net624 _02638_ net619 VGND VGND VPWR VPWR _02639_ sky130_fd_sc_hd__a21o_1
XTAP_TAPCELL_ROW_115_1979 VGND VPWR sky130_fd_sc_hd__tapvpwrvgnd_1
XTAP_TAPCELL_ROW_115_1968 VGND VPWR sky130_fd_sc_hd__tapvpwrvgnd_1
X_06139_ net508 _02588_ _02589_ _02592_ VGND VGND VPWR VPWR picorv32_core.alu_out\[30\]
+ sky130_fd_sc_hd__a31o_1
Xfanout420 net421 VGND VGND VPWR VPWR net420 sky130_fd_sc_hd__clkbuf_8
XFILLER_59_621 VGND VGND VPWR VPWR sky130_fd_sc_hd__fill_1
Xfanout431 net432 VGND VGND VPWR VPWR net431 sky130_fd_sc_hd__clkbuf_2
XFILLER_48_12 VGND VGND VPWR VPWR sky130_fd_sc_hd__decap_3
Xfanout442 _04285_ VGND VGND VPWR VPWR net442 sky130_fd_sc_hd__buf_2
Xfanout475 net477 VGND VGND VPWR VPWR net475 sky130_fd_sc_hd__buf_2
Xfanout453 _04236_ VGND VGND VPWR VPWR net453 sky130_fd_sc_hd__buf_4
Xfanout464 _03585_ VGND VGND VPWR VPWR net464 sky130_fd_sc_hd__buf_2
X_09829_ picorv32_core.cpuregs\[0\]\[29\] picorv32_core.cpuregs\[1\]\[29\] picorv32_core.cpuregs\[2\]\[29\]
+ picorv32_core.cpuregs\[3\]\[29\] net905 net869 VGND VGND VPWR VPWR _04999_ sky130_fd_sc_hd__mux4_1
XFILLER_101_773 VGND VGND VPWR VPWR sky130_fd_sc_hd__decap_8
XFILLER_19_518 VGND VGND VPWR VPWR sky130_fd_sc_hd__fill_1
Xfanout497 _02674_ VGND VGND VPWR VPWR net497 sky130_fd_sc_hd__clkbuf_2
Xfanout486 _03391_ VGND VGND VPWR VPWR net486 sky130_fd_sc_hd__buf_2
XFILLER_58_197 VGND VGND VPWR VPWR sky130_fd_sc_hd__fill_2
XFILLER_64_33 VGND VGND VPWR VPWR sky130_fd_sc_hd__fill_1
XFILLER_14_278 VGND VGND VPWR VPWR sky130_fd_sc_hd__decap_4
X_11653_ clknet_leaf_139_clk _01484_ VGND VGND VPWR VPWR picorv32_core.cpuregs\[26\]\[2\]
+ sky130_fd_sc_hd__dfxtp_1
X_10604_ clknet_leaf_93_clk _00458_ VGND VGND VPWR VPWR picorv32_core.instr_add sky130_fd_sc_hd__dfxtp_1
X_11584_ clknet_leaf_60_clk _01415_ VGND VGND VPWR VPWR picorv32_core.cpuregs\[2\]\[31\]
+ sky130_fd_sc_hd__dfxtp_1
XTAP_TAPCELL_ROW_12_479 VGND VPWR sky130_fd_sc_hd__tapvpwrvgnd_1
X_10535_ clknet_leaf_53_clk picorv32_core.alu_out\[23\] VGND VGND VPWR VPWR picorv32_core.alu_out_q\[23\]
+ sky130_fd_sc_hd__dfxtp_1
XTAP_TAPCELL_ROW_77_1418 VGND VPWR sky130_fd_sc_hd__tapvpwrvgnd_1
XFILLER_13_81 VPWR VGND VPWR VGND sky130_ef_sc_hd__decap_12
XFILLER_129_81 VPWR VGND VPWR VGND sky130_ef_sc_hd__decap_12
XFILLER_127_169 VGND VGND VPWR VPWR sky130_fd_sc_hd__decap_4
X_10466_ clknet_leaf_73_clk _00353_ VGND VGND VPWR VPWR net58 sky130_fd_sc_hd__dfxtp_1
XFILLER_6_477 VGND VGND VPWR VPWR sky130_fd_sc_hd__decap_4
XTAP_TAPCELL_ROW_90_1607 VGND VPWR sky130_fd_sc_hd__tapvpwrvgnd_1
XFILLER_135_191 VGND VGND VPWR VPWR sky130_fd_sc_hd__fill_1
XFILLER_97_727 VGND VGND VPWR VPWR sky130_fd_sc_hd__fill_1
X_10397_ clknet_leaf_77_clk _00316_ VGND VGND VPWR VPWR picorv32_core.count_cycle\[55\]
+ sky130_fd_sc_hd__dfxtp_1
XFILLER_69_407 VGND VGND VPWR VPWR sky130_fd_sc_hd__fill_1
XFILLER_2_661 VPWR VGND VPWR VGND sky130_ef_sc_hd__decap_12
XFILLER_36_7 VPWR VGND VPWR VGND sky130_ef_sc_hd__decap_12
XFILLER_1_193 VPWR VGND VPWR VGND sky130_ef_sc_hd__decap_12
X_11018_ clknet_leaf_131_clk _00869_ VGND VGND VPWR VPWR picorv32_core.cpuregs\[11\]\[0\]
+ sky130_fd_sc_hd__dfxtp_1
XFILLER_37_304 VGND VGND VPWR VPWR sky130_fd_sc_hd__fill_2
XFILLER_92_421 VGND VGND VPWR VPWR sky130_fd_sc_hd__fill_2
Xclkbuf_leaf_138_clk clknet_4_2_0_clk VGND VGND VPWR VPWR clknet_leaf_138_clk sky130_fd_sc_hd__clkbuf_8
X_05510_ net922 _01997_ _01998_ _02004_ VGND VGND VPWR VPWR _01560_ sky130_fd_sc_hd__a31o_1
X_06490_ picorv32_core.count_instr\[8\] _02810_ net974 VGND VGND VPWR VPWR _02812_
+ sky130_fd_sc_hd__a21oi_1
XFILLER_33_543 VGND VGND VPWR VPWR sky130_fd_sc_hd__fill_1
X_05441_ net910 net303 _01937_ net148 net918 VGND VGND VPWR VPWR _01941_ sky130_fd_sc_hd__a32o_1
XTAP_TAPCELL_ROW_119_2035 VGND VPWR sky130_fd_sc_hd__tapvpwrvgnd_1
XTAP_TAPCELL_ROW_119_2024 VGND VPWR sky130_fd_sc_hd__tapvpwrvgnd_1
X_08160_ net2296 net476 _04184_ _04185_ VGND VGND VPWR VPWR _00433_ sky130_fd_sc_hd__a22o_1
XFILLER_20_248 VGND VGND VPWR VPWR sky130_fd_sc_hd__decap_4
XFILLER_119_615 VGND VGND VPWR VPWR sky130_fd_sc_hd__fill_1
X_07111_ net2337 _03299_ _03301_ VGND VGND VPWR VPWR _00274_ sky130_fd_sc_hd__o21a_1
X_05372_ picorv32_core.count_instr\[44\] net936 net940 picorv32_core.count_instr\[12\]
+ VGND VGND VPWR VPWR _01876_ sky130_fd_sc_hd__a22o_1
XTAP_TAPCELL_ROW_31_755 VGND VPWR sky130_fd_sc_hd__tapvpwrvgnd_1
XTAP_TAPCELL_ROW_132_2213 VGND VPWR sky130_fd_sc_hd__tapvpwrvgnd_1
X_08091_ picorv32_core.cpu_state\[2\] _01679_ VGND VGND VPWR VPWR _04164_ sky130_fd_sc_hd__nand2_1
XTAP_TAPCELL_ROW_132_2224 VGND VPWR sky130_fd_sc_hd__tapvpwrvgnd_1
X_07042_ net677 _03248_ _03249_ _03247_ VGND VGND VPWR VPWR _03250_ sky130_fd_sc_hd__o31a_1
XFILLER_106_309 VGND VGND VPWR VPWR sky130_fd_sc_hd__decap_6
Xclkload52 clknet_leaf_29_clk VGND VGND VPWR VPWR clkload52/Y sky130_fd_sc_hd__inv_12
Xclkload41 clknet_leaf_16_clk VGND VGND VPWR VPWR clkload41/Y sky130_fd_sc_hd__inv_6
Xclkload30 clknet_leaf_132_clk VGND VGND VPWR VPWR clkload30/Y sky130_fd_sc_hd__clkinvlp_4
Xclkload74 clknet_leaf_45_clk VGND VGND VPWR VPWR clkload74/Y sky130_fd_sc_hd__inv_8
XFILLER_115_821 VGND VGND VPWR VPWR sky130_fd_sc_hd__decap_4
Xclkload63 clknet_leaf_17_clk VGND VGND VPWR VPWR clkload63/Y sky130_fd_sc_hd__inv_8
Xclkload96 clknet_leaf_125_clk VGND VGND VPWR VPWR clkload96/Y sky130_fd_sc_hd__inv_8
Xclkload85 clknet_leaf_117_clk VGND VGND VPWR VPWR clkload85/X sky130_fd_sc_hd__clkbuf_8
XFILLER_130_813 VPWR VGND VPWR VGND sky130_ef_sc_hd__decap_12
XFILLER_88_716 VGND VGND VPWR VPWR sky130_fd_sc_hd__decap_8
XFILLER_125_39 VPWR VGND VPWR VGND sky130_ef_sc_hd__decap_12
XFILLER_114_375 VGND VGND VPWR VPWR sky130_fd_sc_hd__decap_3
X_08993_ net445 net1925 net344 VGND VGND VPWR VPWR _01163_ sky130_fd_sc_hd__mux2_1
X_07944_ net188 net511 _04025_ VGND VGND VPWR VPWR _00383_ sky130_fd_sc_hd__o21a_1
X_07875_ picorv32_core.cpuregs\[20\]\[20\] picorv32_core.cpuregs\[21\]\[20\] picorv32_core.cpuregs\[22\]\[20\]
+ picorv32_core.cpuregs\[23\]\[20\] net755 net722 VGND VGND VPWR VPWR _03960_ sky130_fd_sc_hd__mux4_1
XTAP_TAPCELL_ROW_110_1898 VGND VPWR sky130_fd_sc_hd__tapvpwrvgnd_1
XFILLER_18_15 VPWR VGND VPWR VGND sky130_ef_sc_hd__decap_12
XFILLER_29_827 VGND VGND VPWR VPWR sky130_fd_sc_hd__fill_1
XFILLER_141_27 VGND VGND VPWR VPWR sky130_fd_sc_hd__fill_1
XFILLER_95_281 VGND VGND VPWR VPWR sky130_fd_sc_hd__decap_4
X_09614_ picorv32_core.cpuregs\[12\]\[19\] picorv32_core.cpuregs\[13\]\[19\] picorv32_core.cpuregs\[14\]\[19\]
+ picorv32_core.cpuregs\[15\]\[19\] net890 net856 VGND VGND VPWR VPWR _04794_ sky130_fd_sc_hd__mux4_1
X_06826_ _03048_ _03050_ VGND VGND VPWR VPWR _03051_ sky130_fd_sc_hd__xnor2_1
XTAP_TAPCELL_ROW_48_1008 VGND VPWR sky130_fd_sc_hd__tapvpwrvgnd_1
XTAP_TAPCELL_ROW_39_866 VGND VPWR sky130_fd_sc_hd__tapvpwrvgnd_1
XTAP_TAPCELL_ROW_39_877 VGND VPWR sky130_fd_sc_hd__tapvpwrvgnd_1
X_09545_ picorv32_core.cpuregs\[8\]\[16\] picorv32_core.cpuregs\[9\]\[16\] picorv32_core.cpuregs\[10\]\[16\]
+ picorv32_core.cpuregs\[11\]\[16\] net893 net859 VGND VGND VPWR VPWR _04728_ sky130_fd_sc_hd__mux4_1
XFILLER_70_104 VGND VGND VPWR VPWR sky130_fd_sc_hd__decap_4
X_06757_ net975 _02987_ VGND VGND VPWR VPWR _00234_ sky130_fd_sc_hd__nor2_1
Xclkbuf_leaf_129_clk clknet_4_3_0_clk VGND VGND VPWR VPWR clknet_leaf_129_clk sky130_fd_sc_hd__clkbuf_8
X_06688_ picorv32_core.reg_pc\[21\] net553 _02933_ net516 VGND VGND VPWR VPWR _00219_
+ sky130_fd_sc_hd__a22o_1
X_05708_ net797 net957 VGND VGND VPWR VPWR _02192_ sky130_fd_sc_hd__nand2_1
X_09476_ picorv32_core.cpuregs\[0\]\[13\] picorv32_core.cpuregs\[1\]\[13\] picorv32_core.cpuregs\[2\]\[13\]
+ picorv32_core.cpuregs\[3\]\[13\] net882 net849 VGND VGND VPWR VPWR _04662_ sky130_fd_sc_hd__mux4_1
XFILLER_36_392 VGND VGND VPWR VPWR sky130_fd_sc_hd__decap_3
X_08427_ picorv32_core.mem_rdata_q\[23\] net614 VGND VGND VPWR VPWR _04294_ sky130_fd_sc_hd__and2_1
XFILLER_24_587 VGND VGND VPWR VPWR sky130_fd_sc_hd__fill_1
X_05639_ net809 net963 VGND VGND VPWR VPWR _02123_ sky130_fd_sc_hd__or2_1
X_08358_ picorv32_core.mem_la_wdata\[1\] net181 net581 VGND VGND VPWR VPWR _04254_
+ sky130_fd_sc_hd__mux2_1
Xclkload2 clknet_4_2_0_clk VGND VGND VPWR VPWR clkload2/X sky130_fd_sc_hd__clkbuf_8
X_08289_ net1761 net223 net412 VGND VGND VPWR VPWR _00513_ sky130_fd_sc_hd__mux2_1
XFILLER_50_46 VGND VGND VPWR VPWR sky130_fd_sc_hd__decap_3
XFILLER_20_793 VGND VGND VPWR VPWR sky130_fd_sc_hd__decap_3
X_07309_ _03448_ VGND VGND VPWR VPWR _03449_ sky130_fd_sc_hd__inv_2
X_10320_ clknet_leaf_91_clk _00239_ VGND VGND VPWR VPWR picorv32_core.reg_next_pc\[10\]
+ sky130_fd_sc_hd__dfxtp_1
XFILLER_124_139 VGND VGND VPWR VPWR sky130_fd_sc_hd__fill_1
XTAP_TAPCELL_ROW_59_1159 VGND VPWR sky130_fd_sc_hd__tapvpwrvgnd_1
X_10251_ clknet_leaf_103_clk _00170_ VGND VGND VPWR VPWR picorv32_core.count_instr\[35\]
+ sky130_fd_sc_hd__dfxtp_1
XFILLER_3_447 VGND VGND VPWR VPWR sky130_fd_sc_hd__fill_1
X_10182_ clknet_leaf_66_clk _00101_ VGND VGND VPWR VPWR picorv32_core.cpuregs\[21\]\[30\]
+ sky130_fd_sc_hd__dfxtp_1
XTAP_TAPCELL_ROW_72_1348 VGND VPWR sky130_fd_sc_hd__tapvpwrvgnd_1
Xfanout250 _02747_ VGND VGND VPWR VPWR net250 sky130_fd_sc_hd__clkbuf_2
XFILLER_87_760 VGND VGND VPWR VPWR sky130_fd_sc_hd__decap_8
Xfanout261 net262 VGND VGND VPWR VPWR net261 sky130_fd_sc_hd__clkbuf_2
Xfanout272 _02723_ VGND VGND VPWR VPWR net272 sky130_fd_sc_hd__clkbuf_2
Xfanout283 _03394_ VGND VGND VPWR VPWR net283 sky130_fd_sc_hd__buf_2
XFILLER_59_495 VGND VGND VPWR VPWR sky130_fd_sc_hd__decap_8
Xfanout294 _02706_ VGND VGND VPWR VPWR net294 sky130_fd_sc_hd__clkbuf_2
XFILLER_46_112 VGND VGND VPWR VPWR sky130_fd_sc_hd__fill_1
XFILLER_62_616 VGND VGND VPWR VPWR sky130_fd_sc_hd__decap_4
XFILLER_46_145 VGND VGND VPWR VPWR sky130_fd_sc_hd__fill_1
XFILLER_74_487 VPWR VGND VPWR VGND sky130_ef_sc_hd__decap_12
XFILLER_27_370 VGND VGND VPWR VPWR sky130_fd_sc_hd__decap_4
XFILLER_46_178 VGND VGND VPWR VPWR sky130_fd_sc_hd__fill_2
XPHY_EDGE_ROW_141_Right_141 VGND VGND VPWR VPWR sky130_fd_sc_hd__decap_3
XFILLER_131_93 VPWR VGND VPWR VGND sky130_ef_sc_hd__decap_12
XFILLER_91_31 VGND VGND VPWR VPWR sky130_fd_sc_hd__decap_6
XTAP_TAPCELL_ROW_17_549 VGND VPWR sky130_fd_sc_hd__tapvpwrvgnd_1
X_11705_ clknet_leaf_32_clk _01536_ VGND VGND VPWR VPWR picorv32_core.cpuregs\[27\]\[22\]
+ sky130_fd_sc_hd__dfxtp_1
X_11636_ clknet_leaf_23_clk _01467_ VGND VGND VPWR VPWR picorv32_core.cpuregs\[28\]\[17\]
+ sky130_fd_sc_hd__dfxtp_1
X_11567_ clknet_leaf_6_clk _01398_ VGND VGND VPWR VPWR picorv32_core.cpuregs\[2\]\[14\]
+ sky130_fd_sc_hd__dfxtp_1
Xhold709 picorv32_core.cpuregs\[31\]\[21\] VGND VGND VPWR VPWR net1818 sky130_fd_sc_hd__dlygate4sd3_1
XFILLER_7_753 VPWR VGND VPWR VGND sky130_ef_sc_hd__decap_12
X_10518_ clknet_leaf_127_clk picorv32_core.alu_out\[6\] VGND VGND VPWR VPWR picorv32_core.alu_out_q\[6\]
+ sky130_fd_sc_hd__dfxtp_1
X_11498_ clknet_leaf_55_clk _01334_ VGND VGND VPWR VPWR net147 sky130_fd_sc_hd__dfxtp_1
XFILLER_7_797 VPWR VGND VPWR VGND sky130_ef_sc_hd__decap_12
X_10449_ clknet_leaf_100_clk _00336_ VGND VGND VPWR VPWR net41 sky130_fd_sc_hd__dfxtp_1
XFILLER_112_813 VGND VGND VPWR VPWR sky130_fd_sc_hd__decap_3
XFILLER_123_183 VGND VGND VPWR VPWR sky130_fd_sc_hd__fill_2
X_05990_ net785 net182 net569 VGND VGND VPWR VPWR _02456_ sky130_fd_sc_hd__and3_1
XFILLER_27_3 VPWR VGND VPWR VGND sky130_ef_sc_hd__decap_12
XFILLER_65_454 VGND VGND VPWR VPWR sky130_fd_sc_hd__fill_1
X_07660_ picorv32_core.cpuregs\[12\]\[8\] picorv32_core.cpuregs\[13\]\[8\] picorv32_core.cpuregs\[14\]\[8\]
+ picorv32_core.cpuregs\[15\]\[8\] net739 net706 VGND VGND VPWR VPWR _03757_ sky130_fd_sc_hd__mux4_1
XFILLER_93_796 VGND VGND VPWR VPWR sky130_fd_sc_hd__fill_2
X_06611_ picorv32_core.count_instr\[52\] _02887_ VGND VGND VPWR VPWR _02889_ sky130_fd_sc_hd__nand2_1
X_07591_ net590 _02641_ VGND VGND VPWR VPWR _03693_ sky130_fd_sc_hd__or2_1
XTAP_TAPCELL_ROW_36_825 VGND VPWR sky130_fd_sc_hd__tapvpwrvgnd_1
XFILLER_37_189 VGND VGND VPWR VPWR sky130_fd_sc_hd__fill_2
X_06542_ _02844_ _02845_ VGND VGND VPWR VPWR _00161_ sky130_fd_sc_hd__nor2_1
X_09330_ net282 _04507_ _04522_ VGND VGND VPWR VPWR _04523_ sky130_fd_sc_hd__and3_1
X_09261_ net823 net806 net540 VGND VGND VPWR VPWR _04456_ sky130_fd_sc_hd__mux2_1
X_08212_ picorv32_core.mem_rdata_q\[30\] picorv32_core.is_alu_reg_reg _04202_ _04203_
+ VGND VGND VPWR VPWR _04209_ sky130_fd_sc_hd__and4_1
X_06473_ _02801_ net984 _02800_ VGND VGND VPWR VPWR _00136_ sky130_fd_sc_hd__and3b_1
X_05424_ picorv32_core.count_cycle\[15\] net601 net578 _01924_ VGND VGND VPWR VPWR
+ _01925_ sky130_fd_sc_hd__o211a_1
X_09192_ picorv32_core.cpuregs\[0\]\[1\] picorv32_core.cpuregs\[1\]\[1\] net887 VGND
+ VGND VPWR VPWR _04390_ sky130_fd_sc_hd__mux2_1
Xpicorv32_axi_1108 VGND VGND VPWR VPWR picorv32_axi_1108/HI trace_data[35] sky130_fd_sc_hd__conb_1
XFILLER_119_434 VPWR VGND VPWR VGND sky130_ef_sc_hd__decap_12
X_05355_ picorv32_core.reg_pc\[11\] picorv32_core.decoded_imm\[11\] VGND VGND VPWR
+ VPWR _01860_ sky130_fd_sc_hd__nand2_1
X_08143_ _02600_ _00747_ VGND VGND VPWR VPWR _04174_ sky130_fd_sc_hd__nor2_1
XFILLER_119_489 VGND VGND VPWR VPWR sky130_fd_sc_hd__fill_1
X_08074_ picorv32_core.cpuregs\[24\]\[31\] picorv32_core.cpuregs\[25\]\[31\] picorv32_core.cpuregs\[26\]\[31\]
+ picorv32_core.cpuregs\[27\]\[31\] net760 net727 VGND VGND VPWR VPWR _04148_ sky130_fd_sc_hd__mux4_1
Xclkload130 clknet_leaf_81_clk VGND VGND VPWR VPWR clkload130/Y sky130_fd_sc_hd__bufinv_16
Xclkload141 clknet_leaf_76_clk VGND VGND VPWR VPWR clkload141/Y sky130_fd_sc_hd__inv_6
X_07025_ _03215_ _03223_ VGND VGND VPWR VPWR _03234_ sky130_fd_sc_hd__nor2_1
X_05286_ _01793_ _01795_ VGND VGND VPWR VPWR _01796_ sky130_fd_sc_hd__xnor2_1
XFILLER_136_27 VGND VGND VPWR VPWR sky130_fd_sc_hd__fill_1
XTAP_TAPCELL_ROW_112_1927 VGND VPWR sky130_fd_sc_hd__tapvpwrvgnd_1
XFILLER_88_524 VGND VGND VPWR VPWR sky130_fd_sc_hd__fill_1
XFILLER_0_406 VGND VGND VPWR VPWR sky130_fd_sc_hd__decap_3
XFILLER_130_643 VGND VGND VPWR VPWR sky130_fd_sc_hd__fill_1
XFILLER_114_183 VGND VGND VPWR VPWR sky130_fd_sc_hd__fill_2
Xhold14 picorv32_core.cpuregs\[0\]\[16\] VGND VGND VPWR VPWR net1123 sky130_fd_sc_hd__dlygate4sd3_1
X_08976_ net1877 net238 net350 VGND VGND VPWR VPWR _01148_ sky130_fd_sc_hd__mux2_1
Xhold25 picorv32_core.cpuregs\[0\]\[24\] VGND VGND VPWR VPWR net1134 sky130_fd_sc_hd__dlygate4sd3_1
Xhold47 picorv32_core.instr_ori VGND VGND VPWR VPWR net1156 sky130_fd_sc_hd__dlygate4sd3_1
Xhold36 _00032_ VGND VGND VPWR VPWR net1145 sky130_fd_sc_hd__dlygate4sd3_1
XTAP_TAPCELL_ROW_54_1089 VGND VPWR sky130_fd_sc_hd__tapvpwrvgnd_1
X_07927_ _04008_ _04009_ net458 _04006_ VGND VGND VPWR VPWR _04010_ sky130_fd_sc_hd__o211a_1
Xhold58 _00033_ VGND VGND VPWR VPWR net1167 sky130_fd_sc_hd__dlygate4sd3_1
Xhold69 picorv32_core.instr_auipc VGND VGND VPWR VPWR net1178 sky130_fd_sc_hd__dlygate4sd3_1
XFILLER_56_410 VGND VGND VPWR VPWR sky130_fd_sc_hd__decap_6
X_07858_ picorv32_core.cpuregs\[24\]\[19\] picorv32_core.cpuregs\[25\]\[19\] picorv32_core.cpuregs\[26\]\[19\]
+ picorv32_core.cpuregs\[27\]\[19\] net749 net716 VGND VGND VPWR VPWR _03944_ sky130_fd_sc_hd__mux4_1
X_07789_ picorv32_core.cpuregs\[16\]\[15\] picorv32_core.cpuregs\[17\]\[15\] picorv32_core.cpuregs\[18\]\[15\]
+ picorv32_core.cpuregs\[19\]\[15\] net751 net718 VGND VGND VPWR VPWR _03879_ sky130_fd_sc_hd__mux4_1
X_06809_ picorv32_core.decoded_imm_j\[10\] _02922_ VGND VGND VPWR VPWR _03035_ sky130_fd_sc_hd__or2_1
XFILLER_16_307 VGND VGND VPWR VPWR sky130_fd_sc_hd__fill_1
X_09528_ _04707_ _04710_ _04711_ net643 net650 VGND VGND VPWR VPWR _04712_ sky130_fd_sc_hd__a221o_1
XTAP_TAPCELL_ROW_14_508 VGND VPWR sky130_fd_sc_hd__tapvpwrvgnd_1
XFILLER_101_85 VGND VGND VPWR VPWR sky130_fd_sc_hd__decap_3
XFILLER_101_63 VGND VGND VPWR VPWR sky130_fd_sc_hd__fill_1
X_09459_ picorv32_core.cpuregs\[8\]\[12\] picorv32_core.cpuregs\[9\]\[12\] picorv32_core.cpuregs\[10\]\[12\]
+ picorv32_core.cpuregs\[11\]\[12\] net879 net846 VGND VGND VPWR VPWR _04646_ sky130_fd_sc_hd__mux4_1
XFILLER_131_3 VPWR VGND VPWR VGND sky130_ef_sc_hd__decap_12
XFILLER_8_506 VGND VGND VPWR VPWR sky130_fd_sc_hd__fill_2
X_11421_ clknet_leaf_109_clk _01257_ VGND VGND VPWR VPWR picorv32_core.cpuregs\[1\]\[4\]
+ sky130_fd_sc_hd__dfxtp_1
XFILLER_6_29 VPWR VGND VPWR VGND sky130_ef_sc_hd__decap_12
XFILLER_6_18 VGND VGND VPWR VPWR sky130_fd_sc_hd__decap_8
XFILLER_4_701 VPWR VGND VPWR VGND sky130_ef_sc_hd__decap_12
X_11352_ clknet_leaf_116_clk _01193_ VGND VGND VPWR VPWR picorv32_core.cpuregs\[18\]\[4\]
+ sky130_fd_sc_hd__dfxtp_1
X_10303_ clknet_leaf_61_clk _00222_ VGND VGND VPWR VPWR picorv32_core.reg_pc\[24\]
+ sky130_fd_sc_hd__dfxtp_1
X_11283_ clknet_leaf_143_clk _01131_ VGND VGND VPWR VPWR picorv32_core.cpuregs\[3\]\[6\]
+ sky130_fd_sc_hd__dfxtp_1
X_10234_ clknet_leaf_80_clk _00153_ VGND VGND VPWR VPWR picorv32_core.count_instr\[18\]
+ sky130_fd_sc_hd__dfxtp_1
XFILLER_3_277 VGND VGND VPWR VPWR sky130_fd_sc_hd__decap_3
X_10165_ clknet_leaf_10_clk _00084_ VGND VGND VPWR VPWR picorv32_core.cpuregs\[21\]\[13\]
+ sky130_fd_sc_hd__dfxtp_1
XFILLER_10_93 VGND VGND VPWR VPWR sky130_fd_sc_hd__fill_1
X_10096_ net1129 VGND VGND VPWR VPWR _00946_ sky130_fd_sc_hd__clkbuf_1
XFILLER_75_752 VPWR VGND VPWR VGND sky130_ef_sc_hd__decap_12
XTAP_TAPCELL_ROW_85_1539 VGND VPWR sky130_fd_sc_hd__tapvpwrvgnd_1
XFILLER_74_262 VGND VGND VPWR VPWR sky130_fd_sc_hd__decap_4
XFILLER_19_178 VGND VGND VPWR VPWR sky130_fd_sc_hd__decap_4
X_10998_ clknet_leaf_8_clk _00849_ VGND VGND VPWR VPWR picorv32_core.cpuregs\[12\]\[12\]
+ sky130_fd_sc_hd__dfxtp_1
X_11619_ clknet_leaf_134_clk _01450_ VGND VGND VPWR VPWR picorv32_core.cpuregs\[28\]\[0\]
+ sky130_fd_sc_hd__dfxtp_1
XFILLER_30_365 VGND VGND VPWR VPWR sky130_fd_sc_hd__decap_3
XTAP_TAPCELL_ROW_41_894 VGND VPWR sky130_fd_sc_hd__tapvpwrvgnd_1
XFILLER_128_253 VGND VGND VPWR VPWR sky130_fd_sc_hd__fill_2
X_05140_ net824 net822 _01668_ _01669_ VGND VGND VPWR VPWR _01670_ sky130_fd_sc_hd__o211a_1
Xhold506 picorv32_core.cpuregs\[28\]\[21\] VGND VGND VPWR VPWR net1615 sky130_fd_sc_hd__dlygate4sd3_1
Xhold517 picorv32_core.cpuregs\[8\]\[1\] VGND VGND VPWR VPWR net1626 sky130_fd_sc_hd__dlygate4sd3_1
Xhold539 picorv32_core.cpuregs\[14\]\[26\] VGND VGND VPWR VPWR net1648 sky130_fd_sc_hd__dlygate4sd3_1
Xhold528 picorv32_core.cpuregs\[29\]\[18\] VGND VGND VPWR VPWR net1637 sky130_fd_sc_hd__dlygate4sd3_1
X_05071_ net177 VGND VGND VPWR VPWR _01606_ sky130_fd_sc_hd__inv_2
XFILLER_98_811 VGND VGND VPWR VPWR sky130_fd_sc_hd__fill_1
XFILLER_124_492 VGND VGND VPWR VPWR sky130_fd_sc_hd__fill_1
XFILLER_112_643 VGND VGND VPWR VPWR sky130_fd_sc_hd__fill_1
XFILLER_112_621 VGND VGND VPWR VPWR sky130_fd_sc_hd__decap_4
XFILLER_106_19 VGND VGND VPWR VPWR sky130_fd_sc_hd__fill_1
X_08830_ net1526 net298 net366 VGND VGND VPWR VPWR _01006_ sky130_fd_sc_hd__mux2_1
Xhold1206 picorv32_core.mem_rdata_q\[0\] VGND VGND VPWR VPWR net2315 sky130_fd_sc_hd__dlygate4sd3_1
XTAP_TAPCELL_ROW_127_2145 VGND VPWR sky130_fd_sc_hd__tapvpwrvgnd_1
XFILLER_112_698 VGND VGND VPWR VPWR sky130_fd_sc_hd__fill_2
Xhold1217 net56 VGND VGND VPWR VPWR net2326 sky130_fd_sc_hd__dlygate4sd3_1
X_05973_ _02432_ _02435_ VGND VGND VPWR VPWR _02440_ sky130_fd_sc_hd__nand2_1
Xhold1228 picorv32_core.count_cycle\[13\] VGND VGND VPWR VPWR net2337 sky130_fd_sc_hd__dlygate4sd3_1
Xhold1239 axi_adapter.ack_wvalid VGND VGND VPWR VPWR net2348 sky130_fd_sc_hd__dlygate4sd3_1
X_08761_ net431 net2100 net374 VGND VGND VPWR VPWR _00908_ sky130_fd_sc_hd__mux2_1
XFILLER_122_29 VPWR VGND VPWR VGND sky130_ef_sc_hd__decap_12
X_08692_ net1509 net465 net383 VGND VGND VPWR VPWR _00841_ sky130_fd_sc_hd__mux2_1
X_07712_ picorv32_core.cpuregs\[28\]\[11\] picorv32_core.cpuregs\[29\]\[11\] picorv32_core.cpuregs\[30\]\[11\]
+ picorv32_core.cpuregs\[31\]\[11\] net736 net703 VGND VGND VPWR VPWR _03806_ sky130_fd_sc_hd__mux4_1
XFILLER_93_571 VGND VGND VPWR VPWR sky130_fd_sc_hd__decap_4
X_07643_ picorv32_core.cpuregs\[8\]\[7\] picorv32_core.cpuregs\[9\]\[7\] picorv32_core.cpuregs\[10\]\[7\]
+ picorv32_core.cpuregs\[11\]\[7\] net734 net701 VGND VGND VPWR VPWR _03741_ sky130_fd_sc_hd__mux4_1
XTAP_TAPCELL_ROW_140_2334 VGND VPWR sky130_fd_sc_hd__tapvpwrvgnd_1
X_07574_ _03676_ _03677_ net633 VGND VGND VPWR VPWR _03678_ sky130_fd_sc_hd__mux2_1
X_09313_ net474 _04505_ _04504_ net485 VGND VGND VPWR VPWR _04506_ sky130_fd_sc_hd__a211o_1
X_06525_ _02833_ _02834_ VGND VGND VPWR VPWR _00155_ sky130_fd_sc_hd__nor2_1
XFILLER_139_518 VGND VGND VPWR VPWR sky130_fd_sc_hd__fill_1
Xclkbuf_leaf_60_clk clknet_4_13_0_clk VGND VGND VPWR VPWR clknet_leaf_60_clk sky130_fd_sc_hd__clkbuf_8
X_06456_ net253 net1949 net420 VGND VGND VPWR VPWR _00122_ sky130_fd_sc_hd__mux2_1
X_09244_ net656 _04439_ net827 VGND VGND VPWR VPWR _04440_ sky130_fd_sc_hd__a21o_1
X_05407_ picorv32_core.reg_pc\[14\] picorv32_core.decoded_imm\[14\] VGND VGND VPWR
+ VPWR _01909_ sky130_fd_sc_hd__or2_1
X_09175_ net823 net282 _04369_ _04373_ VGND VGND VPWR VPWR _01319_ sky130_fd_sc_hd__o22a_1
XFILLER_31_15 VPWR VGND VPWR VGND sky130_ef_sc_hd__decap_12
X_08126_ net246 net2169 net416 VGND VGND VPWR VPWR _00419_ sky130_fd_sc_hd__mux2_1
X_06387_ picorv32_core.reg_pc\[29\] picorv32_core.reg_pc\[28\] _02776_ VGND VGND VPWR
+ VPWR _02784_ sky130_fd_sc_hd__and3_1
X_05338_ picorv32_core.count_cycle\[9\] _01652_ net576 _01844_ VGND VGND VPWR VPWR
+ _01845_ sky130_fd_sc_hd__o211a_1
X_08057_ picorv32_core.cpuregs\[4\]\[30\] picorv32_core.cpuregs\[5\]\[30\] picorv32_core.cpuregs\[6\]\[30\]
+ picorv32_core.cpuregs\[7\]\[30\] net759 net726 VGND VGND VPWR VPWR _04132_ sky130_fd_sc_hd__mux4_1
XTAP_TAPCELL_ROW_56_1118 VGND VPWR sky130_fd_sc_hd__tapvpwrvgnd_1
XPHY_EDGE_ROW_1_Right_1 VGND VGND VPWR VPWR sky130_fd_sc_hd__decap_3
X_05269_ _01778_ _01779_ VGND VGND VPWR VPWR _01780_ sky130_fd_sc_hd__nor2_1
Xoutput48 net48 VGND VGND VPWR VPWR mem_axi_araddr[19] sky130_fd_sc_hd__buf_2
XFILLER_103_610 VGND VGND VPWR VPWR sky130_fd_sc_hd__fill_2
X_07008_ _02937_ _03203_ VGND VGND VPWR VPWR _03219_ sky130_fd_sc_hd__and2_1
XFILLER_0_225 VPWR VGND VPWR VGND sky130_ef_sc_hd__decap_12
Xoutput59 net59 VGND VGND VPWR VPWR mem_axi_araddr[2] sky130_fd_sc_hd__buf_2
XFILLER_130_451 VGND VGND VPWR VPWR sky130_fd_sc_hd__decap_3
XFILLER_103_665 VGND VGND VPWR VPWR sky130_fd_sc_hd__decap_6
XFILLER_102_197 VGND VGND VPWR VPWR sky130_fd_sc_hd__decap_4
XFILLER_76_527 VGND VGND VPWR VPWR sky130_fd_sc_hd__decap_4
X_08959_ net1247 net443 net348 VGND VGND VPWR VPWR _01131_ sky130_fd_sc_hd__mux2_1
XFILLER_57_741 VGND VGND VPWR VPWR sky130_fd_sc_hd__decap_4
X_10921_ clknet_leaf_82_clk _00772_ VGND VGND VPWR VPWR picorv32_core.mem_rdata_q\[31\]
+ sky130_fd_sc_hd__dfxtp_2
XFILLER_56_284 VGND VGND VPWR VPWR sky130_fd_sc_hd__decap_3
XFILLER_44_457 VGND VGND VPWR VPWR sky130_fd_sc_hd__decap_4
X_10852_ clknet_leaf_67_clk _00703_ VGND VGND VPWR VPWR picorv32_core.cpuregs\[17\]\[29\]
+ sky130_fd_sc_hd__dfxtp_1
XFILLER_112_73 VGND VGND VPWR VPWR sky130_fd_sc_hd__fill_2
XFILLER_72_799 VGND VGND VPWR VPWR sky130_fd_sc_hd__fill_1
XFILLER_25_671 VGND VGND VPWR VPWR sky130_fd_sc_hd__fill_1
X_10783_ clknet_leaf_33_clk _00634_ VGND VGND VPWR VPWR picorv32_core.cpuregs\[14\]\[24\]
+ sky130_fd_sc_hd__dfxtp_1
XFILLER_13_833 VGND VGND VPWR VPWR sky130_fd_sc_hd__fill_1
XTAP_TAPCELL_ROW_27_699 VGND VPWR sky130_fd_sc_hd__tapvpwrvgnd_1
Xclkbuf_leaf_51_clk clknet_4_6_0_clk VGND VGND VPWR VPWR clknet_leaf_51_clk sky130_fd_sc_hd__clkbuf_8
XTAP_TAPCELL_ROW_80_1469 VGND VPWR sky130_fd_sc_hd__tapvpwrvgnd_1
XTAP_TAPCELL_ROW_80_1458 VGND VPWR sky130_fd_sc_hd__tapvpwrvgnd_1
X_11404_ clknet_leaf_22_clk _01240_ VGND VGND VPWR VPWR picorv32_core.cpuregs\[31\]\[19\]
+ sky130_fd_sc_hd__dfxtp_1
XFILLER_126_757 VPWR VGND VPWR VGND sky130_ef_sc_hd__decap_12
XFILLER_125_256 VGND VGND VPWR VPWR sky130_fd_sc_hd__decap_4
XFILLER_125_234 VGND VGND VPWR VPWR sky130_fd_sc_hd__fill_1
X_11335_ clknet_leaf_22_clk _01176_ VGND VGND VPWR VPWR picorv32_core.cpuregs\[29\]\[19\]
+ sky130_fd_sc_hd__dfxtp_1
XFILLER_21_81 VGND VGND VPWR VPWR sky130_fd_sc_hd__fill_1
XFILLER_141_727 VGND VGND VPWR VPWR sky130_fd_sc_hd__fill_1
XFILLER_140_215 VGND VGND VPWR VPWR sky130_fd_sc_hd__decap_8
XFILLER_137_81 VPWR VGND VPWR VGND sky130_ef_sc_hd__decap_12
X_11266_ clknet_leaf_50_clk _01114_ VGND VGND VPWR VPWR picorv32_core.cpuregs\[4\]\[21\]
+ sky130_fd_sc_hd__dfxtp_1
X_10217_ clknet_leaf_105_clk _00136_ VGND VGND VPWR VPWR picorv32_core.count_instr\[1\]
+ sky130_fd_sc_hd__dfxtp_1
X_11197_ clknet_leaf_28_clk _01048_ VGND VGND VPWR VPWR picorv32_core.cpuregs\[6\]\[19\]
+ sky130_fd_sc_hd__dfxtp_1
XFILLER_79_365 VGND VGND VPWR VPWR sky130_fd_sc_hd__fill_1
XFILLER_67_505 VGND VGND VPWR VPWR sky130_fd_sc_hd__decap_3
X_10148_ clknet_leaf_68_clk _00070_ VGND VGND VPWR VPWR picorv32_core.cpuregs\[22\]\[31\]
+ sky130_fd_sc_hd__dfxtp_1
XFILLER_95_836 VGND VGND VPWR VPWR sky130_fd_sc_hd__fill_1
XFILLER_67_549 VGND VGND VPWR VPWR sky130_fd_sc_hd__decap_4
XFILLER_11_6 VPWR VGND VPWR VGND sky130_ef_sc_hd__decap_12
X_10079_ picorv32_core.decoded_imm_j\[11\] _00761_ net438 VGND VGND VPWR VPWR _00527_
+ sky130_fd_sc_hd__mux2_1
XFILLER_48_774 VGND VGND VPWR VPWR sky130_fd_sc_hd__decap_4
XFILLER_63_733 VGND VGND VPWR VPWR sky130_fd_sc_hd__fill_1
XTAP_TAPCELL_ROW_122_2075 VGND VPWR sky130_fd_sc_hd__tapvpwrvgnd_1
XTAP_TAPCELL_ROW_46_975 VGND VPWR sky130_fd_sc_hd__tapvpwrvgnd_1
Xclkbuf_leaf_42_clk clknet_4_7_0_clk VGND VGND VPWR VPWR clknet_leaf_42_clk sky130_fd_sc_hd__clkbuf_8
X_06310_ picorv32_core.reg_pc\[14\] _02718_ VGND VGND VPWR VPWR _02722_ sky130_fd_sc_hd__xor2_1
X_07290_ net797 picorv32_core.decoded_imm\[12\] VGND VGND VPWR VPWR _03430_ sky130_fd_sc_hd__nand2_1
XTAP_TAPCELL_ROW_98_1719 VGND VPWR sky130_fd_sc_hd__tapvpwrvgnd_1
X_06241_ _02664_ _02666_ VGND VGND VPWR VPWR _02667_ sky130_fd_sc_hd__nor2_4
X_06172_ _02602_ _02603_ net694 VGND VGND VPWR VPWR _02604_ sky130_fd_sc_hd__mux2_1
Xhold314 picorv32_core.cpuregs\[20\]\[29\] VGND VGND VPWR VPWR net1423 sky130_fd_sc_hd__dlygate4sd3_1
Xhold325 picorv32_core.cpuregs\[24\]\[29\] VGND VGND VPWR VPWR net1434 sky130_fd_sc_hd__dlygate4sd3_1
X_05123_ _00031_ _01633_ _01650_ net599 VGND VGND VPWR VPWR _01654_ sky130_fd_sc_hd__or4_1
Xhold303 picorv32_core.cpuregs\[1\]\[9\] VGND VGND VPWR VPWR net1412 sky130_fd_sc_hd__dlygate4sd3_1
Xhold336 picorv32_core.cpuregs\[23\]\[23\] VGND VGND VPWR VPWR net1445 sky130_fd_sc_hd__dlygate4sd3_1
X_09931_ net207 net1801 net323 VGND VGND VPWR VPWR _01415_ sky130_fd_sc_hd__mux2_1
X_05054_ net996 VGND VGND VPWR VPWR _01589_ sky130_fd_sc_hd__inv_2
Xhold347 picorv32_core.cpuregs\[14\]\[16\] VGND VGND VPWR VPWR net1456 sky130_fd_sc_hd__dlygate4sd3_1
Xhold358 picorv32_core.cpuregs\[20\]\[12\] VGND VGND VPWR VPWR net1467 sky130_fd_sc_hd__dlygate4sd3_1
Xhold369 picorv32_core.cpuregs\[25\]\[6\] VGND VGND VPWR VPWR net1478 sky130_fd_sc_hd__dlygate4sd3_1
Xfanout805 net806 VGND VGND VPWR VPWR net805 sky130_fd_sc_hd__buf_2
Xfanout816 net166 VGND VGND VPWR VPWR net816 sky130_fd_sc_hd__clkbuf_2
Xfanout838 _00007_ VGND VGND VPWR VPWR net838 sky130_fd_sc_hd__buf_4
Xfanout849 net850 VGND VGND VPWR VPWR net849 sky130_fd_sc_hd__buf_2
Xfanout827 _00009_ VGND VGND VPWR VPWR net827 sky130_fd_sc_hd__clkbuf_4
X_09862_ net1488 net502 net324 VGND VGND VPWR VPWR _01350_ sky130_fd_sc_hd__mux2_1
XFILLER_140_793 VPWR VGND VPWR VGND sky130_ef_sc_hd__decap_12
XFILLER_133_39 VPWR VGND VPWR VGND sky130_ef_sc_hd__decap_12
X_08813_ _02773_ net2202 net373 VGND VGND VPWR VPWR _00991_ sky130_fd_sc_hd__mux2_1
X_09793_ picorv32_core.reg_pc\[27\] net538 _04964_ net483 VGND VGND VPWR VPWR _04965_
+ sky130_fd_sc_hd__a211o_1
Xhold1014 picorv32_core.cpuregs\[22\]\[18\] VGND VGND VPWR VPWR net2123 sky130_fd_sc_hd__dlygate4sd3_1
XFILLER_100_613 VGND VGND VPWR VPWR sky130_fd_sc_hd__fill_1
XFILLER_85_313 VGND VGND VPWR VPWR sky130_fd_sc_hd__fill_2
XFILLER_58_538 VPWR VGND VPWR VGND sky130_ef_sc_hd__decap_12
XFILLER_58_527 VGND VGND VPWR VPWR sky130_fd_sc_hd__fill_1
XTAP_TAPCELL_ROW_51_1048 VGND VPWR sky130_fd_sc_hd__tapvpwrvgnd_1
Xhold1003 picorv32_core.cpuregs\[8\]\[5\] VGND VGND VPWR VPWR net2112 sky130_fd_sc_hd__dlygate4sd3_1
Xhold1047 picorv32_core.cpuregs\[2\]\[27\] VGND VGND VPWR VPWR net2156 sky130_fd_sc_hd__dlygate4sd3_1
Xhold1036 picorv32_core.cpuregs\[2\]\[28\] VGND VGND VPWR VPWR net2145 sky130_fd_sc_hd__dlygate4sd3_1
X_08744_ net1635 net236 net379 VGND VGND VPWR VPWR _00892_ sky130_fd_sc_hd__mux2_1
Xhold1025 picorv32_core.cpuregs\[25\]\[19\] VGND VGND VPWR VPWR net2134 sky130_fd_sc_hd__dlygate4sd3_1
Xhold1058 picorv32_core.cpuregs\[8\]\[17\] VGND VGND VPWR VPWR net2167 sky130_fd_sc_hd__dlygate4sd3_1
X_05956_ net791 _02414_ _02422_ _02423_ VGND VGND VPWR VPWR _02424_ sky130_fd_sc_hd__a211o_1
XFILLER_39_752 VGND VGND VPWR VPWR sky130_fd_sc_hd__fill_2
Xhold1069 picorv32_core.cpuregs\[8\]\[27\] VGND VGND VPWR VPWR net2178 sky130_fd_sc_hd__dlygate4sd3_1
XFILLER_73_519 VPWR VGND VPWR VGND sky130_ef_sc_hd__decap_12
XFILLER_26_15 VPWR VGND VPWR VGND sky130_ef_sc_hd__decap_12
XFILLER_38_262 VGND VGND VPWR VPWR sky130_fd_sc_hd__fill_1
XFILLER_39_785 VGND VGND VPWR VPWR sky130_fd_sc_hd__decap_6
XFILLER_39_796 VGND VGND VPWR VPWR sky130_fd_sc_hd__decap_4
XTAP_TAPCELL_ROW_107_1859 VGND VPWR sky130_fd_sc_hd__tapvpwrvgnd_1
X_08675_ net247 net1900 net388 VGND VGND VPWR VPWR _00825_ sky130_fd_sc_hd__mux2_1
X_05887_ net801 net958 net568 VGND VGND VPWR VPWR _02361_ sky130_fd_sc_hd__and3_1
XFILLER_26_37 VGND VGND VPWR VPWR sky130_fd_sc_hd__fill_1
X_07626_ _03719_ _03720_ net627 VGND VGND VPWR VPWR _03725_ sky130_fd_sc_hd__mux2_1
XFILLER_81_585 VGND VGND VPWR VPWR sky130_fd_sc_hd__decap_3
X_07557_ picorv32_core.cpuregs\[24\]\[0\] picorv32_core.cpuregs\[25\]\[0\] picorv32_core.cpuregs\[26\]\[0\]
+ picorv32_core.cpuregs\[27\]\[0\] net742 net709 VGND VGND VPWR VPWR _03662_ sky130_fd_sc_hd__mux4_1
Xclkbuf_leaf_33_clk clknet_4_5_0_clk VGND VGND VPWR VPWR clknet_leaf_33_clk sky130_fd_sc_hd__clkbuf_8
X_06508_ picorv32_core.count_instr\[14\] _02820_ picorv32_core.count_instr\[15\] VGND
+ VGND VPWR VPWR _02823_ sky130_fd_sc_hd__a21o_1
XTAP_TAPCELL_ROW_24_647 VGND VPWR sky130_fd_sc_hd__tapvpwrvgnd_1
XTAP_TAPCELL_ROW_24_658 VGND VPWR sky130_fd_sc_hd__tapvpwrvgnd_1
XFILLER_42_14 VGND VGND VPWR VPWR sky130_fd_sc_hd__decap_6
X_07488_ picorv32_core.reg_out\[16\] picorv32_core.reg_next_pc\[16\] net562 VGND VGND
+ VPWR VPWR _03613_ sky130_fd_sc_hd__mux2_1
XFILLER_10_825 VGND VGND VPWR VPWR sky130_fd_sc_hd__decap_8
XTAP_TAPCELL_ROW_62_1199 VGND VPWR sky130_fd_sc_hd__tapvpwrvgnd_1
X_06439_ net495 net1474 net418 VGND VGND VPWR VPWR _00105_ sky130_fd_sc_hd__mux2_1
X_09227_ _01689_ _04422_ _04423_ net469 VGND VGND VPWR VPWR _04424_ sky130_fd_sc_hd__o22a_1
X_09158_ net656 _04356_ VGND VGND VPWR VPWR _04357_ sky130_fd_sc_hd__or2_1
X_09089_ net493 net1556 net333 VGND VGND VPWR VPWR _01256_ sky130_fd_sc_hd__mux2_1
X_08109_ net467 net1984 net415 VGND VGND VPWR VPWR _00402_ sky130_fd_sc_hd__mux2_1
XFILLER_123_727 VGND VGND VPWR VPWR sky130_fd_sc_hd__fill_1
X_11120_ clknet_leaf_138_clk _00971_ VGND VGND VPWR VPWR picorv32_core.cpuregs\[8\]\[6\]
+ sky130_fd_sc_hd__dfxtp_1
Xhold881 picorv32_core.cpuregs\[13\]\[25\] VGND VGND VPWR VPWR net1990 sky130_fd_sc_hd__dlygate4sd3_1
Xhold870 picorv32_core.cpuregs\[24\]\[23\] VGND VGND VPWR VPWR net1979 sky130_fd_sc_hd__dlygate4sd3_1
XFILLER_122_215 VGND VGND VPWR VPWR sky130_fd_sc_hd__fill_1
Xhold892 picorv32_core.count_instr\[53\] VGND VGND VPWR VPWR net2001 sky130_fd_sc_hd__dlygate4sd3_1
X_11051_ clknet_leaf_114_clk _00902_ VGND VGND VPWR VPWR picorv32_core.cpuregs\[10\]\[1\]
+ sky130_fd_sc_hd__dfxtp_1
X_10002_ net1468 net214 net315 VGND VGND VPWR VPWR _01479_ sky130_fd_sc_hd__mux2_1
XFILLER_77_836 VGND VGND VPWR VPWR sky130_fd_sc_hd__fill_1
XFILLER_67_55 VGND VGND VPWR VPWR sky130_fd_sc_hd__fill_1
XFILLER_1_589 VPWR VGND VPWR VGND sky130_ef_sc_hd__decap_12
XFILLER_88_195 VGND VGND VPWR VPWR sky130_fd_sc_hd__fill_1
XTAP_TAPCELL_ROW_69_1309 VGND VPWR sky130_fd_sc_hd__tapvpwrvgnd_1
XTAP_TAPCELL_ROW_4_361 VGND VPWR sky130_fd_sc_hd__tapvpwrvgnd_1
X_10904_ clknet_leaf_83_clk _00755_ VGND VGND VPWR VPWR picorv32_core.mem_rdata_q\[14\]
+ sky130_fd_sc_hd__dfxtp_1
X_10835_ clknet_leaf_5_clk _00686_ VGND VGND VPWR VPWR picorv32_core.cpuregs\[17\]\[12\]
+ sky130_fd_sc_hd__dfxtp_1
XTAP_TAPCELL_ROW_43_923 VGND VPWR sky130_fd_sc_hd__tapvpwrvgnd_1
XTAP_TAPCELL_ROW_43_934 VGND VPWR sky130_fd_sc_hd__tapvpwrvgnd_1
Xclkbuf_leaf_24_clk clknet_4_4_0_clk VGND VGND VPWR VPWR clknet_leaf_24_clk sky130_fd_sc_hd__clkbuf_8
X_10766_ clknet_leaf_130_clk _00617_ VGND VGND VPWR VPWR picorv32_core.cpuregs\[14\]\[7\]
+ sky130_fd_sc_hd__dfxtp_1
XFILLER_8_133 VGND VGND VPWR VPWR sky130_fd_sc_hd__decap_6
X_10697_ clknet_leaf_137_clk _00548_ VGND VGND VPWR VPWR net133 sky130_fd_sc_hd__dfxtp_1
XFILLER_114_727 VPWR VGND VPWR VGND sky130_ef_sc_hd__decap_12
XFILLER_99_405 VGND VGND VPWR VPWR sky130_fd_sc_hd__fill_1
XTAP_TAPCELL_ROW_93_1649 VGND VPWR sky130_fd_sc_hd__tapvpwrvgnd_1
XFILLER_99_449 VGND VGND VPWR VPWR sky130_fd_sc_hd__decap_8
X_11318_ clknet_leaf_139_clk _01159_ VGND VGND VPWR VPWR picorv32_core.cpuregs\[29\]\[2\]
+ sky130_fd_sc_hd__dfxtp_1
XFILLER_79_151 VGND VGND VPWR VPWR sky130_fd_sc_hd__decap_4
X_11249_ clknet_leaf_110_clk _01097_ VGND VGND VPWR VPWR picorv32_core.cpuregs\[4\]\[4\]
+ sky130_fd_sc_hd__dfxtp_1
XFILLER_122_793 VPWR VGND VPWR VGND sky130_ef_sc_hd__decap_12
X_05810_ _02284_ _02289_ VGND VGND VPWR VPWR _02290_ sky130_fd_sc_hd__nand2_1
XTAP_TAPCELL_ROW_124_2104 VGND VPWR sky130_fd_sc_hd__tapvpwrvgnd_1
X_06790_ _02999_ _03005_ _03015_ _03017_ VGND VGND VPWR VPWR _03018_ sky130_fd_sc_hd__o211ai_1
XFILLER_63_530 VGND VGND VPWR VPWR sky130_fd_sc_hd__decap_8
X_05741_ _02199_ _02223_ net799 _01605_ VGND VGND VPWR VPWR _02225_ sky130_fd_sc_hd__o2bb2a_1
X_05672_ net773 net189 VGND VGND VPWR VPWR _02156_ sky130_fd_sc_hd__xnor2_1
X_08460_ net674 picorv32_core.decoded_imm_j\[7\] _04283_ picorv32_core.mem_rdata_q\[27\]
+ net524 VGND VGND VPWR VPWR _04311_ sky130_fd_sc_hd__a221o_1
X_07411_ picorv32_core.cpuregs\[4\]\[31\] picorv32_core.cpuregs\[5\]\[31\] net903
+ VGND VGND VPWR VPWR _03551_ sky130_fd_sc_hd__mux2_1
XFILLER_51_725 VGND VGND VPWR VPWR sky130_fd_sc_hd__decap_3
X_08391_ net982 _01627_ _01716_ _03582_ VGND VGND VPWR VPWR _04271_ sky130_fd_sc_hd__and4_1
XFILLER_36_799 VPWR VGND VPWR VGND sky130_ef_sc_hd__decap_12
Xclkbuf_leaf_15_clk clknet_4_3_0_clk VGND VGND VPWR VPWR clknet_leaf_15_clk sky130_fd_sc_hd__clkbuf_8
XFILLER_51_758 VGND VGND VPWR VPWR sky130_fd_sc_hd__fill_1
X_07342_ _03471_ _03473_ _03476_ _03478_ _03481_ VGND VGND VPWR VPWR _03482_ sky130_fd_sc_hd__o311ai_4
XTAP_TAPCELL_ROW_102_1789 VGND VPWR sky130_fd_sc_hd__tapvpwrvgnd_1
XTAP_TAPCELL_ROW_102_1778 VGND VPWR sky130_fd_sc_hd__tapvpwrvgnd_1
XTAP_TAPCELL_ROW_21_606 VGND VPWR sky130_fd_sc_hd__tapvpwrvgnd_1
X_07273_ net777 picorv32_core.decoded_imm\[22\] VGND VGND VPWR VPWR _03413_ sky130_fd_sc_hd__nand2_1
XFILLER_136_318 VGND VGND VPWR VPWR sky130_fd_sc_hd__decap_4
XFILLER_129_370 VGND VGND VPWR VPWR sky130_fd_sc_hd__decap_4
X_09012_ net230 net1953 net347 VGND VGND VPWR VPWR _01182_ sky130_fd_sc_hd__mux2_1
X_06224_ _02652_ _02653_ net632 VGND VGND VPWR VPWR _02654_ sky130_fd_sc_hd__mux2_1
XTAP_TAPCELL_ROW_135_2266 VGND VPWR sky130_fd_sc_hd__tapvpwrvgnd_1
X_06155_ net2303 net13 net520 VGND VGND VPWR VPWR _00759_ sky130_fd_sc_hd__mux2_1
Xhold100 net105 VGND VGND VPWR VPWR net1209 sky130_fd_sc_hd__dlygate4sd3_1
Xhold122 picorv32_core.cpuregs\[28\]\[25\] VGND VGND VPWR VPWR net1231 sky130_fd_sc_hd__dlygate4sd3_1
Xhold144 picorv32_core.cpuregs\[3\]\[22\] VGND VGND VPWR VPWR net1253 sky130_fd_sc_hd__dlygate4sd3_1
Xhold111 picorv32_core.cpuregs\[20\]\[16\] VGND VGND VPWR VPWR net1220 sky130_fd_sc_hd__dlygate4sd3_1
XFILLER_2_309 VGND VGND VPWR VPWR sky130_fd_sc_hd__fill_1
Xhold133 picorv32_core.cpuregs\[20\]\[6\] VGND VGND VPWR VPWR net1242 sky130_fd_sc_hd__dlygate4sd3_1
X_05106_ net908 picorv32_core.cpu_state\[5\] VGND VGND VPWR VPWR _01638_ sky130_fd_sc_hd__or2_1
X_06086_ net769 _02542_ VGND VGND VPWR VPWR _02544_ sky130_fd_sc_hd__or2_1
Xhold166 picorv32_core.cpuregs\[3\]\[3\] VGND VGND VPWR VPWR net1275 sky130_fd_sc_hd__dlygate4sd3_1
Xhold155 picorv32_core.cpuregs\[31\]\[4\] VGND VGND VPWR VPWR net1264 sky130_fd_sc_hd__dlygate4sd3_1
Xhold177 picorv32_core.cpuregs\[20\]\[7\] VGND VGND VPWR VPWR net1286 sky130_fd_sc_hd__dlygate4sd3_1
Xhold188 picorv32_core.cpuregs\[23\]\[22\] VGND VGND VPWR VPWR net1297 sky130_fd_sc_hd__dlygate4sd3_1
Xfanout602 net605 VGND VGND VPWR VPWR net602 sky130_fd_sc_hd__clkbuf_4
X_09914_ net272 net2217 net320 VGND VGND VPWR VPWR _01398_ sky130_fd_sc_hd__mux2_1
Xhold199 picorv32_core.cpuregs\[15\]\[6\] VGND VGND VPWR VPWR net1308 sky130_fd_sc_hd__dlygate4sd3_1
Xfanout624 _01620_ VGND VGND VPWR VPWR net624 sky130_fd_sc_hd__buf_4
Xfanout613 _01638_ VGND VGND VPWR VPWR net613 sky130_fd_sc_hd__clkbuf_4
X_09845_ picorv32_core.cpuregs\[16\]\[30\] picorv32_core.cpuregs\[17\]\[30\] picorv32_core.cpuregs\[18\]\[30\]
+ picorv32_core.cpuregs\[19\]\[30\] net904 net869 VGND VGND VPWR VPWR _05014_ sky130_fd_sc_hd__mux4_1
Xfanout657 net659 VGND VGND VPWR VPWR net657 sky130_fd_sc_hd__buf_4
Xfanout646 net647 VGND VGND VPWR VPWR net646 sky130_fd_sc_hd__buf_4
Xfanout635 net638 VGND VGND VPWR VPWR net635 sky130_fd_sc_hd__buf_4
XFILLER_100_421 VPWR VGND VPWR VGND sky130_ef_sc_hd__decap_12
Xfanout679 net680 VGND VGND VPWR VPWR net679 sky130_fd_sc_hd__clkbuf_2
XFILLER_58_357 VGND VGND VPWR VPWR sky130_fd_sc_hd__fill_1
Xfanout668 _01583_ VGND VGND VPWR VPWR net668 sky130_fd_sc_hd__buf_2
X_09776_ net776 net545 _04947_ net473 VGND VGND VPWR VPWR _04948_ sky130_fd_sc_hd__o211a_1
X_06988_ _03191_ _03193_ _03199_ VGND VGND VPWR VPWR _03200_ sky130_fd_sc_hd__a21oi_1
XTAP_TAPCELL_ROW_29_728 VGND VPWR sky130_fd_sc_hd__tapvpwrvgnd_1
X_05939_ _02185_ _02407_ _02408_ VGND VGND VPWR VPWR _02409_ sky130_fd_sc_hd__a21o_1
XTAP_TAPCELL_ROW_1_320 VGND VPWR sky130_fd_sc_hd__tapvpwrvgnd_1
X_08727_ net1346 net445 net378 VGND VGND VPWR VPWR _00875_ sky130_fd_sc_hd__mux2_1
X_08658_ net492 net1466 net387 VGND VGND VPWR VPWR _00808_ sky130_fd_sc_hd__mux2_1
XFILLER_27_766 VPWR VGND VPWR VGND sky130_ef_sc_hd__decap_12
XTAP_TAPCELL_ROW_64_1239 VGND VPWR sky130_fd_sc_hd__tapvpwrvgnd_1
XTAP_TAPCELL_ROW_64_1228 VGND VPWR sky130_fd_sc_hd__tapvpwrvgnd_1
XFILLER_54_596 VGND VGND VPWR VPWR sky130_fd_sc_hd__decap_3
X_07609_ net693 _03705_ net623 VGND VGND VPWR VPWR _03709_ sky130_fd_sc_hd__o21a_1
XFILLER_42_736 VGND VGND VPWR VPWR sky130_fd_sc_hd__decap_4
XFILLER_53_57 VGND VGND VPWR VPWR sky130_fd_sc_hd__fill_2
X_08589_ net447 net2211 net394 VGND VGND VPWR VPWR _00712_ sky130_fd_sc_hd__mux2_1
XFILLER_41_257 VGND VGND VPWR VPWR sky130_fd_sc_hd__fill_1
XFILLER_22_471 VGND VGND VPWR VPWR sky130_fd_sc_hd__decap_4
X_10620_ clknet_leaf_94_clk _00474_ VGND VGND VPWR VPWR picorv32_core.decoded_imm_j\[4\]
+ sky130_fd_sc_hd__dfxtp_2
X_10551_ clknet_leaf_131_clk _00405_ VGND VGND VPWR VPWR picorv32_core.cpuregs\[25\]\[7\]
+ sky130_fd_sc_hd__dfxtp_1
X_10482_ clknet_leaf_129_clk _00368_ VGND VGND VPWR VPWR net203 sky130_fd_sc_hd__dfxtp_1
XFILLER_6_615 VGND VGND VPWR VPWR sky130_fd_sc_hd__fill_1
XFILLER_10_699 VGND VGND VPWR VPWR sky130_fd_sc_hd__fill_1
XFILLER_10_688 VGND VGND VPWR VPWR sky130_fd_sc_hd__fill_2
XFILLER_5_125 VPWR VGND VPWR VGND sky130_ef_sc_hd__decap_12
XFILLER_108_587 VGND VGND VPWR VPWR sky130_fd_sc_hd__fill_1
XFILLER_5_169 VPWR VGND VPWR VGND sky130_ef_sc_hd__decap_12
XTAP_TAPCELL_ROW_9_442 VGND VPWR sky130_fd_sc_hd__tapvpwrvgnd_1
XTAP_TAPCELL_ROW_9_431 VGND VPWR sky130_fd_sc_hd__tapvpwrvgnd_1
XFILLER_123_557 VGND VGND VPWR VPWR sky130_fd_sc_hd__decap_3
X_11103_ clknet_leaf_49_clk _00954_ VGND VGND VPWR VPWR picorv32_core.cpuregs\[0\]\[21\]
+ sky130_fd_sc_hd__dfxtp_1
XFILLER_111_708 VGND VGND VPWR VPWR sky130_fd_sc_hd__decap_3
XFILLER_96_419 VGND VGND VPWR VPWR sky130_fd_sc_hd__fill_1
X_11034_ clknet_leaf_23_clk _00885_ VGND VGND VPWR VPWR picorv32_core.cpuregs\[11\]\[16\]
+ sky130_fd_sc_hd__dfxtp_1
XFILLER_131_590 VGND VGND VPWR VPWR sky130_fd_sc_hd__fill_2
XFILLER_76_110 VGND VGND VPWR VPWR sky130_fd_sc_hd__fill_2
XFILLER_49_335 VGND VGND VPWR VPWR sky130_fd_sc_hd__fill_1
XFILLER_92_625 VGND VGND VPWR VPWR sky130_fd_sc_hd__decap_3
XFILLER_64_349 VGND VGND VPWR VPWR sky130_fd_sc_hd__fill_1
XFILLER_72_393 VGND VGND VPWR VPWR sky130_fd_sc_hd__decap_3
X_10818_ clknet_leaf_42_clk _00669_ VGND VGND VPWR VPWR picorv32_core.cpuregs\[15\]\[27\]
+ sky130_fd_sc_hd__dfxtp_1
XFILLER_13_460 VGND VGND VPWR VPWR sky130_fd_sc_hd__decap_6
X_10749_ clknet_leaf_93_clk _00600_ VGND VGND VPWR VPWR picorv32_core.decoded_imm\[10\]
+ sky130_fd_sc_hd__dfxtp_1
XFILLER_40_290 VGND VGND VPWR VPWR sky130_fd_sc_hd__fill_2
Xoutput205 net205 VGND VGND VPWR VPWR trap sky130_fd_sc_hd__buf_2
XFILLER_141_365 VGND VGND VPWR VPWR sky130_fd_sc_hd__fill_1
XTAP_TAPCELL_ROW_130_2185 VGND VPWR sky130_fd_sc_hd__tapvpwrvgnd_1
X_07960_ net684 _04039_ net625 VGND VGND VPWR VPWR _04041_ sky130_fd_sc_hd__a21o_1
XTAP_TAPCELL_ROW_130_2196 VGND VPWR sky130_fd_sc_hd__tapvpwrvgnd_1
XFILLER_99_279 VGND VGND VPWR VPWR sky130_fd_sc_hd__fill_1
X_06911_ net989 _03129_ VGND VGND VPWR VPWR _00246_ sky130_fd_sc_hd__and2_1
Xclkbuf_leaf_4_clk clknet_4_1_0_clk VGND VGND VPWR VPWR clknet_leaf_4_clk sky130_fd_sc_hd__clkbuf_8
XFILLER_114_19 VGND VGND VPWR VPWR sky130_fd_sc_hd__fill_1
X_07891_ net1193 net511 _03974_ _03975_ VGND VGND VPWR VPWR _00380_ sky130_fd_sc_hd__o22a_1
X_09630_ net658 _04808_ VGND VGND VPWR VPWR _04809_ sky130_fd_sc_hd__or2_1
XFILLER_68_699 VGND VGND VPWR VPWR sky130_fd_sc_hd__fill_1
X_06842_ net588 _03064_ _03065_ VGND VGND VPWR VPWR _03066_ sky130_fd_sc_hd__a21oi_1
XFILLER_56_817 VGND VGND VPWR VPWR sky130_fd_sc_hd__fill_1
X_09561_ picorv32_core.cpuregs\[28\]\[17\] picorv32_core.cpuregs\[29\]\[17\] picorv32_core.cpuregs\[30\]\[17\]
+ picorv32_core.cpuregs\[31\]\[17\] net889 net855 VGND VGND VPWR VPWR _04743_ sky130_fd_sc_hd__mux4_1
XFILLER_36_530 VGND VGND VPWR VPWR sky130_fd_sc_hd__fill_2
X_06773_ _02964_ _02977_ _02978_ _02989_ _02976_ VGND VGND VPWR VPWR _03002_ sky130_fd_sc_hd__a311o_1
XTAP_TAPCELL_ROW_104_1807 VGND VPWR sky130_fd_sc_hd__tapvpwrvgnd_1
X_05724_ _02155_ _02207_ _01601_ net954 VGND VGND VPWR VPWR _02208_ sky130_fd_sc_hd__a2bb2o_1
X_08512_ picorv32_core.latched_rd\[0\] picorv32_core.latched_rd\[1\] VGND VGND VPWR
+ VPWR _04324_ sky130_fd_sc_hd__nand2_1
XFILLER_130_29 VPWR VGND VPWR VGND sky130_ef_sc_hd__decap_12
XTAP_TAPCELL_ROW_104_1818 VGND VPWR sky130_fd_sc_hd__tapvpwrvgnd_1
X_09492_ net473 _04613_ _04675_ _04676_ net488 VGND VGND VPWR VPWR _04677_ sky130_fd_sc_hd__a311o_1
XFILLER_63_371 VGND VGND VPWR VPWR sky130_fd_sc_hd__fill_1
XFILLER_23_202 VGND VGND VPWR VPWR sky130_fd_sc_hd__decap_3
X_08443_ net679 picorv32_core.decoded_imm_j\[15\] net616 picorv32_core.mem_rdata_q\[15\]
+ VGND VGND VPWR VPWR _04302_ sky130_fd_sc_hd__a22o_1
XFILLER_24_769 VPWR VGND VPWR VGND sky130_ef_sc_hd__decap_12
X_05655_ net817 net967 VGND VGND VPWR VPWR _02139_ sky130_fd_sc_hd__nand2_1
X_05586_ net912 net302 _02069_ _02074_ VGND VGND VPWR VPWR _01566_ sky130_fd_sc_hd__a31o_1
X_08374_ net190 net581 net452 _04239_ VGND VGND VPWR VPWR _04262_ sky130_fd_sc_hd__a211o_2
XFILLER_23_27 VPWR VGND VPWR VGND sky130_ef_sc_hd__decap_12
XFILLER_139_27 VPWR VGND VPWR VGND sky130_ef_sc_hd__decap_12
X_07325_ net815 picorv32_core.decoded_imm\[3\] VGND VGND VPWR VPWR _03465_ sky130_fd_sc_hd__or2_1
XTAP_TAPCELL_ROW_34_797 VGND VPWR sky130_fd_sc_hd__tapvpwrvgnd_1
X_07256_ _01653_ _01693_ net283 VGND VGND VPWR VPWR _03396_ sky130_fd_sc_hd__o21ai_2
X_06207_ _02636_ _02637_ net632 VGND VGND VPWR VPWR _02638_ sky130_fd_sc_hd__mux2_1
X_07187_ picorv32_core.count_cycle\[40\] picorv32_core.count_cycle\[41\] picorv32_core.count_cycle\[42\]
+ _03344_ VGND VGND VPWR VPWR _03349_ sky130_fd_sc_hd__and4_1
XFILLER_133_833 VGND VGND VPWR VPWR sky130_fd_sc_hd__decap_4
XTAP_TAPCELL_ROW_115_1969 VGND VPWR sky130_fd_sc_hd__tapvpwrvgnd_1
X_06138_ _02166_ _02590_ _02591_ VGND VGND VPWR VPWR _02592_ sky130_fd_sc_hd__a21o_1
X_06069_ net190 _02527_ VGND VGND VPWR VPWR _02528_ sky130_fd_sc_hd__xnor2_1
XFILLER_2_139 VGND VGND VPWR VPWR sky130_fd_sc_hd__fill_1
XFILLER_132_365 VGND VGND VPWR VPWR sky130_fd_sc_hd__decap_6
Xfanout421 _02798_ VGND VGND VPWR VPWR net421 sky130_fd_sc_hd__buf_4
Xfanout410 net411 VGND VGND VPWR VPWR net410 sky130_fd_sc_hd__buf_4
Xfanout432 _02695_ VGND VGND VPWR VPWR net432 sky130_fd_sc_hd__buf_1
XFILLER_101_752 VGND VGND VPWR VPWR sky130_fd_sc_hd__decap_6
XFILLER_98_290 VGND VGND VPWR VPWR sky130_fd_sc_hd__decap_4
Xfanout454 net455 VGND VGND VPWR VPWR net454 sky130_fd_sc_hd__buf_2
Xfanout443 net444 VGND VGND VPWR VPWR net443 sky130_fd_sc_hd__clkbuf_2
Xfanout465 net468 VGND VGND VPWR VPWR net465 sky130_fd_sc_hd__clkbuf_2
X_09828_ picorv32_core.cpuregs\[4\]\[29\] picorv32_core.cpuregs\[5\]\[29\] picorv32_core.cpuregs\[6\]\[29\]
+ picorv32_core.cpuregs\[7\]\[29\] net905 net869 VGND VGND VPWR VPWR _04998_ sky130_fd_sc_hd__mux4_1
XPHY_EDGE_ROW_122_Right_122 VGND VGND VPWR VPWR sky130_fd_sc_hd__decap_3
XFILLER_101_763 VGND VGND VPWR VPWR sky130_fd_sc_hd__fill_1
Xfanout487 net488 VGND VGND VPWR VPWR net487 sky130_fd_sc_hd__buf_2
XFILLER_86_474 VGND VGND VPWR VPWR sky130_fd_sc_hd__fill_2
Xfanout476 net477 VGND VGND VPWR VPWR net476 sky130_fd_sc_hd__buf_2
Xfanout498 _02672_ VGND VGND VPWR VPWR net498 sky130_fd_sc_hd__clkbuf_2
X_09759_ picorv32_core.cpuregs\[12\]\[26\] picorv32_core.cpuregs\[13\]\[26\] picorv32_core.cpuregs\[14\]\[26\]
+ picorv32_core.cpuregs\[15\]\[26\] net901 net867 VGND VGND VPWR VPWR _04932_ sky130_fd_sc_hd__mux4_1
XFILLER_73_113 VGND VGND VPWR VPWR sky130_fd_sc_hd__fill_2
XFILLER_70_820 VGND VGND VPWR VPWR sky130_fd_sc_hd__fill_1
XFILLER_42_511 VGND VGND VPWR VPWR sky130_fd_sc_hd__fill_1
XFILLER_9_18 VPWR VGND VPWR VGND sky130_ef_sc_hd__decap_12
XFILLER_42_533 VGND VGND VPWR VPWR sky130_fd_sc_hd__fill_1
X_11652_ clknet_leaf_111_clk _01483_ VGND VGND VPWR VPWR picorv32_core.cpuregs\[26\]\[1\]
+ sky130_fd_sc_hd__dfxtp_1
XFILLER_128_605 VGND VGND VPWR VPWR sky130_fd_sc_hd__decap_6
X_10603_ clknet_leaf_93_clk _00457_ VGND VGND VPWR VPWR picorv32_core.instr_srli sky130_fd_sc_hd__dfxtp_1
X_11583_ clknet_leaf_64_clk _01414_ VGND VGND VPWR VPWR picorv32_core.cpuregs\[2\]\[30\]
+ sky130_fd_sc_hd__dfxtp_1
X_10534_ clknet_leaf_53_clk picorv32_core.alu_out\[22\] VGND VGND VPWR VPWR picorv32_core.alu_out_q\[22\]
+ sky130_fd_sc_hd__dfxtp_1
XTAP_TAPCELL_ROW_77_1419 VGND VPWR sky130_fd_sc_hd__tapvpwrvgnd_1
XFILLER_13_93 VGND VGND VPWR VPWR sky130_fd_sc_hd__decap_3
XFILLER_129_93 VGND VGND VPWR VPWR sky130_fd_sc_hd__decap_6
XFILLER_124_811 VGND VGND VPWR VPWR sky130_fd_sc_hd__fill_1
X_10465_ clknet_leaf_73_clk _00352_ VGND VGND VPWR VPWR net57 sky130_fd_sc_hd__dfxtp_1
XFILLER_108_340 VGND VGND VPWR VPWR sky130_fd_sc_hd__fill_1
X_10396_ clknet_leaf_77_clk _00315_ VGND VGND VPWR VPWR picorv32_core.count_cycle\[54\]
+ sky130_fd_sc_hd__dfxtp_1
XTAP_TAPCELL_ROW_90_1608 VGND VPWR sky130_fd_sc_hd__tapvpwrvgnd_1
XFILLER_2_651 VGND VGND VPWR VPWR sky130_fd_sc_hd__fill_2
XFILLER_2_673 VPWR VGND VPWR VGND sky130_ef_sc_hd__decap_12
XFILLER_1_161 VGND VGND VPWR VPWR sky130_fd_sc_hd__decap_6
XFILLER_89_290 VGND VGND VPWR VPWR sky130_fd_sc_hd__fill_1
XPHY_EDGE_ROW_8_Left_150 VGND VGND VPWR VPWR sky130_fd_sc_hd__decap_3
X_11017_ clknet_leaf_62_clk _00868_ VGND VGND VPWR VPWR picorv32_core.cpuregs\[12\]\[31\]
+ sky130_fd_sc_hd__dfxtp_1
XFILLER_53_809 VGND VGND VPWR VPWR sky130_fd_sc_hd__fill_1
XFILLER_45_393 VGND VGND VPWR VPWR sky130_fd_sc_hd__decap_6
X_05440_ picorv32_core.count_cycle\[16\] net601 net578 _01939_ VGND VGND VPWR VPWR
+ _01940_ sky130_fd_sc_hd__o211a_1
XFILLER_60_363 VGND VGND VPWR VPWR sky130_fd_sc_hd__fill_1
XFILLER_33_577 VGND VGND VPWR VPWR sky130_fd_sc_hd__decap_4
XTAP_TAPCELL_ROW_119_2025 VGND VPWR sky130_fd_sc_hd__tapvpwrvgnd_1
X_05371_ net918 net798 _01874_ net909 net577 VGND VGND VPWR VPWR _01875_ sky130_fd_sc_hd__a221o_1
XTAP_TAPCELL_ROW_119_2036 VGND VPWR sky130_fd_sc_hd__tapvpwrvgnd_1
X_07110_ picorv32_core.count_cycle\[13\] _03299_ net974 VGND VGND VPWR VPWR _03301_
+ sky130_fd_sc_hd__a21oi_1
XTAP_TAPCELL_ROW_31_756 VGND VPWR sky130_fd_sc_hd__tapvpwrvgnd_1
X_08090_ net920 _02247_ _01708_ VGND VGND VPWR VPWR _04163_ sky130_fd_sc_hd__a21o_1
Xclkload20 clknet_leaf_2_clk VGND VGND VPWR VPWR clkload20/X sky130_fd_sc_hd__clkbuf_4
XTAP_TAPCELL_ROW_132_2225 VGND VPWR sky130_fd_sc_hd__tapvpwrvgnd_1
XTAP_TAPCELL_ROW_132_2214 VGND VPWR sky130_fd_sc_hd__tapvpwrvgnd_1
X_07041_ _02940_ _03238_ VGND VGND VPWR VPWR _03249_ sky130_fd_sc_hd__nor2_1
Xclkload53 clknet_leaf_30_clk VGND VGND VPWR VPWR clkload53/Y sky130_fd_sc_hd__inv_6
Xclkload42 clknet_leaf_127_clk VGND VGND VPWR VPWR clkload42/Y sky130_fd_sc_hd__clkinv_8
Xclkload31 clknet_leaf_133_clk VGND VGND VPWR VPWR clkload31/Y sky130_fd_sc_hd__inv_8
XFILLER_127_682 VGND VGND VPWR VPWR sky130_fd_sc_hd__fill_1
Xclkload75 clknet_leaf_46_clk VGND VGND VPWR VPWR clkload75/Y sky130_fd_sc_hd__inv_6
Xclkload64 clknet_leaf_18_clk VGND VGND VPWR VPWR clkload64/Y sky130_fd_sc_hd__clkinv_2
Xclkload86 clknet_leaf_119_clk VGND VGND VPWR VPWR clkload86/Y sky130_fd_sc_hd__inv_6
Xclkload97 clknet_leaf_126_clk VGND VGND VPWR VPWR clkload97/Y sky130_fd_sc_hd__inv_8
XFILLER_130_825 VGND VGND VPWR VPWR sky130_fd_sc_hd__decap_8
XFILLER_114_365 VGND VGND VPWR VPWR sky130_fd_sc_hd__fill_1
X_08992_ net450 net2052 net344 VGND VGND VPWR VPWR _01162_ sky130_fd_sc_hd__mux2_1
X_07943_ picorv32_core.decoded_imm\[23\] net591 net458 _04024_ net596 VGND VGND VPWR
+ VPWR _04025_ sky130_fd_sc_hd__a221o_1
XTAP_TAPCELL_ROW_110_1899 VGND VPWR sky130_fd_sc_hd__tapvpwrvgnd_1
X_07874_ picorv32_core.cpuregs\[28\]\[20\] picorv32_core.cpuregs\[29\]\[20\] picorv32_core.cpuregs\[30\]\[20\]
+ picorv32_core.cpuregs\[31\]\[20\] net750 net717 VGND VGND VPWR VPWR _03959_ sky130_fd_sc_hd__mux4_1
X_09613_ picorv32_core.cpuregs\[0\]\[19\] picorv32_core.cpuregs\[1\]\[19\] picorv32_core.cpuregs\[2\]\[19\]
+ picorv32_core.cpuregs\[3\]\[19\] net890 net856 VGND VGND VPWR VPWR _04793_ sky130_fd_sc_hd__mux4_1
X_06825_ _03028_ _03049_ _03035_ VGND VGND VPWR VPWR _03050_ sky130_fd_sc_hd__o21ai_1
XFILLER_56_625 VGND VGND VPWR VPWR sky130_fd_sc_hd__decap_3
XFILLER_55_113 VGND VGND VPWR VPWR sky130_fd_sc_hd__decap_4
XFILLER_18_27 VGND VGND VPWR VPWR sky130_fd_sc_hd__fill_1
XTAP_TAPCELL_ROW_39_867 VGND VPWR sky130_fd_sc_hd__tapvpwrvgnd_1
XFILLER_44_809 VGND VGND VPWR VPWR sky130_fd_sc_hd__decap_3
X_09544_ picorv32_core.cpuregs\[12\]\[16\] picorv32_core.cpuregs\[13\]\[16\] picorv32_core.cpuregs\[14\]\[16\]
+ picorv32_core.cpuregs\[15\]\[16\] net891 net855 VGND VGND VPWR VPWR _04727_ sky130_fd_sc_hd__mux4_1
XFILLER_24_511 VGND VGND VPWR VPWR sky130_fd_sc_hd__fill_1
XFILLER_36_360 VGND VGND VPWR VPWR sky130_fd_sc_hd__fill_1
X_06756_ net588 _02985_ _02986_ VGND VGND VPWR VPWR _02987_ sky130_fd_sc_hd__a21oi_1
X_06687_ _02748_ picorv32_core.reg_next_pc\[21\] net558 VGND VGND VPWR VPWR _02933_
+ sky130_fd_sc_hd__mux2_2
XFILLER_70_138 VGND VGND VPWR VPWR sky130_fd_sc_hd__fill_2
X_05707_ net797 net957 VGND VGND VPWR VPWR _02191_ sky130_fd_sc_hd__or2_1
X_09475_ picorv32_core.cpuregs\[4\]\[13\] picorv32_core.cpuregs\[5\]\[13\] picorv32_core.cpuregs\[6\]\[13\]
+ picorv32_core.cpuregs\[7\]\[13\] net882 net849 VGND VGND VPWR VPWR _04661_ sky130_fd_sc_hd__mux4_1
XTAP_TAPCELL_ROW_19_580 VGND VPWR sky130_fd_sc_hd__tapvpwrvgnd_1
XFILLER_24_533 VGND VGND VPWR VPWR sky130_fd_sc_hd__decap_3
XFILLER_34_15 VGND VGND VPWR VPWR sky130_fd_sc_hd__decap_4
X_08426_ picorv32_core.decoded_imm\[24\] net528 net442 _04293_ VGND VGND VPWR VPWR
+ _00586_ sky130_fd_sc_hd__o22a_1
XFILLER_12_717 VPWR VGND VPWR VGND sky130_ef_sc_hd__decap_12
X_05638_ net807 net962 VGND VGND VPWR VPWR _02122_ sky130_fd_sc_hd__xor2_1
X_05569_ picorv32_core.count_instr\[58\] net937 net941 picorv32_core.count_instr\[26\]
+ VGND VGND VPWR VPWR _02059_ sky130_fd_sc_hd__a22o_1
X_08357_ net1155 _04253_ net455 VGND VGND VPWR VPWR _00557_ sky130_fd_sc_hd__mux2_1
XFILLER_11_249 VGND VGND VPWR VPWR sky130_fd_sc_hd__fill_1
XFILLER_20_750 VGND VGND VPWR VPWR sky130_fd_sc_hd__decap_6
Xclkload3 clknet_4_3_0_clk VGND VGND VPWR VPWR clkload3/Y sky130_fd_sc_hd__inv_6
X_08288_ net1599 net227 net413 VGND VGND VPWR VPWR _00512_ sky130_fd_sc_hd__mux2_1
X_07308_ net807 picorv32_core.decoded_imm\[7\] VGND VGND VPWR VPWR _03448_ sky130_fd_sc_hd__nand2_1
X_07239_ picorv32_core.count_cycle\[61\] _03380_ net977 VGND VGND VPWR VPWR _03382_
+ sky130_fd_sc_hd__a21oi_1
X_10250_ clknet_leaf_103_clk _00169_ VGND VGND VPWR VPWR picorv32_core.count_instr\[34\]
+ sky130_fd_sc_hd__dfxtp_1
X_10181_ clknet_leaf_71_clk _00100_ VGND VGND VPWR VPWR picorv32_core.cpuregs\[21\]\[29\]
+ sky130_fd_sc_hd__dfxtp_1
XFILLER_79_739 VGND VGND VPWR VPWR sky130_fd_sc_hd__fill_2
XTAP_TAPCELL_ROW_72_1349 VGND VPWR sky130_fd_sc_hd__tapvpwrvgnd_1
Xfanout240 net243 VGND VGND VPWR VPWR net240 sky130_fd_sc_hd__clkbuf_2
XFILLER_59_430 VPWR VGND VPWR VGND sky130_ef_sc_hd__decap_12
Xfanout251 net254 VGND VGND VPWR VPWR net251 sky130_fd_sc_hd__clkbuf_2
Xfanout262 _02736_ VGND VGND VPWR VPWR net262 sky130_fd_sc_hd__buf_1
Xfanout273 _02723_ VGND VGND VPWR VPWR net273 sky130_fd_sc_hd__buf_1
XFILLER_47_614 VGND VGND VPWR VPWR sky130_fd_sc_hd__fill_2
XFILLER_101_571 VGND VGND VPWR VPWR sky130_fd_sc_hd__decap_3
Xfanout284 net285 VGND VGND VPWR VPWR net284 sky130_fd_sc_hd__clkbuf_4
Xfanout295 _02706_ VGND VGND VPWR VPWR net295 sky130_fd_sc_hd__buf_1
XFILLER_35_809 VPWR VGND VPWR VGND sky130_ef_sc_hd__decap_12
XTAP_TAPCELL_ROW_87_1570 VGND VPWR sky130_fd_sc_hd__tapvpwrvgnd_1
XFILLER_74_499 VGND VGND VPWR VPWR sky130_fd_sc_hd__decap_8
XFILLER_74_477 VGND VGND VPWR VPWR sky130_fd_sc_hd__fill_1
XFILLER_27_393 VGND VGND VPWR VPWR sky130_fd_sc_hd__fill_2
X_11704_ clknet_leaf_48_clk _01535_ VGND VGND VPWR VPWR picorv32_core.cpuregs\[27\]\[21\]
+ sky130_fd_sc_hd__dfxtp_1
XFILLER_30_503 VGND VGND VPWR VPWR sky130_fd_sc_hd__decap_8
XFILLER_91_87 VGND VGND VPWR VPWR sky130_fd_sc_hd__fill_1
XFILLER_70_694 VGND VGND VPWR VPWR sky130_fd_sc_hd__fill_2
X_11635_ clknet_leaf_18_clk _01466_ VGND VGND VPWR VPWR picorv32_core.cpuregs\[28\]\[16\]
+ sky130_fd_sc_hd__dfxtp_1
X_11566_ clknet_leaf_14_clk _01397_ VGND VGND VPWR VPWR picorv32_core.cpuregs\[2\]\[13\]
+ sky130_fd_sc_hd__dfxtp_1
XFILLER_11_783 VGND VGND VPWR VPWR sky130_fd_sc_hd__fill_1
XFILLER_7_765 VPWR VGND VPWR VGND sky130_ef_sc_hd__decap_12
XFILLER_6_253 VGND VGND VPWR VPWR sky130_fd_sc_hd__fill_2
XFILLER_6_231 VGND VGND VPWR VPWR sky130_fd_sc_hd__decap_4
X_10517_ clknet_leaf_132_clk picorv32_core.alu_out\[5\] VGND VGND VPWR VPWR picorv32_core.alu_out_q\[5\]
+ sky130_fd_sc_hd__dfxtp_1
X_11497_ clknet_leaf_90_clk _01333_ VGND VGND VPWR VPWR net146 sky130_fd_sc_hd__dfxtp_1
X_10448_ clknet_leaf_101_clk _00335_ VGND VGND VPWR VPWR net40 sky130_fd_sc_hd__dfxtp_1
XFILLER_111_302 VGND VGND VPWR VPWR sky130_fd_sc_hd__fill_2
X_10379_ clknet_leaf_102_clk _00298_ VGND VGND VPWR VPWR picorv32_core.count_cycle\[37\]
+ sky130_fd_sc_hd__dfxtp_1
XFILLER_123_173 VGND VGND VPWR VPWR sky130_fd_sc_hd__fill_1
XFILLER_97_558 VGND VGND VPWR VPWR sky130_fd_sc_hd__fill_2
XFILLER_97_536 VPWR VGND VPWR VGND sky130_ef_sc_hd__decap_12
XFILLER_65_433 VGND VGND VPWR VPWR sky130_fd_sc_hd__fill_1
XFILLER_37_113 VGND VGND VPWR VPWR sky130_fd_sc_hd__decap_4
X_06610_ picorv32_core.count_instr\[52\] _02887_ VGND VGND VPWR VPWR _02888_ sky130_fd_sc_hd__or2_1
XFILLER_65_499 VGND VGND VPWR VPWR sky130_fd_sc_hd__decap_4
X_07590_ net967 _03692_ net510 VGND VGND VPWR VPWR _00362_ sky130_fd_sc_hd__mux2_1
XTAP_TAPCELL_ROW_36_826 VGND VPWR sky130_fd_sc_hd__tapvpwrvgnd_1
X_06541_ net2258 _02843_ net997 VGND VGND VPWR VPWR _02845_ sky130_fd_sc_hd__o21ai_1
X_09260_ net815 net812 net540 VGND VGND VPWR VPWR _04455_ sky130_fd_sc_hd__mux2_1
X_06472_ picorv32_core.cpu_state\[1\] picorv32_core.count_instr\[1\] picorv32_core.count_instr\[0\]
+ picorv32_core.decoder_trigger VGND VGND VPWR VPWR _02801_ sky130_fd_sc_hd__and4_1
X_05423_ net946 picorv32_core.count_cycle\[47\] net604 _01923_ VGND VGND VPWR VPWR
+ _01924_ sky130_fd_sc_hd__a211o_1
X_08211_ net1174 net475 _04180_ _04208_ VGND VGND VPWR VPWR _00458_ sky130_fd_sc_hd__a22o_1
X_09191_ picorv32_core.cpuregs\[2\]\[1\] picorv32_core.cpuregs\[3\]\[1\] net887 VGND
+ VGND VPWR VPWR _04389_ sky130_fd_sc_hd__mux2_1
Xpicorv32_axi_1109 VGND VGND VPWR VPWR picorv32_axi_1109/HI trace_valid sky130_fd_sc_hd__conb_1
XFILLER_119_446 VGND VGND VPWR VPWR sky130_fd_sc_hd__fill_2
X_05354_ picorv32_core.reg_pc\[11\] picorv32_core.decoded_imm\[11\] VGND VGND VPWR
+ VPWR _01859_ sky130_fd_sc_hd__nor2_1
X_08142_ net2310 net32 net521 VGND VGND VPWR VPWR _00747_ sky130_fd_sc_hd__mux2_1
X_08073_ picorv32_core.cpuregs\[28\]\[31\] picorv32_core.cpuregs\[29\]\[31\] picorv32_core.cpuregs\[30\]\[31\]
+ picorv32_core.cpuregs\[31\]\[31\] net760 net727 VGND VGND VPWR VPWR _04147_ sky130_fd_sc_hd__mux4_1
Xclkload120 clknet_leaf_61_clk VGND VGND VPWR VPWR clkload120/Y sky130_fd_sc_hd__inv_8
Xclkload131 clknet_leaf_82_clk VGND VGND VPWR VPWR clkload131/X sky130_fd_sc_hd__clkbuf_8
X_05285_ _01778_ _01794_ VGND VGND VPWR VPWR _01795_ sky130_fd_sc_hd__nor2_1
X_07024_ _02937_ _02938_ net932 VGND VGND VPWR VPWR _03233_ sky130_fd_sc_hd__o21a_1
Xclkload142 clknet_leaf_78_clk VGND VGND VPWR VPWR clkload142/Y sky130_fd_sc_hd__clkinvlp_4
XTAP_TAPCELL_ROW_112_1928 VGND VPWR sky130_fd_sc_hd__tapvpwrvgnd_1
X_08975_ net1253 net240 net350 VGND VGND VPWR VPWR _01147_ sky130_fd_sc_hd__mux2_1
XFILLER_0_429 VGND VGND VPWR VPWR sky130_fd_sc_hd__fill_1
XFILLER_29_15 VPWR VGND VPWR VGND sky130_ef_sc_hd__decap_12
Xhold26 picorv32_core.cpuregs\[0\]\[21\] VGND VGND VPWR VPWR net1135 sky130_fd_sc_hd__dlygate4sd3_1
Xhold15 picorv32_core.cpuregs\[0\]\[22\] VGND VGND VPWR VPWR net1124 sky130_fd_sc_hd__dlygate4sd3_1
X_07926_ net684 _04007_ net625 VGND VGND VPWR VPWR _04009_ sky130_fd_sc_hd__a21o_1
Xhold37 picorv32_core.cpuregs\[0\]\[0\] VGND VGND VPWR VPWR net1146 sky130_fd_sc_hd__dlygate4sd3_1
XFILLER_130_699 VGND VGND VPWR VPWR sky130_fd_sc_hd__fill_1
XFILLER_96_580 VGND VGND VPWR VPWR sky130_fd_sc_hd__fill_1
XFILLER_75_219 VGND VGND VPWR VPWR sky130_fd_sc_hd__fill_1
XFILLER_69_783 VGND VGND VPWR VPWR sky130_fd_sc_hd__fill_1
Xhold48 net106 VGND VGND VPWR VPWR net1157 sky130_fd_sc_hd__dlygate4sd3_1
Xhold59 net124 VGND VGND VPWR VPWR net1168 sky130_fd_sc_hd__dlygate4sd3_1
X_07857_ picorv32_core.cpuregs\[28\]\[19\] picorv32_core.cpuregs\[29\]\[19\] picorv32_core.cpuregs\[30\]\[19\]
+ picorv32_core.cpuregs\[31\]\[19\] net748 net715 VGND VGND VPWR VPWR _03943_ sky130_fd_sc_hd__mux4_1
XFILLER_17_809 VGND VGND VPWR VPWR sky130_fd_sc_hd__decap_4
X_07788_ picorv32_core.cpuregs\[20\]\[15\] picorv32_core.cpuregs\[21\]\[15\] picorv32_core.cpuregs\[22\]\[15\]
+ picorv32_core.cpuregs\[23\]\[15\] net751 net718 VGND VGND VPWR VPWR _03878_ sky130_fd_sc_hd__mux4_1
X_06808_ net975 _03034_ VGND VGND VPWR VPWR _00238_ sky130_fd_sc_hd__nor2_1
X_09527_ _04702_ _04703_ net655 VGND VGND VPWR VPWR _04711_ sky130_fd_sc_hd__mux2_1
X_06739_ net673 _02969_ _02970_ _02967_ _02968_ VGND VGND VPWR VPWR _02971_ sky130_fd_sc_hd__o32a_1
XTAP_TAPCELL_ROW_14_509 VGND VPWR sky130_fd_sc_hd__tapvpwrvgnd_1
X_09458_ net654 _04644_ VGND VGND VPWR VPWR _04645_ sky130_fd_sc_hd__or2_1
XFILLER_51_182 VGND VGND VPWR VPWR sky130_fd_sc_hd__fill_1
X_08409_ picorv32_core.mem_rdata_q\[31\] _04283_ net524 VGND VGND VPWR VPWR _04284_
+ sky130_fd_sc_hd__a21o_2
X_09389_ picorv32_core.cpuregs\[4\]\[9\] picorv32_core.cpuregs\[5\]\[9\] picorv32_core.cpuregs\[6\]\[9\]
+ picorv32_core.cpuregs\[7\]\[9\] net873 net840 VGND VGND VPWR VPWR _04579_ sky130_fd_sc_hd__mux4_1
XFILLER_138_755 VGND VGND VPWR VPWR sky130_fd_sc_hd__fill_1
XFILLER_8_529 VGND VGND VPWR VPWR sky130_fd_sc_hd__decap_3
X_11420_ clknet_leaf_116_clk _01256_ VGND VGND VPWR VPWR picorv32_core.cpuregs\[1\]\[3\]
+ sky130_fd_sc_hd__dfxtp_1
XFILLER_124_3 VPWR VGND VPWR VGND sky130_ef_sc_hd__decap_12
X_11351_ clknet_leaf_118_clk _01192_ VGND VGND VPWR VPWR picorv32_core.cpuregs\[18\]\[3\]
+ sky130_fd_sc_hd__dfxtp_1
XFILLER_137_298 VGND VGND VPWR VPWR sky130_fd_sc_hd__decap_4
X_10302_ clknet_leaf_58_clk _00221_ VGND VGND VPWR VPWR picorv32_core.reg_pc\[23\]
+ sky130_fd_sc_hd__dfxtp_2
XPHY_EDGE_ROW_89_Left_231 VGND VGND VPWR VPWR sky130_fd_sc_hd__decap_3
XFILLER_4_713 VPWR VGND VPWR VGND sky130_ef_sc_hd__decap_12
X_11282_ clknet_leaf_138_clk _01130_ VGND VGND VPWR VPWR picorv32_core.cpuregs\[3\]\[5\]
+ sky130_fd_sc_hd__dfxtp_1
XFILLER_4_757 VPWR VGND VPWR VGND sky130_ef_sc_hd__decap_12
XFILLER_3_223 VGND VGND VPWR VPWR sky130_fd_sc_hd__fill_1
X_10233_ clknet_leaf_80_clk net1833 VGND VGND VPWR VPWR picorv32_core.count_instr\[17\]
+ sky130_fd_sc_hd__dfxtp_1
X_10164_ clknet_leaf_5_clk _00083_ VGND VGND VPWR VPWR picorv32_core.cpuregs\[21\]\[12\]
+ sky130_fd_sc_hd__dfxtp_1
XFILLER_10_83 VGND VGND VPWR VPWR sky130_fd_sc_hd__fill_1
XFILLER_126_83 VGND VGND VPWR VPWR sky130_fd_sc_hd__fill_1
X_10095_ net1121 VGND VGND VPWR VPWR _00945_ sky130_fd_sc_hd__clkbuf_1
XFILLER_19_113 VGND VGND VPWR VPWR sky130_fd_sc_hd__fill_1
XFILLER_101_390 VGND VGND VPWR VPWR sky130_fd_sc_hd__fill_2
XPHY_EDGE_ROW_98_Left_240 VGND VGND VPWR VPWR sky130_fd_sc_hd__decap_3
XFILLER_75_764 VGND VGND VPWR VPWR sky130_fd_sc_hd__fill_1
XFILLER_19_81 VGND VGND VPWR VPWR sky130_fd_sc_hd__decap_4
XFILLER_19_157 VGND VGND VPWR VPWR sky130_fd_sc_hd__decap_3
XFILLER_34_138 VGND VGND VPWR VPWR sky130_fd_sc_hd__fill_2
X_10997_ clknet_leaf_10_clk _00848_ VGND VGND VPWR VPWR picorv32_core.cpuregs\[12\]\[11\]
+ sky130_fd_sc_hd__dfxtp_1
XFILLER_35_91 VGND VGND VPWR VPWR sky130_fd_sc_hd__fill_1
XFILLER_129_711 VGND VGND VPWR VPWR sky130_fd_sc_hd__fill_2
XFILLER_30_344 VGND VGND VPWR VPWR sky130_fd_sc_hd__decap_3
X_11618_ clknet_leaf_67_clk _01449_ VGND VGND VPWR VPWR picorv32_core.cpuregs\[23\]\[31\]
+ sky130_fd_sc_hd__dfxtp_1
XFILLER_128_232 VGND VGND VPWR VPWR sky130_fd_sc_hd__decap_4
XTAP_TAPCELL_ROW_41_895 VGND VPWR sky130_fd_sc_hd__tapvpwrvgnd_1
Xhold518 picorv32_core.cpuregs\[5\]\[26\] VGND VGND VPWR VPWR net1627 sky130_fd_sc_hd__dlygate4sd3_1
X_11549_ clknet_leaf_63_clk _01380_ VGND VGND VPWR VPWR picorv32_core.cpuregs\[30\]\[30\]
+ sky130_fd_sc_hd__dfxtp_1
Xhold507 picorv32_core.cpuregs\[26\]\[21\] VGND VGND VPWR VPWR net1616 sky130_fd_sc_hd__dlygate4sd3_1
Xhold529 picorv32_core.cpuregs\[5\]\[18\] VGND VGND VPWR VPWR net1638 sky130_fd_sc_hd__dlygate4sd3_1
X_05070_ net175 VGND VGND VPWR VPWR _01605_ sky130_fd_sc_hd__inv_2
XFILLER_112_611 VGND VGND VPWR VPWR sky130_fd_sc_hd__fill_1
XFILLER_98_801 VGND VGND VPWR VPWR sky130_fd_sc_hd__fill_1
Xhold1207 picorv32_core.decoded_imm_j\[7\] VGND VGND VPWR VPWR net2316 sky130_fd_sc_hd__dlygate4sd3_1
XTAP_TAPCELL_ROW_127_2146 VGND VPWR sky130_fd_sc_hd__tapvpwrvgnd_1
Xhold1218 picorv32_core.count_cycle\[25\] VGND VGND VPWR VPWR net2327 sky130_fd_sc_hd__dlygate4sd3_1
X_05972_ net787 _02438_ VGND VGND VPWR VPWR _02439_ sky130_fd_sc_hd__nand2_1
XFILLER_66_731 VGND VGND VPWR VPWR sky130_fd_sc_hd__fill_1
X_08760_ net445 net1837 net374 VGND VGND VPWR VPWR _00907_ sky130_fd_sc_hd__mux2_1
Xhold1229 picorv32_core.is_compare VGND VGND VPWR VPWR net2338 sky130_fd_sc_hd__dlygate4sd3_1
X_08691_ net1643 net492 net383 VGND VGND VPWR VPWR _00840_ sky130_fd_sc_hd__mux2_1
X_07711_ picorv32_core.cpuregs\[16\]\[11\] picorv32_core.cpuregs\[17\]\[11\] picorv32_core.cpuregs\[18\]\[11\]
+ picorv32_core.cpuregs\[19\]\[11\] net736 net703 VGND VGND VPWR VPWR _03805_ sky130_fd_sc_hd__mux4_1
XFILLER_38_477 VGND VGND VPWR VPWR sky130_fd_sc_hd__decap_3
X_07642_ net628 _03739_ VGND VGND VPWR VPWR _03740_ sky130_fd_sc_hd__or2_1
XTAP_TAPCELL_ROW_140_2335 VGND VPWR sky130_fd_sc_hd__tapvpwrvgnd_1
XTAP_TAPCELL_ROW_109_1890 VGND VPWR sky130_fd_sc_hd__tapvpwrvgnd_1
XFILLER_80_222 VGND VGND VPWR VPWR sky130_fd_sc_hd__decap_3
X_07573_ picorv32_core.cpuregs\[8\]\[1\] picorv32_core.cpuregs\[9\]\[1\] picorv32_core.cpuregs\[10\]\[1\]
+ picorv32_core.cpuregs\[11\]\[1\] net744 net711 VGND VGND VPWR VPWR _03677_ sky130_fd_sc_hd__mux4_1
X_09312_ net818 net802 net540 VGND VGND VPWR VPWR _04505_ sky130_fd_sc_hd__mux2_1
X_06524_ net2252 _02831_ net991 VGND VGND VPWR VPWR _02834_ sky130_fd_sc_hd__o21ai_1
X_06455_ net255 net1951 net419 VGND VGND VPWR VPWR _00121_ sky130_fd_sc_hd__mux2_1
X_09243_ picorv32_core.cpuregs\[0\]\[3\] picorv32_core.cpuregs\[1\]\[3\] picorv32_core.cpuregs\[2\]\[3\]
+ picorv32_core.cpuregs\[3\]\[3\] net885 net852 VGND VGND VPWR VPWR _04439_ sky130_fd_sc_hd__mux4_1
X_06386_ picorv32_core.reg_pc\[28\] _02776_ picorv32_core.reg_pc\[29\] VGND VGND VPWR
+ VPWR _02783_ sky130_fd_sc_hd__a21oi_1
X_05406_ _01727_ _01907_ VGND VGND VPWR VPWR _01908_ sky130_fd_sc_hd__or2_1
X_09174_ net610 _03461_ _04370_ _04372_ net281 VGND VGND VPWR VPWR _04373_ sky130_fd_sc_hd__a311o_1
X_08125_ net249 net2194 net417 VGND VGND VPWR VPWR _00418_ sky130_fd_sc_hd__mux2_1
X_05337_ net944 picorv32_core.count_cycle\[41\] net605 _01843_ VGND VGND VPWR VPWR
+ _01844_ sky130_fd_sc_hd__a211o_1
XFILLER_31_27 VGND VGND VPWR VPWR sky130_fd_sc_hd__decap_3
X_08056_ picorv32_core.cpuregs\[24\]\[30\] picorv32_core.cpuregs\[25\]\[30\] picorv32_core.cpuregs\[26\]\[30\]
+ picorv32_core.cpuregs\[27\]\[30\] net759 net726 VGND VGND VPWR VPWR _04131_ sky130_fd_sc_hd__mux4_1
XFILLER_107_449 VGND VGND VPWR VPWR sky130_fd_sc_hd__decap_6
XTAP_TAPCELL_ROW_56_1119 VGND VPWR sky130_fd_sc_hd__tapvpwrvgnd_1
X_05268_ picorv32_core.reg_pc\[5\] picorv32_core.decoded_imm\[5\] VGND VGND VPWR VPWR
+ _01779_ sky130_fd_sc_hd__and2_1
Xoutput49 net49 VGND VGND VPWR VPWR mem_axi_araddr[20] sky130_fd_sc_hd__buf_2
X_07007_ _02937_ _03203_ VGND VGND VPWR VPWR _03218_ sky130_fd_sc_hd__nor2_1
XFILLER_89_812 VGND VGND VPWR VPWR sky130_fd_sc_hd__fill_1
X_05199_ net928 net925 VGND VGND VPWR VPWR _01715_ sky130_fd_sc_hd__nor2_2
XFILLER_1_727 VGND VGND VPWR VPWR sky130_fd_sc_hd__fill_1
XFILLER_115_482 VGND VGND VPWR VPWR sky130_fd_sc_hd__fill_1
XFILLER_0_237 VPWR VGND VPWR VGND sky130_ef_sc_hd__decap_12
XFILLER_103_688 VGND VGND VPWR VPWR sky130_fd_sc_hd__fill_1
X_08958_ net1289 net447 net348 VGND VGND VPWR VPWR _01130_ sky130_fd_sc_hd__mux2_1
X_07909_ picorv32_core.decoded_imm\[21\] net592 net597 VGND VGND VPWR VPWR _03993_
+ sky130_fd_sc_hd__a21o_1
X_08889_ net496 net2158 net359 VGND VGND VPWR VPWR _01063_ sky130_fd_sc_hd__mux2_1
XFILLER_29_455 VGND VGND VPWR VPWR sky130_fd_sc_hd__decap_3
X_10920_ clknet_leaf_88_clk _00771_ VGND VGND VPWR VPWR picorv32_core.mem_rdata_q\[30\]
+ sky130_fd_sc_hd__dfxtp_1
XFILLER_29_488 VGND VGND VPWR VPWR sky130_fd_sc_hd__decap_3
XFILLER_84_594 VPWR VGND VPWR VGND sky130_ef_sc_hd__decap_12
XFILLER_44_447 VGND VGND VPWR VPWR sky130_fd_sc_hd__fill_2
X_10851_ clknet_leaf_38_clk _00702_ VGND VGND VPWR VPWR picorv32_core.cpuregs\[17\]\[28\]
+ sky130_fd_sc_hd__dfxtp_1
XFILLER_112_85 VGND VGND VPWR VPWR sky130_fd_sc_hd__decap_4
XFILLER_72_23 VGND VGND VPWR VPWR sky130_fd_sc_hd__decap_4
X_10782_ clknet_leaf_43_clk _00633_ VGND VGND VPWR VPWR picorv32_core.cpuregs\[14\]\[23\]
+ sky130_fd_sc_hd__dfxtp_1
XFILLER_71_277 VGND VGND VPWR VPWR sky130_fd_sc_hd__decap_3
XTAP_TAPCELL_ROW_80_1459 VGND VPWR sky130_fd_sc_hd__tapvpwrvgnd_1
XFILLER_52_491 VGND VGND VPWR VPWR sky130_fd_sc_hd__fill_1
XFILLER_138_530 VGND VGND VPWR VPWR sky130_fd_sc_hd__fill_2
X_11403_ clknet_leaf_51_clk _01239_ VGND VGND VPWR VPWR picorv32_core.cpuregs\[31\]\[18\]
+ sky130_fd_sc_hd__dfxtp_1
XFILLER_126_725 VPWR VGND VPWR VGND sky130_ef_sc_hd__decap_12
XFILLER_126_769 VPWR VGND VPWR VGND sky130_ef_sc_hd__decap_12
X_11334_ clknet_leaf_51_clk _01175_ VGND VGND VPWR VPWR picorv32_core.cpuregs\[29\]\[18\]
+ sky130_fd_sc_hd__dfxtp_1
XFILLER_141_706 VGND VGND VPWR VPWR sky130_fd_sc_hd__decap_4
XFILLER_140_205 VGND VGND VPWR VPWR sky130_fd_sc_hd__fill_2
XFILLER_113_408 VGND VGND VPWR VPWR sky130_fd_sc_hd__fill_1
X_11265_ clknet_leaf_40_clk _01113_ VGND VGND VPWR VPWR picorv32_core.cpuregs\[4\]\[20\]
+ sky130_fd_sc_hd__dfxtp_1
XFILLER_97_31 VGND VGND VPWR VPWR sky130_fd_sc_hd__fill_1
XTAP_TAPCELL_ROW_95_1680 VGND VPWR sky130_fd_sc_hd__tapvpwrvgnd_1
XFILLER_137_93 VPWR VGND VPWR VGND sky130_ef_sc_hd__decap_12
X_10216_ clknet_leaf_105_clk _00135_ VGND VGND VPWR VPWR picorv32_core.count_instr\[0\]
+ sky130_fd_sc_hd__dfxtp_1
X_11196_ clknet_leaf_21_clk _01047_ VGND VGND VPWR VPWR picorv32_core.cpuregs\[6\]\[18\]
+ sky130_fd_sc_hd__dfxtp_1
X_10147_ clknet_leaf_65_clk _00069_ VGND VGND VPWR VPWR picorv32_core.cpuregs\[22\]\[30\]
+ sky130_fd_sc_hd__dfxtp_1
XFILLER_67_528 VGND VGND VPWR VPWR sky130_fd_sc_hd__decap_6
X_10078_ picorv32_core.decoded_imm_j\[18\] _00759_ net440 VGND VGND VPWR VPWR _00526_
+ sky130_fd_sc_hd__mux2_1
XFILLER_48_753 VGND VGND VPWR VPWR sky130_fd_sc_hd__decap_3
XFILLER_35_436 VGND VGND VPWR VPWR sky130_fd_sc_hd__decap_4
XTAP_TAPCELL_ROW_122_2076 VGND VPWR sky130_fd_sc_hd__tapvpwrvgnd_1
XFILLER_16_661 VGND VGND VPWR VPWR sky130_fd_sc_hd__decap_4
XTAP_TAPCELL_ROW_46_965 VGND VPWR sky130_fd_sc_hd__tapvpwrvgnd_1
XTAP_TAPCELL_ROW_46_976 VGND VPWR sky130_fd_sc_hd__tapvpwrvgnd_1
Xclkbuf_0_clk clk VGND VGND VPWR VPWR clknet_0_clk sky130_fd_sc_hd__clkbuf_16
X_06240_ _02665_ picorv32_core.latched_rd\[0\] picorv32_core.latched_rd\[1\] VGND
+ VGND VPWR VPWR _02666_ sky130_fd_sc_hd__or3b_4
X_06171_ picorv32_core.cpuregs\[12\]\[2\] picorv32_core.cpuregs\[13\]\[2\] picorv32_core.cpuregs\[14\]\[2\]
+ picorv32_core.cpuregs\[15\]\[2\] net733 net700 VGND VGND VPWR VPWR _02603_ sky130_fd_sc_hd__mux4_1
X_05122_ picorv32_core.instr_sra picorv32_core.instr_srai VGND VGND VPWR VPWR _01653_
+ sky130_fd_sc_hd__nor2_1
Xhold326 picorv32_core.cpuregs\[13\]\[12\] VGND VGND VPWR VPWR net1435 sky130_fd_sc_hd__dlygate4sd3_1
Xhold304 picorv32_core.cpuregs\[28\]\[7\] VGND VGND VPWR VPWR net1413 sky130_fd_sc_hd__dlygate4sd3_1
Xhold315 picorv32_core.cpuregs\[28\]\[8\] VGND VGND VPWR VPWR net1424 sky130_fd_sc_hd__dlygate4sd3_1
X_09930_ net211 net2058 net323 VGND VGND VPWR VPWR _01414_ sky130_fd_sc_hd__mux2_1
Xhold359 picorv32_core.cpuregs\[28\]\[29\] VGND VGND VPWR VPWR net1468 sky130_fd_sc_hd__dlygate4sd3_1
XFILLER_117_19 VGND VGND VPWR VPWR sky130_fd_sc_hd__fill_1
Xhold348 picorv32_core.cpuregs\[11\]\[14\] VGND VGND VPWR VPWR net1457 sky130_fd_sc_hd__dlygate4sd3_1
X_05053_ axi_adapter.mem_valid VGND VGND VPWR VPWR _01588_ sky130_fd_sc_hd__inv_2
Xhold337 picorv32_core.cpuregs\[5\]\[7\] VGND VGND VPWR VPWR net1446 sky130_fd_sc_hd__dlygate4sd3_1
XPHY_EDGE_ROW_15_Right_15 VGND VGND VPWR VPWR sky130_fd_sc_hd__decap_3
Xfanout806 net171 VGND VGND VPWR VPWR net806 sky130_fd_sc_hd__dlymetal6s2s_1
Xfanout839 _00007_ VGND VGND VPWR VPWR net839 sky130_fd_sc_hd__buf_2
Xfanout828 _00009_ VGND VGND VPWR VPWR net828 sky130_fd_sc_hd__buf_4
Xfanout817 net818 VGND VGND VPWR VPWR net817 sky130_fd_sc_hd__clkbuf_2
X_09861_ _02666_ _04346_ VGND VGND VPWR VPWR _05029_ sky130_fd_sc_hd__nor2_2
X_09792_ net832 _04960_ _04963_ net481 VGND VGND VPWR VPWR _04964_ sky130_fd_sc_hd__o211a_1
X_08812_ net228 net2183 net373 VGND VGND VPWR VPWR _00990_ sky130_fd_sc_hd__mux2_1
Xhold1004 picorv32_core.cpuregs\[18\]\[21\] VGND VGND VPWR VPWR net2113 sky130_fd_sc_hd__dlygate4sd3_1
Xhold1015 picorv32_core.cpuregs\[4\]\[20\] VGND VGND VPWR VPWR net2124 sky130_fd_sc_hd__dlygate4sd3_1
XTAP_TAPCELL_ROW_51_1049 VGND VPWR sky130_fd_sc_hd__tapvpwrvgnd_1
XTAP_TAPCELL_ROW_51_1038 VGND VPWR sky130_fd_sc_hd__tapvpwrvgnd_1
Xhold1048 picorv32_core.cpuregs\[24\]\[28\] VGND VGND VPWR VPWR net2157 sky130_fd_sc_hd__dlygate4sd3_1
X_08743_ net1261 net242 net379 VGND VGND VPWR VPWR _00891_ sky130_fd_sc_hd__mux2_1
X_05955_ net791 _02414_ _02401_ net793 VGND VGND VPWR VPWR _02423_ sky130_fd_sc_hd__o211a_1
Xhold1037 picorv32_core.cpuregs\[21\]\[12\] VGND VGND VPWR VPWR net2146 sky130_fd_sc_hd__dlygate4sd3_1
Xhold1026 picorv32_core.cpuregs\[6\]\[6\] VGND VGND VPWR VPWR net2135 sky130_fd_sc_hd__dlygate4sd3_1
XFILLER_54_701 VGND VGND VPWR VPWR sky130_fd_sc_hd__fill_1
Xhold1059 picorv32_core.cpuregs\[9\]\[6\] VGND VGND VPWR VPWR net2168 sky130_fd_sc_hd__dlygate4sd3_1
X_08674_ net253 net1741 net388 VGND VGND VPWR VPWR _00824_ sky130_fd_sc_hd__mux2_1
XFILLER_81_531 VGND VGND VPWR VPWR sky130_fd_sc_hd__fill_2
XFILLER_66_583 VGND VGND VPWR VPWR sky130_fd_sc_hd__decap_4
X_05886_ _02198_ net572 net607 VGND VGND VPWR VPWR _02360_ sky130_fd_sc_hd__a21o_1
XFILLER_26_27 VGND VGND VPWR VPWR sky130_fd_sc_hd__fill_1
X_07625_ net627 _03714_ net681 VGND VGND VPWR VPWR _03724_ sky130_fd_sc_hd__o21a_1
XPHY_EDGE_ROW_24_Right_24 VGND VGND VPWR VPWR sky130_fd_sc_hd__decap_3
X_07556_ net691 _03660_ VGND VGND VPWR VPWR _03661_ sky130_fd_sc_hd__nand2_1
X_06507_ net2344 _02820_ _02822_ VGND VGND VPWR VPWR _00149_ sky130_fd_sc_hd__o21a_1
XTAP_TAPCELL_ROW_24_648 VGND VPWR sky130_fd_sc_hd__tapvpwrvgnd_1
XTAP_TAPCELL_ROW_24_659 VGND VPWR sky130_fd_sc_hd__tapvpwrvgnd_1
X_07487_ net2277 _03612_ net462 VGND VGND VPWR VPWR _00339_ sky130_fd_sc_hd__mux2_1
XFILLER_22_664 VGND VGND VPWR VPWR sky130_fd_sc_hd__decap_3
X_09226_ net913 net810 net540 VGND VGND VPWR VPWR _04423_ sky130_fd_sc_hd__and3_1
XFILLER_42_48 VGND VGND VPWR VPWR sky130_fd_sc_hd__decap_6
X_06438_ net498 net1778 net421 VGND VGND VPWR VPWR _00104_ sky130_fd_sc_hd__mux2_1
X_06369_ _02766_ _02769_ net564 VGND VGND VPWR VPWR _02770_ sky130_fd_sc_hd__mux2_2
X_09157_ picorv32_core.cpuregs\[12\]\[0\] picorv32_core.cpuregs\[13\]\[0\] picorv32_core.cpuregs\[14\]\[0\]
+ picorv32_core.cpuregs\[15\]\[0\] net876 net843 VGND VGND VPWR VPWR _04356_ sky130_fd_sc_hd__mux4_1
XFILLER_108_747 VGND VGND VPWR VPWR sky130_fd_sc_hd__decap_3
X_09088_ net496 net1419 net333 VGND VGND VPWR VPWR _01255_ sky130_fd_sc_hd__mux2_1
X_08108_ net494 net1450 net415 VGND VGND VPWR VPWR _00401_ sky130_fd_sc_hd__mux2_1
X_08039_ picorv32_core.cpuregs\[0\]\[29\] picorv32_core.cpuregs\[1\]\[29\] picorv32_core.cpuregs\[2\]\[29\]
+ picorv32_core.cpuregs\[3\]\[29\] net761 net728 VGND VGND VPWR VPWR _04115_ sky130_fd_sc_hd__mux4_1
XFILLER_1_502 VGND VGND VPWR VPWR sky130_fd_sc_hd__fill_2
XPHY_EDGE_ROW_33_Right_33 VGND VGND VPWR VPWR sky130_fd_sc_hd__decap_3
Xhold882 picorv32_core.cpuregs\[19\]\[23\] VGND VGND VPWR VPWR net1991 sky130_fd_sc_hd__dlygate4sd3_1
Xhold871 picorv32_core.cpuregs\[15\]\[20\] VGND VGND VPWR VPWR net1980 sky130_fd_sc_hd__dlygate4sd3_1
Xhold860 picorv32_core.cpuregs\[12\]\[13\] VGND VGND VPWR VPWR net1969 sky130_fd_sc_hd__dlygate4sd3_1
XFILLER_122_249 VGND VGND VPWR VPWR sky130_fd_sc_hd__decap_3
Xhold893 _00188_ VGND VGND VPWR VPWR net2002 sky130_fd_sc_hd__dlygate4sd3_1
XFILLER_89_664 VGND VGND VPWR VPWR sky130_fd_sc_hd__decap_8
X_11050_ clknet_leaf_132_clk _00901_ VGND VGND VPWR VPWR picorv32_core.cpuregs\[10\]\[0\]
+ sky130_fd_sc_hd__dfxtp_1
XFILLER_131_783 VGND VGND VPWR VPWR sky130_fd_sc_hd__fill_1
X_10001_ net1625 net219 net314 VGND VGND VPWR VPWR _01478_ sky130_fd_sc_hd__mux2_1
XFILLER_76_303 VGND VGND VPWR VPWR sky130_fd_sc_hd__decap_4
XFILLER_123_51 VGND VGND VPWR VPWR sky130_fd_sc_hd__decap_4
XFILLER_92_818 VGND VGND VPWR VPWR sky130_fd_sc_hd__fill_1
XFILLER_57_561 VGND VGND VPWR VPWR sky130_fd_sc_hd__decap_4
XTAP_TAPCELL_ROW_4_362 VGND VPWR sky130_fd_sc_hd__tapvpwrvgnd_1
XFILLER_123_95 VGND VGND VPWR VPWR sky130_fd_sc_hd__fill_1
XFILLER_72_531 VGND VGND VPWR VPWR sky130_fd_sc_hd__fill_1
XPHY_EDGE_ROW_42_Right_42 VGND VGND VPWR VPWR sky130_fd_sc_hd__decap_3
X_10903_ clknet_leaf_98_clk _00754_ VGND VGND VPWR VPWR picorv32_core.mem_rdata_q\[13\]
+ sky130_fd_sc_hd__dfxtp_2
XTAP_TAPCELL_ROW_43_924 VGND VPWR sky130_fd_sc_hd__tapvpwrvgnd_1
XTAP_TAPCELL_ROW_43_935 VGND VPWR sky130_fd_sc_hd__tapvpwrvgnd_1
X_10834_ clknet_leaf_3_clk _00685_ VGND VGND VPWR VPWR picorv32_core.cpuregs\[17\]\[11\]
+ sky130_fd_sc_hd__dfxtp_1
XFILLER_12_152 VGND VGND VPWR VPWR sky130_fd_sc_hd__decap_3
XFILLER_12_141 VGND VGND VPWR VPWR sky130_fd_sc_hd__fill_2
XFILLER_9_635 VGND VGND VPWR VPWR sky130_fd_sc_hd__fill_1
X_10765_ clknet_leaf_141_clk _00616_ VGND VGND VPWR VPWR picorv32_core.cpuregs\[14\]\[6\]
+ sky130_fd_sc_hd__dfxtp_1
XPHY_EDGE_ROW_17_Left_159 VGND VGND VPWR VPWR sky130_fd_sc_hd__decap_3
X_10696_ clknet_leaf_137_clk _00547_ VGND VGND VPWR VPWR net132 sky130_fd_sc_hd__dfxtp_1
XPHY_EDGE_ROW_51_Right_51 VGND VGND VPWR VPWR sky130_fd_sc_hd__decap_3
XPHY_EDGE_ROW_136_Right_136 VGND VGND VPWR VPWR sky130_fd_sc_hd__decap_3
X_11317_ clknet_leaf_111_clk _01158_ VGND VGND VPWR VPWR picorv32_core.cpuregs\[29\]\[1\]
+ sky130_fd_sc_hd__dfxtp_1
XFILLER_114_739 VPWR VGND VPWR VGND sky130_ef_sc_hd__decap_12
XFILLER_99_428 VGND VGND VPWR VPWR sky130_fd_sc_hd__decap_3
XFILLER_4_362 VGND VGND VPWR VPWR sky130_fd_sc_hd__fill_2
XFILLER_141_558 VGND VGND VPWR VPWR sky130_fd_sc_hd__fill_2
XFILLER_79_130 VGND VGND VPWR VPWR sky130_fd_sc_hd__fill_1
X_11248_ clknet_leaf_115_clk _01096_ VGND VGND VPWR VPWR picorv32_core.cpuregs\[4\]\[3\]
+ sky130_fd_sc_hd__dfxtp_1
XPHY_EDGE_ROW_26_Left_168 VGND VGND VPWR VPWR sky130_fd_sc_hd__decap_3
X_11179_ clknet_leaf_110_clk _01030_ VGND VGND VPWR VPWR picorv32_core.cpuregs\[6\]\[1\]
+ sky130_fd_sc_hd__dfxtp_1
XTAP_TAPCELL_ROW_124_2105 VGND VPWR sky130_fd_sc_hd__tapvpwrvgnd_1
XFILLER_67_369 VGND VGND VPWR VPWR sky130_fd_sc_hd__decap_3
XPHY_EDGE_ROW_60_Right_60 VGND VGND VPWR VPWR sky130_fd_sc_hd__decap_3
XFILLER_75_391 VGND VGND VPWR VPWR sky130_fd_sc_hd__fill_1
X_05740_ net801 _02196_ net958 VGND VGND VPWR VPWR _02224_ sky130_fd_sc_hd__or3b_1
XFILLER_36_745 VGND VGND VPWR VPWR sky130_fd_sc_hd__decap_8
X_05671_ _02153_ _02154_ _02152_ VGND VGND VPWR VPWR _02155_ sky130_fd_sc_hd__a21bo_1
X_07410_ net839 _03545_ _03549_ VGND VGND VPWR VPWR _03550_ sky130_fd_sc_hd__a21o_1
X_08390_ picorv32_core.mem_do_rdata _03580_ _01627_ VGND VGND VPWR VPWR _04270_ sky130_fd_sc_hd__o21a_1
XPHY_EDGE_ROW_35_Left_177 VGND VGND VPWR VPWR sky130_fd_sc_hd__decap_3
X_07341_ _03442_ _03480_ VGND VGND VPWR VPWR _03481_ sky130_fd_sc_hd__and2_1
XTAP_TAPCELL_ROW_102_1779 VGND VPWR sky130_fd_sc_hd__tapvpwrvgnd_1
XTAP_TAPCELL_ROW_21_607 VGND VPWR sky130_fd_sc_hd__tapvpwrvgnd_1
XFILLER_137_809 VPWR VGND VPWR VGND sky130_ef_sc_hd__decap_12
X_07272_ net775 picorv32_core.decoded_imm\[23\] VGND VGND VPWR VPWR _03412_ sky130_fd_sc_hd__nor2_1
XFILLER_12_18 VGND VGND VPWR VPWR sky130_fd_sc_hd__decap_8
XTAP_TAPCELL_ROW_135_2256 VGND VPWR sky130_fd_sc_hd__tapvpwrvgnd_1
X_09011_ net235 net1705 net346 VGND VGND VPWR VPWR _01181_ sky130_fd_sc_hd__mux2_1
XFILLER_12_29 VPWR VGND VPWR VGND sky130_ef_sc_hd__decap_12
X_06223_ picorv32_core.cpuregs\[16\]\[4\] picorv32_core.cpuregs\[17\]\[4\] picorv32_core.cpuregs\[18\]\[4\]
+ picorv32_core.cpuregs\[19\]\[4\] net744 net711 VGND VGND VPWR VPWR _02653_ sky130_fd_sc_hd__mux4_1
XTAP_TAPCELL_ROW_135_2267 VGND VPWR sky130_fd_sc_hd__tapvpwrvgnd_1
XFILLER_129_393 VGND VGND VPWR VPWR sky130_fd_sc_hd__decap_3
XFILLER_128_29 VPWR VGND VPWR VGND sky130_ef_sc_hd__decap_12
X_06154_ picorv32_core.decoded_imm_j\[17\] _00758_ net439 VGND VGND VPWR VPWR _00027_
+ sky130_fd_sc_hd__mux2_1
Xhold101 picorv32_core.cpuregs\[20\]\[3\] VGND VGND VPWR VPWR net1210 sky130_fd_sc_hd__dlygate4sd3_1
Xhold112 picorv32_core.cpuregs\[27\]\[24\] VGND VGND VPWR VPWR net1221 sky130_fd_sc_hd__dlygate4sd3_1
XFILLER_117_588 VGND VGND VPWR VPWR sky130_fd_sc_hd__fill_1
Xhold123 picorv32_core.cpuregs\[30\]\[24\] VGND VGND VPWR VPWR net1232 sky130_fd_sc_hd__dlygate4sd3_1
XFILLER_105_717 VGND VGND VPWR VPWR sky130_fd_sc_hd__decap_8
XPHY_EDGE_ROW_103_Right_103 VGND VGND VPWR VPWR sky130_fd_sc_hd__decap_3
Xhold134 picorv32_core.cpuregs\[26\]\[12\] VGND VGND VPWR VPWR net1243 sky130_fd_sc_hd__dlygate4sd3_1
X_05105_ net908 picorv32_core.cpu_state\[5\] VGND VGND VPWR VPWR _01637_ sky130_fd_sc_hd__nor2_8
X_06085_ net769 _02542_ VGND VGND VPWR VPWR _02543_ sky130_fd_sc_hd__nand2_1
Xhold145 picorv32_core.cpuregs\[31\]\[5\] VGND VGND VPWR VPWR net1254 sky130_fd_sc_hd__dlygate4sd3_1
Xhold167 picorv32_core.cpuregs\[12\]\[0\] VGND VGND VPWR VPWR net1276 sky130_fd_sc_hd__dlygate4sd3_1
Xhold156 picorv32_core.cpuregs\[19\]\[7\] VGND VGND VPWR VPWR net1265 sky130_fd_sc_hd__dlygate4sd3_1
XPHY_EDGE_ROW_44_Left_186 VGND VGND VPWR VPWR sky130_fd_sc_hd__decap_3
Xfanout603 net604 VGND VGND VPWR VPWR net603 sky130_fd_sc_hd__buf_2
Xfanout614 net615 VGND VGND VPWR VPWR net614 sky130_fd_sc_hd__clkbuf_2
X_09913_ net276 net1813 net320 VGND VGND VPWR VPWR _01397_ sky130_fd_sc_hd__mux2_1
Xhold178 picorv32_core.cpuregs\[27\]\[11\] VGND VGND VPWR VPWR net1287 sky130_fd_sc_hd__dlygate4sd3_1
Xhold189 picorv32_core.cpuregs\[26\]\[3\] VGND VGND VPWR VPWR net1298 sky130_fd_sc_hd__dlygate4sd3_1
X_09844_ picorv32_core.cpuregs\[20\]\[30\] picorv32_core.cpuregs\[21\]\[30\] picorv32_core.cpuregs\[22\]\[30\]
+ picorv32_core.cpuregs\[23\]\[30\] net904 net869 VGND VGND VPWR VPWR _05013_ sky130_fd_sc_hd__mux4_1
Xfanout658 net659 VGND VGND VPWR VPWR net658 sky130_fd_sc_hd__clkbuf_8
XFILLER_113_783 VGND VGND VPWR VPWR sky130_fd_sc_hd__fill_1
Xfanout636 net637 VGND VGND VPWR VPWR net636 sky130_fd_sc_hd__clkbuf_4
Xfanout647 _01618_ VGND VGND VPWR VPWR net647 sky130_fd_sc_hd__clkbuf_8
Xfanout625 net626 VGND VGND VPWR VPWR net625 sky130_fd_sc_hd__buf_4
XFILLER_100_433 VGND VGND VPWR VPWR sky130_fd_sc_hd__decap_3
XFILLER_86_645 VGND VGND VPWR VPWR sky130_fd_sc_hd__fill_2
Xfanout669 net672 VGND VGND VPWR VPWR net669 sky130_fd_sc_hd__buf_2
XFILLER_37_15 VGND VGND VPWR VPWR sky130_fd_sc_hd__decap_4
XFILLER_100_477 VGND VGND VPWR VPWR sky130_fd_sc_hd__decap_8
X_06987_ net932 _02936_ VGND VGND VPWR VPWR _03199_ sky130_fd_sc_hd__xnor2_1
X_09775_ net971 net549 VGND VGND VPWR VPWR _04947_ sky130_fd_sc_hd__or2_2
XFILLER_39_561 VGND VGND VPWR VPWR sky130_fd_sc_hd__fill_1
X_05938_ net793 net178 net569 VGND VGND VPWR VPWR _02408_ sky130_fd_sc_hd__and3_1
XFILLER_54_531 VGND VGND VPWR VPWR sky130_fd_sc_hd__fill_1
X_08726_ net1352 net447 net378 VGND VGND VPWR VPWR _00874_ sky130_fd_sc_hd__mux2_1
XTAP_TAPCELL_ROW_1_321 VGND VPWR sky130_fd_sc_hd__tapvpwrvgnd_1
XTAP_TAPCELL_ROW_29_729 VGND VPWR sky130_fd_sc_hd__tapvpwrvgnd_1
X_05869_ net803 _02342_ VGND VGND VPWR VPWR _02344_ sky130_fd_sc_hd__nand2_1
XPHY_EDGE_ROW_53_Left_195 VGND VGND VPWR VPWR sky130_fd_sc_hd__decap_3
X_08657_ net495 net1966 net386 VGND VGND VPWR VPWR _00807_ sky130_fd_sc_hd__mux2_1
XFILLER_27_778 VGND VGND VPWR VPWR sky130_fd_sc_hd__decap_6
XFILLER_81_361 VGND VGND VPWR VPWR sky130_fd_sc_hd__decap_8
XTAP_TAPCELL_ROW_64_1229 VGND VPWR sky130_fd_sc_hd__tapvpwrvgnd_1
X_07608_ net628 _03697_ net687 VGND VGND VPWR VPWR _03708_ sky130_fd_sc_hd__o21a_1
XFILLER_53_47 VGND VGND VPWR VPWR sky130_fd_sc_hd__fill_1
X_08588_ net466 net2182 net395 VGND VGND VPWR VPWR _00711_ sky130_fd_sc_hd__mux2_1
XFILLER_139_113 VPWR VGND VPWR VGND sky130_ef_sc_hd__decap_12
X_07539_ _01590_ _01597_ net552 VGND VGND VPWR VPWR _03647_ sky130_fd_sc_hd__and3_1
X_10550_ clknet_leaf_141_clk _00404_ VGND VGND VPWR VPWR picorv32_core.cpuregs\[25\]\[6\]
+ sky130_fd_sc_hd__dfxtp_1
X_09209_ picorv32_core.cpuregs\[12\]\[2\] picorv32_core.cpuregs\[13\]\[2\] picorv32_core.cpuregs\[14\]\[2\]
+ picorv32_core.cpuregs\[15\]\[2\] net875 net842 VGND VGND VPWR VPWR _04406_ sky130_fd_sc_hd__mux4_1
X_10481_ clknet_leaf_128_clk _00367_ VGND VGND VPWR VPWR picorv32_core.mem_la_wdata\[7\]
+ sky130_fd_sc_hd__dfxtp_1
XTAP_TAPCELL_ROW_79_1450 VGND VPWR sky130_fd_sc_hd__tapvpwrvgnd_1
XFILLER_5_137 VPWR VGND VPWR VGND sky130_ef_sc_hd__decap_12
XTAP_TAPCELL_ROW_9_432 VGND VPWR sky130_fd_sc_hd__tapvpwrvgnd_1
XFILLER_2_833 VGND VGND VPWR VPWR sky130_fd_sc_hd__fill_1
XFILLER_2_811 VGND VGND VPWR VPWR sky130_fd_sc_hd__fill_1
Xhold690 picorv32_core.cpuregs\[13\]\[26\] VGND VGND VPWR VPWR net1799 sky130_fd_sc_hd__dlygate4sd3_1
X_11102_ clknet_leaf_40_clk _00953_ VGND VGND VPWR VPWR picorv32_core.cpuregs\[0\]\[20\]
+ sky130_fd_sc_hd__dfxtp_1
XFILLER_89_461 VGND VGND VPWR VPWR sky130_fd_sc_hd__decap_6
XFILLER_77_612 VGND VGND VPWR VPWR sky130_fd_sc_hd__decap_4
X_11033_ clknet_leaf_9_clk _00884_ VGND VGND VPWR VPWR picorv32_core.cpuregs\[11\]\[15\]
+ sky130_fd_sc_hd__dfxtp_1
XFILLER_76_133 VGND VGND VPWR VPWR sky130_fd_sc_hd__fill_1
XFILLER_134_83 VGND VGND VPWR VPWR sky130_fd_sc_hd__fill_1
XFILLER_17_222 VGND VGND VPWR VPWR sky130_fd_sc_hd__fill_2
XFILLER_27_70 VGND VGND VPWR VPWR sky130_fd_sc_hd__fill_2
XFILLER_45_597 VPWR VGND VPWR VGND sky130_ef_sc_hd__decap_12
X_10817_ clknet_leaf_45_clk _00668_ VGND VGND VPWR VPWR picorv32_core.cpuregs\[15\]\[26\]
+ sky130_fd_sc_hd__dfxtp_1
XFILLER_60_567 VGND VGND VPWR VPWR sky130_fd_sc_hd__fill_2
XFILLER_119_809 VPWR VGND VPWR VGND sky130_ef_sc_hd__decap_12
X_10748_ clknet_leaf_94_clk _00599_ VGND VGND VPWR VPWR picorv32_core.decoded_imm\[11\]
+ sky130_fd_sc_hd__dfxtp_2
X_10679_ clknet_leaf_99_clk _00532_ VGND VGND VPWR VPWR picorv32_core.is_lb_lh_lw_lbu_lhu
+ sky130_fd_sc_hd__dfxtp_2
XFILLER_99_225 VGND VGND VPWR VPWR sky130_fd_sc_hd__fill_2
XTAP_TAPCELL_ROW_130_2186 VGND VPWR sky130_fd_sc_hd__tapvpwrvgnd_1
XFILLER_4_41 VPWR VGND VPWR VGND sky130_ef_sc_hd__decap_12
XTAP_TAPCELL_ROW_130_2197 VGND VPWR sky130_fd_sc_hd__tapvpwrvgnd_1
X_06910_ net589 _03127_ _03128_ VGND VGND VPWR VPWR _03129_ sky130_fd_sc_hd__a21o_1
XFILLER_4_85 VPWR VGND VPWR VGND sky130_ef_sc_hd__decap_12
X_07890_ picorv32_core.decoded_imm\[20\] net592 net597 VGND VGND VPWR VPWR _03975_
+ sky130_fd_sc_hd__a21o_1
XFILLER_83_615 VGND VGND VPWR VPWR sky130_fd_sc_hd__fill_1
X_06841_ net668 picorv32_core.reg_next_pc\[12\] _02924_ net491 VGND VGND VPWR VPWR
+ _03065_ sky130_fd_sc_hd__a22o_1
X_09560_ picorv32_core.cpuregs\[8\]\[17\] picorv32_core.cpuregs\[9\]\[17\] picorv32_core.cpuregs\[10\]\[17\]
+ picorv32_core.cpuregs\[11\]\[17\] net889 net855 VGND VGND VPWR VPWR _04742_ sky130_fd_sc_hd__mux4_1
XFILLER_82_114 VGND VGND VPWR VPWR sky130_fd_sc_hd__fill_1
X_06772_ picorv32_core.decoded_imm_j\[7\] _02919_ VGND VGND VPWR VPWR _03001_ sky130_fd_sc_hd__or2_1
X_08511_ net1529 net206 net409 VGND VGND VPWR VPWR _00641_ sky130_fd_sc_hd__mux2_1
X_05723_ net768 _01614_ _02162_ _02205_ _02206_ VGND VGND VPWR VPWR _02207_ sky130_fd_sc_hd__o221a_1
XFILLER_82_158 VGND VGND VPWR VPWR sky130_fd_sc_hd__fill_1
XFILLER_82_136 VGND VGND VPWR VPWR sky130_fd_sc_hd__decap_4
X_09491_ net796 net546 _04612_ net471 VGND VGND VPWR VPWR _04676_ sky130_fd_sc_hd__o211a_1
XFILLER_36_553 VGND VGND VPWR VPWR sky130_fd_sc_hd__decap_3
XTAP_TAPCELL_ROW_104_1819 VGND VPWR sky130_fd_sc_hd__tapvpwrvgnd_1
XTAP_TAPCELL_ROW_104_1808 VGND VPWR sky130_fd_sc_hd__tapvpwrvgnd_1
X_08442_ picorv32_core.decoded_imm\[16\] net530 _04284_ _04301_ VGND VGND VPWR VPWR
+ _00594_ sky130_fd_sc_hd__o22a_1
XFILLER_51_523 VGND VGND VPWR VPWR sky130_fd_sc_hd__fill_1
XFILLER_36_586 VGND VGND VPWR VPWR sky130_fd_sc_hd__fill_2
X_05654_ net817 net967 VGND VGND VPWR VPWR _02138_ sky130_fd_sc_hd__or2_1
X_05585_ net919 net768 _02068_ net922 _02072_ VGND VGND VPWR VPWR _02074_ sky130_fd_sc_hd__a221o_1
X_08373_ net1181 net454 _04261_ VGND VGND VPWR VPWR _00565_ sky130_fd_sc_hd__o21a_1
XFILLER_51_567 VGND VGND VPWR VPWR sky130_fd_sc_hd__fill_1
XFILLER_23_39 VPWR VGND VPWR VGND sky130_ef_sc_hd__decap_12
X_07324_ _03458_ _03462_ _03463_ _03457_ VGND VGND VPWR VPWR _03464_ sky130_fd_sc_hd__o211ai_2
XTAP_TAPCELL_ROW_34_798 VGND VPWR sky130_fd_sc_hd__tapvpwrvgnd_1
XFILLER_139_39 VPWR VGND VPWR VGND sky130_ef_sc_hd__decap_12
X_07255_ _01635_ _03386_ _03393_ VGND VGND VPWR VPWR _03395_ sky130_fd_sc_hd__nand3_4
X_06206_ picorv32_core.cpuregs\[16\]\[3\] picorv32_core.cpuregs\[17\]\[3\] picorv32_core.cpuregs\[18\]\[3\]
+ picorv32_core.cpuregs\[19\]\[3\] net742 net709 VGND VGND VPWR VPWR _02637_ sky130_fd_sc_hd__mux4_1
XFILLER_105_503 VGND VGND VPWR VPWR sky130_fd_sc_hd__fill_1
X_07186_ _03348_ net986 _03347_ VGND VGND VPWR VPWR _00302_ sky130_fd_sc_hd__and3b_1
X_06137_ net764 net196 net570 VGND VGND VPWR VPWR _02591_ sky130_fd_sc_hd__and3_1
X_06068_ net189 _02517_ net670 VGND VGND VPWR VPWR _02527_ sky130_fd_sc_hd__o21a_1
XFILLER_132_388 VGND VGND VPWR VPWR sky130_fd_sc_hd__fill_1
Xfanout400 net401 VGND VGND VPWR VPWR net400 sky130_fd_sc_hd__clkbuf_8
XTAP_TAPCELL_ROW_74_1380 VGND VPWR sky130_fd_sc_hd__tapvpwrvgnd_1
XFILLER_59_612 VGND VGND VPWR VPWR sky130_fd_sc_hd__decap_4
Xfanout422 net423 VGND VGND VPWR VPWR net422 sky130_fd_sc_hd__clkbuf_8
Xfanout411 _04226_ VGND VGND VPWR VPWR net411 sky130_fd_sc_hd__buf_4
Xfanout455 net456 VGND VGND VPWR VPWR net455 sky130_fd_sc_hd__buf_2
Xfanout444 net446 VGND VGND VPWR VPWR net444 sky130_fd_sc_hd__clkbuf_2
Xfanout466 net468 VGND VGND VPWR VPWR net466 sky130_fd_sc_hd__clkbuf_2
Xfanout433 net434 VGND VGND VPWR VPWR net433 sky130_fd_sc_hd__clkbuf_8
X_09827_ picorv32_core.cpuregs\[24\]\[29\] picorv32_core.cpuregs\[25\]\[29\] picorv32_core.cpuregs\[26\]\[29\]
+ picorv32_core.cpuregs\[27\]\[29\] net903 net871 VGND VGND VPWR VPWR _04997_ sky130_fd_sc_hd__mux4_1
Xfanout488 _03391_ VGND VGND VPWR VPWR net488 sky130_fd_sc_hd__clkbuf_4
Xfanout477 _04179_ VGND VGND VPWR VPWR net477 sky130_fd_sc_hd__clkbuf_2
Xfanout499 _02672_ VGND VGND VPWR VPWR net499 sky130_fd_sc_hd__buf_1
X_09758_ picorv32_core.cpuregs\[0\]\[26\] picorv32_core.cpuregs\[1\]\[26\] picorv32_core.cpuregs\[2\]\[26\]
+ picorv32_core.cpuregs\[3\]\[26\] net906 net868 VGND VGND VPWR VPWR _04931_ sky130_fd_sc_hd__mux4_1
XFILLER_86_497 VGND VGND VPWR VPWR sky130_fd_sc_hd__decap_8
XFILLER_74_626 VGND VGND VPWR VPWR sky130_fd_sc_hd__decap_3
XPHY_EDGE_ROW_61_Left_203 VGND VGND VPWR VPWR sky130_fd_sc_hd__decap_3
X_08709_ net1696 net244 net384 VGND VGND VPWR VPWR _00858_ sky130_fd_sc_hd__mux2_1
XFILLER_27_542 VGND VGND VPWR VPWR sky130_fd_sc_hd__fill_1
X_09689_ net775 net280 VGND VGND VPWR VPWR _04865_ sky130_fd_sc_hd__and2_1
XFILLER_73_169 VGND VGND VPWR VPWR sky130_fd_sc_hd__fill_2
X_11651_ clknet_leaf_133_clk _01482_ VGND VGND VPWR VPWR picorv32_core.cpuregs\[26\]\[0\]
+ sky130_fd_sc_hd__dfxtp_1
XFILLER_42_589 VPWR VGND VPWR VGND sky130_ef_sc_hd__decap_12
X_11582_ clknet_leaf_71_clk _01413_ VGND VGND VPWR VPWR picorv32_core.cpuregs\[2\]\[29\]
+ sky130_fd_sc_hd__dfxtp_1
X_10602_ clknet_leaf_111_clk _00456_ VGND VGND VPWR VPWR picorv32_core.latched_rd\[4\]
+ sky130_fd_sc_hd__dfxtp_1
X_10533_ clknet_leaf_53_clk picorv32_core.alu_out\[21\] VGND VGND VPWR VPWR picorv32_core.alu_out_q\[21\]
+ sky130_fd_sc_hd__dfxtp_1
XPHY_EDGE_ROW_70_Left_212 VGND VGND VPWR VPWR sky130_fd_sc_hd__decap_3
X_10464_ clknet_leaf_69_clk _00351_ VGND VGND VPWR VPWR net56 sky130_fd_sc_hd__dfxtp_1
XFILLER_108_330 VGND VGND VPWR VPWR sky130_fd_sc_hd__fill_2
XFILLER_136_694 VGND VGND VPWR VPWR sky130_fd_sc_hd__decap_6
X_10395_ clknet_leaf_80_clk _00314_ VGND VGND VPWR VPWR picorv32_core.count_cycle\[53\]
+ sky130_fd_sc_hd__dfxtp_1
XTAP_TAPCELL_ROW_90_1609 VGND VPWR sky130_fd_sc_hd__tapvpwrvgnd_1
XFILLER_2_685 VPWR VGND VPWR VGND sky130_ef_sc_hd__decap_12
X_11016_ clknet_leaf_65_clk _00867_ VGND VGND VPWR VPWR picorv32_core.cpuregs\[12\]\[30\]
+ sky130_fd_sc_hd__dfxtp_1
XFILLER_92_401 VGND VGND VPWR VPWR sky130_fd_sc_hd__fill_2
XFILLER_92_456 VGND VGND VPWR VPWR sky130_fd_sc_hd__decap_8
X_11849_ net52 VGND VGND VPWR VPWR net84 sky130_fd_sc_hd__clkbuf_1
XFILLER_21_729 VPWR VGND VPWR VGND sky130_ef_sc_hd__decap_12
XTAP_TAPCELL_ROW_119_2026 VGND VPWR sky130_fd_sc_hd__tapvpwrvgnd_1
XPHY_EDGE_ROW_109_Left_251 VGND VGND VPWR VPWR sky130_fd_sc_hd__decap_3
X_05370_ _01822_ _01872_ _01873_ _01817_ VGND VGND VPWR VPWR _01874_ sky130_fd_sc_hd__a31o_1
XFILLER_14_781 VPWR VGND VPWR VGND sky130_ef_sc_hd__decap_12
XTAP_TAPCELL_ROW_119_2037 VGND VPWR sky130_fd_sc_hd__tapvpwrvgnd_1
XFILLER_119_617 VGND VGND VPWR VPWR sky130_fd_sc_hd__decap_3
XTAP_TAPCELL_ROW_31_757 VGND VPWR sky130_fd_sc_hd__tapvpwrvgnd_1
Xclkload10 clknet_4_11_0_clk VGND VGND VPWR VPWR clkload10/Y sky130_fd_sc_hd__clkinvlp_4
XTAP_TAPCELL_ROW_132_2226 VGND VPWR sky130_fd_sc_hd__tapvpwrvgnd_1
XTAP_TAPCELL_ROW_132_2215 VGND VPWR sky130_fd_sc_hd__tapvpwrvgnd_1
X_07040_ _02940_ _03238_ VGND VGND VPWR VPWR _03248_ sky130_fd_sc_hd__and2_1
Xclkload21 clknet_leaf_4_clk VGND VGND VPWR VPWR clkload21/Y sky130_fd_sc_hd__clkinv_4
XTAP_TAPCELL_ROW_11_470 VGND VPWR sky130_fd_sc_hd__tapvpwrvgnd_1
Xclkload32 clknet_leaf_134_clk VGND VGND VPWR VPWR clkload32/Y sky130_fd_sc_hd__clkinv_4
Xclkload43 clknet_leaf_128_clk VGND VGND VPWR VPWR clkload43/Y sky130_fd_sc_hd__clkinv_8
Xclkload76 clknet_leaf_47_clk VGND VGND VPWR VPWR clkload76/Y sky130_fd_sc_hd__inv_6
Xclkload54 clknet_leaf_31_clk VGND VGND VPWR VPWR clkload54/Y sky130_fd_sc_hd__inv_6
Xclkload65 clknet_leaf_19_clk VGND VGND VPWR VPWR clkload65/Y sky130_fd_sc_hd__bufinv_16
Xclkload87 clknet_leaf_120_clk VGND VGND VPWR VPWR clkload87/Y sky130_fd_sc_hd__inv_8
XFILLER_88_707 VGND VGND VPWR VPWR sky130_fd_sc_hd__fill_1
Xclkload98 clknet_leaf_95_clk VGND VGND VPWR VPWR clkload98/Y sky130_fd_sc_hd__inv_6
XFILLER_141_141 VPWR VGND VPWR VGND sky130_ef_sc_hd__decap_12
XFILLER_102_506 VGND VGND VPWR VPWR sky130_fd_sc_hd__fill_2
X_08991_ net468 net1733 net345 VGND VGND VPWR VPWR _01161_ sky130_fd_sc_hd__mux2_1
X_07942_ _04020_ _04021_ _04022_ _04023_ net690 net622 VGND VGND VPWR VPWR _04024_
+ sky130_fd_sc_hd__mux4_1
XPHY_EDGE_ROW_118_Left_260 VGND VGND VPWR VPWR sky130_fd_sc_hd__decap_3
X_07873_ picorv32_core.cpuregs\[24\]\[20\] picorv32_core.cpuregs\[25\]\[20\] picorv32_core.cpuregs\[26\]\[20\]
+ picorv32_core.cpuregs\[27\]\[20\] net750 net717 VGND VGND VPWR VPWR _03958_ sky130_fd_sc_hd__mux4_1
XFILLER_96_773 VGND VGND VPWR VPWR sky130_fd_sc_hd__decap_8
X_09612_ picorv32_core.cpuregs\[4\]\[19\] picorv32_core.cpuregs\[5\]\[19\] picorv32_core.cpuregs\[6\]\[19\]
+ picorv32_core.cpuregs\[7\]\[19\] net890 net856 VGND VGND VPWR VPWR _04792_ sky130_fd_sc_hd__mux4_1
XFILLER_68_475 VGND VGND VPWR VPWR sky130_fd_sc_hd__fill_1
X_06824_ picorv32_core.decoded_imm_j\[9\] _02921_ _02922_ picorv32_core.decoded_imm_j\[10\]
+ VGND VGND VPWR VPWR _03049_ sky130_fd_sc_hd__a22o_1
XFILLER_141_29 VPWR VGND VPWR VGND sky130_ef_sc_hd__decap_12
X_09543_ picorv32_core.cpuregs\[0\]\[16\] picorv32_core.cpuregs\[1\]\[16\] picorv32_core.cpuregs\[2\]\[16\]
+ picorv32_core.cpuregs\[3\]\[16\] net890 net856 VGND VGND VPWR VPWR _04726_ sky130_fd_sc_hd__mux4_1
XFILLER_83_467 VGND VGND VPWR VPWR sky130_fd_sc_hd__fill_1
XTAP_TAPCELL_ROW_39_868 VGND VPWR sky130_fd_sc_hd__tapvpwrvgnd_1
XFILLER_55_169 VGND VGND VPWR VPWR sky130_fd_sc_hd__decap_3
X_06755_ net665 picorv32_core.reg_next_pc\[5\] _02917_ net491 VGND VGND VPWR VPWR
+ _02986_ sky130_fd_sc_hd__a22o_1
X_06686_ net2336 net554 _02932_ net517 VGND VGND VPWR VPWR _00218_ sky130_fd_sc_hd__a22o_1
X_05706_ _02188_ _02189_ VGND VGND VPWR VPWR _02190_ sky130_fd_sc_hd__and2_1
X_09474_ picorv32_core.cpuregs\[12\]\[13\] picorv32_core.cpuregs\[13\]\[13\] picorv32_core.cpuregs\[14\]\[13\]
+ picorv32_core.cpuregs\[15\]\[13\] net881 net848 VGND VGND VPWR VPWR _04660_ sky130_fd_sc_hd__mux4_1
XTAP_TAPCELL_ROW_19_581 VGND VPWR sky130_fd_sc_hd__tapvpwrvgnd_1
X_05637_ net923 _02115_ _02121_ VGND VGND VPWR VPWR _01571_ sky130_fd_sc_hd__a21o_1
X_08425_ picorv32_core.mem_rdata_q\[24\] net615 VGND VGND VPWR VPWR _04293_ sky130_fd_sc_hd__and2_1
XFILLER_12_729 VPWR VGND VPWR VGND sky130_ef_sc_hd__decap_12
XFILLER_24_578 VGND VGND VPWR VPWR sky130_fd_sc_hd__fill_1
X_08356_ net969 net956 net581 VGND VGND VPWR VPWR _04253_ sky130_fd_sc_hd__mux2_2
Xclkload4 clknet_4_5_0_clk VGND VGND VPWR VPWR clkload4/Y sky130_fd_sc_hd__clkinvlp_4
X_05568_ net22 net583 net574 VGND VGND VPWR VPWR _02058_ sky130_fd_sc_hd__a21o_1
X_07307_ net807 picorv32_core.decoded_imm\[7\] VGND VGND VPWR VPWR _03447_ sky130_fd_sc_hd__or2_1
X_08287_ net1697 net228 net413 VGND VGND VPWR VPWR _00511_ sky130_fd_sc_hd__mux2_1
XFILLER_137_447 VGND VGND VPWR VPWR sky130_fd_sc_hd__fill_1
X_05499_ picorv32_core.reg_pc\[21\] picorv32_core.decoded_imm\[21\] VGND VGND VPWR
+ VPWR _01994_ sky130_fd_sc_hd__nand2_1
XFILLER_118_661 VGND VGND VPWR VPWR sky130_fd_sc_hd__fill_2
X_07238_ _03380_ _03381_ VGND VGND VPWR VPWR _00321_ sky130_fd_sc_hd__nor2_1
X_07169_ picorv32_core.count_cycle\[34\] picorv32_core.count_cycle\[35\] _03334_ VGND
+ VGND VPWR VPWR _03338_ sky130_fd_sc_hd__and3_1
XFILLER_105_333 VGND VGND VPWR VPWR sky130_fd_sc_hd__decap_3
X_10180_ clknet_leaf_36_clk _00099_ VGND VGND VPWR VPWR picorv32_core.cpuregs\[21\]\[28\]
+ sky130_fd_sc_hd__dfxtp_1
XFILLER_79_729 VGND VGND VPWR VPWR sky130_fd_sc_hd__decap_6
Xfanout230 _02770_ VGND VGND VPWR VPWR net230 sky130_fd_sc_hd__clkbuf_2
Xfanout241 net243 VGND VGND VPWR VPWR net241 sky130_fd_sc_hd__dlymetal6s2s_1
Xfanout252 net254 VGND VGND VPWR VPWR net252 sky130_fd_sc_hd__dlymetal6s2s_1
XFILLER_86_250 VGND VGND VPWR VPWR sky130_fd_sc_hd__fill_2
Xfanout274 _02723_ VGND VGND VPWR VPWR net274 sky130_fd_sc_hd__clkbuf_2
XFILLER_59_453 VGND VGND VPWR VPWR sky130_fd_sc_hd__fill_1
XFILLER_59_442 VGND VGND VPWR VPWR sky130_fd_sc_hd__decap_6
Xfanout285 _03394_ VGND VGND VPWR VPWR net285 sky130_fd_sc_hd__clkbuf_4
Xfanout296 _02706_ VGND VGND VPWR VPWR net296 sky130_fd_sc_hd__clkbuf_2
XFILLER_47_626 VGND VGND VPWR VPWR sky130_fd_sc_hd__decap_4
XFILLER_74_445 VGND VGND VPWR VPWR sky130_fd_sc_hd__fill_1
XFILLER_131_51 VGND VGND VPWR VPWR sky130_fd_sc_hd__decap_4
XTAP_TAPCELL_ROW_87_1571 VGND VPWR sky130_fd_sc_hd__tapvpwrvgnd_1
XTAP_TAPCELL_ROW_87_1560 VGND VPWR sky130_fd_sc_hd__tapvpwrvgnd_1
XFILLER_55_670 VGND VGND VPWR VPWR sky130_fd_sc_hd__fill_2
XFILLER_34_309 VGND VGND VPWR VPWR sky130_fd_sc_hd__decap_4
X_11703_ clknet_leaf_50_clk _01534_ VGND VGND VPWR VPWR picorv32_core.cpuregs\[27\]\[20\]
+ sky130_fd_sc_hd__dfxtp_1
XFILLER_42_342 VGND VGND VPWR VPWR sky130_fd_sc_hd__fill_2
X_11634_ clknet_leaf_15_clk _01465_ VGND VGND VPWR VPWR picorv32_core.cpuregs\[28\]\[15\]
+ sky130_fd_sc_hd__dfxtp_1
X_11565_ clknet_leaf_6_clk _01396_ VGND VGND VPWR VPWR picorv32_core.cpuregs\[2\]\[12\]
+ sky130_fd_sc_hd__dfxtp_1
XFILLER_10_261 VGND VGND VPWR VPWR sky130_fd_sc_hd__fill_2
X_11496_ clknet_leaf_126_clk _01332_ VGND VGND VPWR VPWR net145 sky130_fd_sc_hd__dfxtp_1
XFILLER_7_777 VGND VGND VPWR VPWR sky130_fd_sc_hd__decap_6
X_10516_ clknet_leaf_128_clk picorv32_core.alu_out\[4\] VGND VGND VPWR VPWR picorv32_core.alu_out_q\[4\]
+ sky130_fd_sc_hd__dfxtp_1
X_10447_ clknet_leaf_117_clk _00334_ VGND VGND VPWR VPWR net39 sky130_fd_sc_hd__dfxtp_1
XFILLER_124_653 VGND VGND VPWR VPWR sky130_fd_sc_hd__fill_1
X_10378_ clknet_leaf_102_clk _00297_ VGND VGND VPWR VPWR picorv32_core.count_cycle\[36\]
+ sky130_fd_sc_hd__dfxtp_1
XFILLER_97_548 VGND VGND VPWR VPWR sky130_fd_sc_hd__fill_1
XFILLER_111_347 VGND VGND VPWR VPWR sky130_fd_sc_hd__fill_1
XFILLER_65_423 VGND VGND VPWR VPWR sky130_fd_sc_hd__fill_1
XFILLER_38_626 VGND VGND VPWR VPWR sky130_fd_sc_hd__fill_1
XFILLER_1_53 VGND VGND VPWR VPWR sky130_fd_sc_hd__decap_3
XFILLER_80_415 VGND VGND VPWR VPWR sky130_fd_sc_hd__decap_4
XFILLER_65_489 VGND VGND VPWR VPWR sky130_fd_sc_hd__fill_1
XFILLER_18_361 VGND VGND VPWR VPWR sky130_fd_sc_hd__decap_3
XFILLER_34_810 VGND VGND VPWR VPWR sky130_fd_sc_hd__fill_2
XTAP_TAPCELL_ROW_36_827 VGND VPWR sky130_fd_sc_hd__tapvpwrvgnd_1
X_06540_ picorv32_core.count_instr\[26\] picorv32_core.count_instr\[25\] picorv32_core.count_instr\[24\]
+ _02839_ VGND VGND VPWR VPWR _02844_ sky130_fd_sc_hd__and4_1
XTAP_TAPCELL_ROW_16_540 VGND VPWR sky130_fd_sc_hd__tapvpwrvgnd_1
XFILLER_33_353 VGND VGND VPWR VPWR sky130_fd_sc_hd__fill_1
X_06471_ picorv32_core.cpu_state\[1\] picorv32_core.count_instr\[0\] picorv32_core.decoder_trigger
+ picorv32_core.count_instr\[1\] VGND VGND VPWR VPWR _02800_ sky130_fd_sc_hd__a31o_1
X_05422_ picorv32_core.count_instr\[47\] net938 net942 picorv32_core.count_instr\[15\]
+ VGND VGND VPWR VPWR _01923_ sky130_fd_sc_hd__a22o_1
X_08210_ _04204_ _04207_ VGND VGND VPWR VPWR _04208_ sky130_fd_sc_hd__and2_2
X_09190_ _04385_ _04387_ _04384_ _04386_ net656 net853 VGND VGND VPWR VPWR _04388_
+ sky130_fd_sc_hd__mux4_1
X_08141_ _00744_ _00743_ _00741_ _00742_ VGND VGND VPWR VPWR _04173_ sky130_fd_sc_hd__and4b_1
X_05353_ _01850_ _01853_ _01858_ net921 VGND VGND VPWR VPWR _01548_ sky130_fd_sc_hd__a22o_1
X_08072_ picorv32_core.cpuregs\[16\]\[31\] picorv32_core.cpuregs\[17\]\[31\] picorv32_core.cpuregs\[18\]\[31\]
+ picorv32_core.cpuregs\[19\]\[31\] net761 net728 VGND VGND VPWR VPWR _04146_ sky130_fd_sc_hd__mux4_1
XFILLER_119_458 VGND VGND VPWR VPWR sky130_fd_sc_hd__fill_1
Xclkload121 clknet_leaf_62_clk VGND VGND VPWR VPWR clkload121/Y sky130_fd_sc_hd__clkinv_2
Xclkload110 clknet_leaf_102_clk VGND VGND VPWR VPWR clkload110/Y sky130_fd_sc_hd__clkinv_4
X_05284_ _01766_ _01768_ _01779_ _01765_ VGND VGND VPWR VPWR _01794_ sky130_fd_sc_hd__a211oi_1
X_07023_ _03230_ _03231_ VGND VGND VPWR VPWR _03232_ sky130_fd_sc_hd__and2_1
Xclkload132 clknet_leaf_83_clk VGND VGND VPWR VPWR clkload132/X sky130_fd_sc_hd__clkbuf_4
XFILLER_20_18 VGND VGND VPWR VPWR sky130_fd_sc_hd__decap_8
XFILLER_20_29 VPWR VGND VPWR VGND sky130_ef_sc_hd__decap_12
XFILLER_136_29 VPWR VGND VPWR VGND sky130_ef_sc_hd__decap_12
XTAP_TAPCELL_ROW_58_1150 VGND VPWR sky130_fd_sc_hd__tapvpwrvgnd_1
XTAP_TAPCELL_ROW_112_1929 VGND VPWR sky130_fd_sc_hd__tapvpwrvgnd_1
XFILLER_88_504 VPWR VGND VPWR VGND sky130_ef_sc_hd__decap_12
XFILLER_130_645 VGND VGND VPWR VPWR sky130_fd_sc_hd__decap_6
X_08974_ net1739 net245 net350 VGND VGND VPWR VPWR _01146_ sky130_fd_sc_hd__mux2_1
X_07925_ net695 _04003_ _04002_ net621 VGND VGND VPWR VPWR _04008_ sky130_fd_sc_hd__o211a_1
Xhold38 net117 VGND VGND VPWR VPWR net1147 sky130_fd_sc_hd__dlygate4sd3_1
XPHY_EDGE_ROW_89_Right_89 VGND VGND VPWR VPWR sky130_fd_sc_hd__decap_3
Xhold27 picorv32_core.decoded_rd\[0\] VGND VGND VPWR VPWR net1136 sky130_fd_sc_hd__dlygate4sd3_1
XFILLER_29_27 VGND VGND VPWR VPWR sky130_fd_sc_hd__decap_4
Xhold16 picorv32_core.decoded_rd\[4\] VGND VGND VPWR VPWR net1125 sky130_fd_sc_hd__dlygate4sd3_1
Xhold49 picorv32_core.instr_addi VGND VGND VPWR VPWR net1158 sky130_fd_sc_hd__dlygate4sd3_1
X_07856_ net696 _03941_ VGND VGND VPWR VPWR _03942_ sky130_fd_sc_hd__or2_1
XFILLER_84_765 VPWR VGND VPWR VGND sky130_ef_sc_hd__decap_12
X_07787_ picorv32_core.cpuregs\[0\]\[15\] picorv32_core.cpuregs\[1\]\[15\] picorv32_core.cpuregs\[2\]\[15\]
+ picorv32_core.cpuregs\[3\]\[15\] net751 net718 VGND VGND VPWR VPWR _03877_ sky130_fd_sc_hd__mux4_1
X_06807_ net588 _03032_ _03033_ VGND VGND VPWR VPWR _03034_ sky130_fd_sc_hd__a21oi_1
XFILLER_16_309 VGND VGND VPWR VPWR sky130_fd_sc_hd__fill_1
XFILLER_45_15 VPWR VGND VPWR VGND sky130_ef_sc_hd__decap_12
X_09526_ net838 _04708_ net826 VGND VGND VPWR VPWR _04710_ sky130_fd_sc_hd__o21a_1
X_06738_ _02916_ _02960_ VGND VGND VPWR VPWR _02970_ sky130_fd_sc_hd__nor2_1
X_09457_ picorv32_core.cpuregs\[12\]\[12\] picorv32_core.cpuregs\[13\]\[12\] picorv32_core.cpuregs\[14\]\[12\]
+ picorv32_core.cpuregs\[15\]\[12\] net879 net846 VGND VGND VPWR VPWR _04644_ sky130_fd_sc_hd__mux4_1
XPHY_EDGE_ROW_98_Right_98 VGND VGND VPWR VPWR sky130_fd_sc_hd__decap_3
X_06669_ _02713_ picorv32_core.reg_next_pc\[12\] net557 VGND VGND VPWR VPWR _02924_
+ sky130_fd_sc_hd__mux2_2
X_08408_ _04227_ _04282_ VGND VGND VPWR VPWR _04283_ sky130_fd_sc_hd__or2_2
XFILLER_138_701 VPWR VGND VPWR VGND sky130_ef_sc_hd__decap_12
XTAP_TAPCELL_ROW_82_1490 VGND VPWR sky130_fd_sc_hd__tapvpwrvgnd_1
X_09388_ picorv32_core.cpuregs\[24\]\[9\] picorv32_core.cpuregs\[25\]\[9\] picorv32_core.cpuregs\[26\]\[9\]
+ picorv32_core.cpuregs\[27\]\[9\] net873 net840 VGND VGND VPWR VPWR _04578_ sky130_fd_sc_hd__mux4_1
X_08339_ _01595_ net174 net451 _04241_ VGND VGND VPWR VPWR _04242_ sky130_fd_sc_hd__a211o_1
X_11350_ clknet_leaf_137_clk _01191_ VGND VGND VPWR VPWR picorv32_core.cpuregs\[18\]\[2\]
+ sky130_fd_sc_hd__dfxtp_1
XFILLER_117_3 VPWR VGND VPWR VGND sky130_ef_sc_hd__decap_12
X_10301_ clknet_leaf_58_clk _00220_ VGND VGND VPWR VPWR picorv32_core.reg_pc\[22\]
+ sky130_fd_sc_hd__dfxtp_1
XFILLER_4_725 VPWR VGND VPWR VGND sky130_ef_sc_hd__decap_12
XFILLER_106_642 VGND VGND VPWR VPWR sky130_fd_sc_hd__fill_2
X_11281_ clknet_leaf_110_clk _01129_ VGND VGND VPWR VPWR picorv32_core.cpuregs\[3\]\[4\]
+ sky130_fd_sc_hd__dfxtp_1
X_10232_ clknet_leaf_81_clk _00151_ VGND VGND VPWR VPWR picorv32_core.count_instr\[16\]
+ sky130_fd_sc_hd__dfxtp_1
XFILLER_4_769 VPWR VGND VPWR VGND sky130_ef_sc_hd__decap_12
XFILLER_79_559 VGND VGND VPWR VPWR sky130_fd_sc_hd__fill_1
X_10163_ clknet_leaf_2_clk _00082_ VGND VGND VPWR VPWR picorv32_core.cpuregs\[21\]\[11\]
+ sky130_fd_sc_hd__dfxtp_1
XTAP_TAPCELL_ROW_89_1600 VGND VPWR sky130_fd_sc_hd__tapvpwrvgnd_1
X_10094_ net1141 VGND VGND VPWR VPWR _00944_ sky130_fd_sc_hd__clkbuf_1
XFILLER_75_743 VGND VGND VPWR VPWR sky130_fd_sc_hd__fill_1
XFILLER_47_434 VGND VGND VPWR VPWR sky130_fd_sc_hd__decap_4
XFILLER_47_445 VGND VGND VPWR VPWR sky130_fd_sc_hd__decap_3
XFILLER_47_456 VGND VGND VPWR VPWR sky130_fd_sc_hd__decap_8
XFILLER_74_242 VGND VGND VPWR VPWR sky130_fd_sc_hd__fill_1
X_10996_ clknet_leaf_1_clk _00847_ VGND VGND VPWR VPWR picorv32_core.cpuregs\[12\]\[10\]
+ sky130_fd_sc_hd__dfxtp_1
XFILLER_43_673 VGND VGND VPWR VPWR sky130_fd_sc_hd__decap_6
XFILLER_30_323 VGND VGND VPWR VPWR sky130_fd_sc_hd__decap_3
X_11617_ clknet_leaf_66_clk _01448_ VGND VGND VPWR VPWR picorv32_core.cpuregs\[23\]\[30\]
+ sky130_fd_sc_hd__dfxtp_1
X_11548_ clknet_leaf_69_clk _01379_ VGND VGND VPWR VPWR picorv32_core.cpuregs\[30\]\[29\]
+ sky130_fd_sc_hd__dfxtp_1
XTAP_TAPCELL_ROW_41_896 VGND VPWR sky130_fd_sc_hd__tapvpwrvgnd_1
Xhold508 picorv32_core.cpuregs\[22\]\[2\] VGND VGND VPWR VPWR net1617 sky130_fd_sc_hd__dlygate4sd3_1
X_11479_ clknet_leaf_60_clk _01315_ VGND VGND VPWR VPWR picorv32_core.cpuregs\[24\]\[30\]
+ sky130_fd_sc_hd__dfxtp_1
Xhold519 picorv32_core.cpuregs\[31\]\[26\] VGND VGND VPWR VPWR net1628 sky130_fd_sc_hd__dlygate4sd3_1
XFILLER_124_472 VGND VGND VPWR VPWR sky130_fd_sc_hd__decap_4
XFILLER_32_3 VPWR VGND VPWR VGND sky130_ef_sc_hd__decap_12
XFILLER_112_667 VGND VGND VPWR VPWR sky130_fd_sc_hd__fill_1
XFILLER_100_807 VGND VGND VPWR VPWR sky130_fd_sc_hd__fill_1
XFILLER_97_367 VPWR VGND VPWR VGND sky130_ef_sc_hd__decap_12
X_05971_ net181 _02437_ VGND VGND VPWR VPWR _02438_ sky130_fd_sc_hd__xnor2_1
XTAP_TAPCELL_ROW_53_1080 VGND VPWR sky130_fd_sc_hd__tapvpwrvgnd_1
Xhold1208 picorv32_core.decoded_imm_j\[6\] VGND VGND VPWR VPWR net2317 sky130_fd_sc_hd__dlygate4sd3_1
Xhold1219 picorv32_core.count_instr\[0\] VGND VGND VPWR VPWR net2328 sky130_fd_sc_hd__dlygate4sd3_1
X_07710_ picorv32_core.cpuregs\[20\]\[11\] picorv32_core.cpuregs\[21\]\[11\] picorv32_core.cpuregs\[22\]\[11\]
+ picorv32_core.cpuregs\[23\]\[11\] net736 net703 VGND VGND VPWR VPWR _03804_ sky130_fd_sc_hd__mux4_1
XTAP_TAPCELL_ROW_127_2147 VGND VPWR sky130_fd_sc_hd__tapvpwrvgnd_1
X_08690_ net1706 net496 net382 VGND VGND VPWR VPWR _00839_ sky130_fd_sc_hd__mux2_1
XFILLER_53_415 VGND VGND VPWR VPWR sky130_fd_sc_hd__fill_1
X_07641_ picorv32_core.cpuregs\[12\]\[7\] picorv32_core.cpuregs\[13\]\[7\] picorv32_core.cpuregs\[14\]\[7\]
+ picorv32_core.cpuregs\[15\]\[7\] net739 net706 VGND VGND VPWR VPWR _03739_ sky130_fd_sc_hd__mux4_1
XTAP_TAPCELL_ROW_140_2336 VGND VPWR sky130_fd_sc_hd__tapvpwrvgnd_1
XTAP_TAPCELL_ROW_109_1891 VGND VPWR sky130_fd_sc_hd__tapvpwrvgnd_1
XTAP_TAPCELL_ROW_109_1880 VGND VPWR sky130_fd_sc_hd__tapvpwrvgnd_1
X_07572_ picorv32_core.cpuregs\[12\]\[1\] picorv32_core.cpuregs\[13\]\[1\] picorv32_core.cpuregs\[14\]\[1\]
+ picorv32_core.cpuregs\[15\]\[1\] net744 net711 VGND VGND VPWR VPWR _03676_ sky130_fd_sc_hd__mux4_1
X_06523_ picorv32_core.count_instr\[20\] picorv32_core.count_instr\[19\] picorv32_core.count_instr\[18\]
+ _02828_ VGND VGND VPWR VPWR _02833_ sky130_fd_sc_hd__and4_1
XFILLER_81_779 VGND VGND VPWR VPWR sky130_fd_sc_hd__decap_4
XFILLER_15_18 VPWR VGND VPWR VGND sky130_ef_sc_hd__decap_12
XFILLER_34_651 VGND VGND VPWR VPWR sky130_fd_sc_hd__decap_8
X_09311_ net808 net548 _04503_ net469 VGND VGND VPWR VPWR _04504_ sky130_fd_sc_hd__o211a_1
XFILLER_21_312 VGND VGND VPWR VPWR sky130_fd_sc_hd__fill_1
X_06454_ net261 net2132 net419 VGND VGND VPWR VPWR _00120_ sky130_fd_sc_hd__mux2_1
X_09242_ net837 _04437_ VGND VGND VPWR VPWR _04438_ sky130_fd_sc_hd__and2_1
XFILLER_21_334 VGND VGND VPWR VPWR sky130_fd_sc_hd__fill_2
X_06385_ picorv32_core.reg_out\[29\] picorv32_core.alu_out_q\[29\] net953 VGND VGND
+ VPWR VPWR _02782_ sky130_fd_sc_hd__mux2_1
X_05405_ net946 picorv32_core.count_cycle\[46\] picorv32_core.count_cycle\[14\] net604
+ _01906_ VGND VGND VPWR VPWR _01907_ sky130_fd_sc_hd__a221o_1
X_09173_ net913 net540 _04371_ VGND VGND VPWR VPWR _04372_ sky130_fd_sc_hd__and3_1
X_08124_ net253 net2134 net416 VGND VGND VPWR VPWR _00417_ sky130_fd_sc_hd__mux2_1
X_05336_ picorv32_core.count_instr\[41\] net935 net939 picorv32_core.count_instr\[9\]
+ VGND VGND VPWR VPWR _01843_ sky130_fd_sc_hd__a22o_1
X_08055_ picorv32_core.cpuregs\[28\]\[30\] picorv32_core.cpuregs\[29\]\[30\] picorv32_core.cpuregs\[30\]\[30\]
+ picorv32_core.cpuregs\[31\]\[30\] net759 net726 VGND VGND VPWR VPWR _04130_ sky130_fd_sc_hd__mux4_1
XFILLER_119_299 VGND VGND VPWR VPWR sky130_fd_sc_hd__fill_2
X_05267_ picorv32_core.reg_pc\[5\] picorv32_core.decoded_imm\[5\] VGND VGND VPWR VPWR
+ _01778_ sky130_fd_sc_hd__nor2_1
X_07006_ _03215_ _03216_ net664 VGND VGND VPWR VPWR _03217_ sky130_fd_sc_hd__a21o_1
Xoutput39 net39 VGND VGND VPWR VPWR mem_axi_araddr[10] sky130_fd_sc_hd__buf_2
X_05198_ net925 _01596_ net822 VGND VGND VPWR VPWR _01714_ sky130_fd_sc_hd__o21ai_2
XFILLER_0_249 VGND VGND VPWR VPWR sky130_fd_sc_hd__decap_3
X_08957_ net1515 net467 net349 VGND VGND VPWR VPWR _01129_ sky130_fd_sc_hd__mux2_1
X_07908_ _03989_ _03991_ net458 _03988_ VGND VGND VPWR VPWR _03992_ sky130_fd_sc_hd__o211a_1
XFILLER_56_47 VGND VGND VPWR VPWR sky130_fd_sc_hd__fill_1
X_08888_ net500 net1933 net359 VGND VGND VPWR VPWR _01062_ sky130_fd_sc_hd__mux2_1
X_07839_ picorv32_core.cpuregs\[24\]\[18\] picorv32_core.cpuregs\[25\]\[18\] picorv32_core.cpuregs\[26\]\[18\]
+ picorv32_core.cpuregs\[27\]\[18\] net751 net718 VGND VGND VPWR VPWR _03926_ sky130_fd_sc_hd__mux4_1
X_10850_ clknet_leaf_43_clk _00701_ VGND VGND VPWR VPWR picorv32_core.cpuregs\[17\]\[27\]
+ sky130_fd_sc_hd__dfxtp_1
XFILLER_72_757 VGND VGND VPWR VPWR sky130_fd_sc_hd__fill_2
XTAP_TAPCELL_ROW_84_1530 VGND VPWR sky130_fd_sc_hd__tapvpwrvgnd_1
X_10781_ clknet_leaf_30_clk _00632_ VGND VGND VPWR VPWR picorv32_core.cpuregs\[14\]\[22\]
+ sky130_fd_sc_hd__dfxtp_1
X_09509_ _03425_ _03489_ _03423_ _03424_ VGND VGND VPWR VPWR _04693_ sky130_fd_sc_hd__a211o_1
XFILLER_52_470 VGND VGND VPWR VPWR sky130_fd_sc_hd__decap_6
XFILLER_40_632 VGND VGND VPWR VPWR sky130_fd_sc_hd__decap_4
XPHY_EDGE_ROW_117_Right_117 VGND VGND VPWR VPWR sky130_fd_sc_hd__decap_3
X_11402_ clknet_leaf_24_clk _01238_ VGND VGND VPWR VPWR picorv32_core.cpuregs\[31\]\[17\]
+ sky130_fd_sc_hd__dfxtp_1
XFILLER_126_737 VPWR VGND VPWR VGND sky130_ef_sc_hd__decap_12
XANTENNA_90 net647 VGND VGND VPWR VPWR sky130_fd_sc_hd__diode_2
X_11333_ clknet_leaf_23_clk _01174_ VGND VGND VPWR VPWR picorv32_core.cpuregs\[29\]\[17\]
+ sky130_fd_sc_hd__dfxtp_1
XFILLER_4_533 VGND VGND VPWR VPWR sky130_fd_sc_hd__decap_3
XFILLER_141_729 VGND VGND VPWR VPWR sky130_fd_sc_hd__fill_2
XTAP_TAPCELL_ROW_95_1681 VGND VPWR sky130_fd_sc_hd__tapvpwrvgnd_1
X_11264_ clknet_leaf_28_clk _01112_ VGND VGND VPWR VPWR picorv32_core.cpuregs\[4\]\[19\]
+ sky130_fd_sc_hd__dfxtp_1
XFILLER_134_781 VPWR VGND VPWR VGND sky130_ef_sc_hd__decap_12
X_10215_ clknet_leaf_62_clk _00134_ VGND VGND VPWR VPWR picorv32_core.cpuregs\[9\]\[31\]
+ sky130_fd_sc_hd__dfxtp_1
X_11195_ clknet_leaf_26_clk _01046_ VGND VGND VPWR VPWR picorv32_core.cpuregs\[6\]\[17\]
+ sky130_fd_sc_hd__dfxtp_1
X_10146_ clknet_leaf_67_clk _00068_ VGND VGND VPWR VPWR picorv32_core.cpuregs\[22\]\[29\]
+ sky130_fd_sc_hd__dfxtp_1
XFILLER_0_783 VGND VGND VPWR VPWR sky130_fd_sc_hd__fill_1
X_10077_ picorv32_core.decoded_imm_j\[17\] _00758_ net439 VGND VGND VPWR VPWR _00525_
+ sky130_fd_sc_hd__mux2_1
XFILLER_48_765 VGND VGND VPWR VPWR sky130_fd_sc_hd__decap_4
XFILLER_48_798 VGND VGND VPWR VPWR sky130_fd_sc_hd__fill_1
XFILLER_62_245 VGND VGND VPWR VPWR sky130_fd_sc_hd__decap_6
XTAP_TAPCELL_ROW_46_966 VGND VPWR sky130_fd_sc_hd__tapvpwrvgnd_1
XTAP_TAPCELL_ROW_46_977 VGND VPWR sky130_fd_sc_hd__tapvpwrvgnd_1
X_10979_ clknet_leaf_70_clk _00830_ VGND VGND VPWR VPWR picorv32_core.cpuregs\[13\]\[25\]
+ sky130_fd_sc_hd__dfxtp_1
XTAP_TAPCELL_ROW_122_2077 VGND VPWR sky130_fd_sc_hd__tapvpwrvgnd_1
XFILLER_16_695 VGND VGND VPWR VPWR sky130_fd_sc_hd__decap_4
XFILLER_7_30 VPWR VGND VPWR VGND sky130_ef_sc_hd__decap_12
XFILLER_117_726 VGND VGND VPWR VPWR sky130_fd_sc_hd__fill_2
X_06170_ picorv32_core.cpuregs\[8\]\[2\] picorv32_core.cpuregs\[9\]\[2\] picorv32_core.cpuregs\[10\]\[2\]
+ picorv32_core.cpuregs\[11\]\[2\] net734 net701 VGND VGND VPWR VPWR _02602_ sky130_fd_sc_hd__mux4_1
Xhold305 picorv32_core.cpuregs\[22\]\[30\] VGND VGND VPWR VPWR net1414 sky130_fd_sc_hd__dlygate4sd3_1
Xhold316 picorv32_core.cpuregs\[14\]\[22\] VGND VGND VPWR VPWR net1425 sky130_fd_sc_hd__dlygate4sd3_1
X_05121_ picorv32_core.instr_rdinstrh picorv32_core.instr_rdinstr net945 VGND VGND
+ VPWR VPWR _01652_ sky130_fd_sc_hd__or3_4
XFILLER_7_393 VGND VGND VPWR VPWR sky130_fd_sc_hd__fill_1
Xhold349 picorv32_core.cpuregs\[19\]\[25\] VGND VGND VPWR VPWR net1458 sky130_fd_sc_hd__dlygate4sd3_1
Xhold338 picorv32_core.cpuregs\[15\]\[28\] VGND VGND VPWR VPWR net1447 sky130_fd_sc_hd__dlygate4sd3_1
X_05052_ net1832 VGND VGND VPWR VPWR _01587_ sky130_fd_sc_hd__inv_2
Xhold327 picorv32_core.reg_next_pc\[3\] VGND VGND VPWR VPWR net1436 sky130_fd_sc_hd__dlygate4sd3_1
X_09860_ net764 _05028_ net284 VGND VGND VPWR VPWR _01349_ sky130_fd_sc_hd__mux2_1
Xfanout807 net808 VGND VGND VPWR VPWR net807 sky130_fd_sc_hd__buf_2
Xfanout829 _00009_ VGND VGND VPWR VPWR net829 sky130_fd_sc_hd__buf_2
XFILLER_98_665 VGND VGND VPWR VPWR sky130_fd_sc_hd__decap_8
XFILLER_98_643 VGND VGND VPWR VPWR sky130_fd_sc_hd__fill_1
Xfanout818 net163 VGND VGND VPWR VPWR net818 sky130_fd_sc_hd__buf_2
X_09791_ _04954_ _04961_ _04962_ net646 net650 VGND VGND VPWR VPWR _04963_ sky130_fd_sc_hd__a221o_1
X_08811_ net234 net1698 net372 VGND VGND VPWR VPWR _00989_ sky130_fd_sc_hd__mux2_1
Xhold1005 picorv32_core.cpuregs\[13\]\[13\] VGND VGND VPWR VPWR net2114 sky130_fd_sc_hd__dlygate4sd3_1
XTAP_TAPCELL_ROW_51_1039 VGND VPWR sky130_fd_sc_hd__tapvpwrvgnd_1
Xhold1016 picorv32_core.cpuregs\[20\]\[20\] VGND VGND VPWR VPWR net2125 sky130_fd_sc_hd__dlygate4sd3_1
X_08742_ net2143 net244 net379 VGND VGND VPWR VPWR _00890_ sky130_fd_sc_hd__mux2_1
XFILLER_85_337 VGND VGND VPWR VPWR sky130_fd_sc_hd__fill_2
Xhold1027 picorv32_core.cpuregs\[17\]\[15\] VGND VGND VPWR VPWR net2136 sky130_fd_sc_hd__dlygate4sd3_1
X_05954_ _02377_ _02392_ _02404_ _02416_ _02391_ VGND VGND VPWR VPWR _02422_ sky130_fd_sc_hd__a2111oi_1
Xhold1049 picorv32_core.cpuregs\[5\]\[2\] VGND VGND VPWR VPWR net2158 sky130_fd_sc_hd__dlygate4sd3_1
Xhold1038 picorv32_core.cpuregs\[8\]\[6\] VGND VGND VPWR VPWR net2147 sky130_fd_sc_hd__dlygate4sd3_1
X_08673_ net255 net1614 net388 VGND VGND VPWR VPWR _00823_ sky130_fd_sc_hd__mux2_1
XFILLER_39_776 VGND VGND VPWR VPWR sky130_fd_sc_hd__decap_8
X_05885_ _02356_ _02357_ VGND VGND VPWR VPWR _02359_ sky130_fd_sc_hd__xnor2_1
X_07624_ picorv32_core.cpuregs\[8\]\[6\] picorv32_core.cpuregs\[9\]\[6\] picorv32_core.cpuregs\[10\]\[6\]
+ picorv32_core.cpuregs\[11\]\[6\] net732 net699 VGND VGND VPWR VPWR _03723_ sky130_fd_sc_hd__mux4_1
XFILLER_53_234 VGND VGND VPWR VPWR sky130_fd_sc_hd__fill_1
XFILLER_26_459 VGND VGND VPWR VPWR sky130_fd_sc_hd__fill_1
XTAP_TAPCELL_ROW_66_1260 VGND VPWR sky130_fd_sc_hd__tapvpwrvgnd_1
X_07555_ _03658_ _03659_ net632 VGND VGND VPWR VPWR _03660_ sky130_fd_sc_hd__mux2_1
X_07486_ net792 _03611_ net533 VGND VGND VPWR VPWR _03612_ sky130_fd_sc_hd__mux2_1
X_06506_ picorv32_core.count_instr\[14\] _02820_ net976 VGND VGND VPWR VPWR _02822_
+ sky130_fd_sc_hd__a21oi_1
XTAP_TAPCELL_ROW_24_649 VGND VPWR sky130_fd_sc_hd__tapvpwrvgnd_1
XFILLER_34_481 VGND VGND VPWR VPWR sky130_fd_sc_hd__fill_1
XFILLER_10_805 VGND VGND VPWR VPWR sky130_fd_sc_hd__decap_6
X_06437_ net503 net1772 net421 VGND VGND VPWR VPWR _00103_ sky130_fd_sc_hd__mux2_1
X_09225_ net816 net548 _04421_ VGND VGND VPWR VPWR _04422_ sky130_fd_sc_hd__o21a_1
X_06368_ _02767_ _02768_ VGND VGND VPWR VPWR _02769_ sky130_fd_sc_hd__nor2_1
X_09156_ picorv32_core.cpuregs\[8\]\[0\] picorv32_core.cpuregs\[9\]\[0\] picorv32_core.cpuregs\[10\]\[0\]
+ picorv32_core.cpuregs\[11\]\[0\] net876 net843 VGND VGND VPWR VPWR _04355_ sky130_fd_sc_hd__mux4_1
XFILLER_107_225 VGND VGND VPWR VPWR sky130_fd_sc_hd__decap_4
X_06299_ picorv32_core.reg_out\[12\] picorv32_core.alu_out_q\[12\] net951 VGND VGND
+ VPWR VPWR _02713_ sky130_fd_sc_hd__mux2_1
X_05319_ net943 picorv32_core.count_cycle\[40\] picorv32_core.count_cycle\[8\] net602
+ _01826_ VGND VGND VPWR VPWR _01827_ sky130_fd_sc_hd__a221o_1
X_09087_ net500 net1780 net333 VGND VGND VPWR VPWR _01254_ sky130_fd_sc_hd__mux2_1
Xclkbuf_leaf_110_clk clknet_4_10_0_clk VGND VGND VPWR VPWR clknet_leaf_110_clk sky130_fd_sc_hd__clkbuf_8
X_08107_ _02674_ net1920 net414 VGND VGND VPWR VPWR _00400_ sky130_fd_sc_hd__mux2_1
X_08038_ picorv32_core.cpuregs\[4\]\[29\] picorv32_core.cpuregs\[5\]\[29\] picorv32_core.cpuregs\[6\]\[29\]
+ picorv32_core.cpuregs\[7\]\[29\] net761 net728 VGND VGND VPWR VPWR _04114_ sky130_fd_sc_hd__mux4_1
XFILLER_123_729 VPWR VGND VPWR VGND sky130_ef_sc_hd__decap_12
XFILLER_116_781 VPWR VGND VPWR VGND sky130_ef_sc_hd__decap_12
Xhold861 picorv32_core.cpuregs\[28\]\[19\] VGND VGND VPWR VPWR net1970 sky130_fd_sc_hd__dlygate4sd3_1
Xhold872 picorv32_core.cpuregs\[14\]\[3\] VGND VGND VPWR VPWR net1981 sky130_fd_sc_hd__dlygate4sd3_1
XFILLER_1_525 VGND VGND VPWR VPWR sky130_fd_sc_hd__fill_2
Xhold850 picorv32_core.cpuregs\[8\]\[0\] VGND VGND VPWR VPWR net1959 sky130_fd_sc_hd__dlygate4sd3_1
Xhold894 picorv32_core.cpuregs\[9\]\[26\] VGND VGND VPWR VPWR net2003 sky130_fd_sc_hd__dlygate4sd3_1
X_10000_ net1677 net224 net314 VGND VGND VPWR VPWR _01477_ sky130_fd_sc_hd__mux2_1
Xhold883 picorv32_core.cpuregs\[14\]\[9\] VGND VGND VPWR VPWR net1992 sky130_fd_sc_hd__dlygate4sd3_1
X_09989_ net1246 net265 net314 VGND VGND VPWR VPWR _01466_ sky130_fd_sc_hd__mux2_1
XFILLER_49_518 VPWR VGND VPWR VGND sky130_ef_sc_hd__decap_12
XFILLER_88_197 VGND VGND VPWR VPWR sky130_fd_sc_hd__fill_2
XFILLER_29_220 VGND VGND VPWR VPWR sky130_fd_sc_hd__decap_4
XTAP_TAPCELL_ROW_4_363 VGND VPWR sky130_fd_sc_hd__tapvpwrvgnd_1
XFILLER_123_85 VGND VGND VPWR VPWR sky130_fd_sc_hd__fill_1
XFILLER_123_63 VGND VGND VPWR VPWR sky130_fd_sc_hd__fill_1
XFILLER_84_370 VGND VGND VPWR VPWR sky130_fd_sc_hd__fill_1
XFILLER_84_392 VGND VGND VPWR VPWR sky130_fd_sc_hd__fill_1
XFILLER_72_565 VGND VGND VPWR VPWR sky130_fd_sc_hd__decap_3
X_10902_ clknet_leaf_98_clk _00753_ VGND VGND VPWR VPWR picorv32_core.mem_rdata_q\[12\]
+ sky130_fd_sc_hd__dfxtp_1
XFILLER_72_598 VGND VGND VPWR VPWR sky130_fd_sc_hd__decap_8
XFILLER_72_587 VGND VGND VPWR VPWR sky130_fd_sc_hd__fill_1
XFILLER_25_470 VGND VGND VPWR VPWR sky130_fd_sc_hd__decap_4
X_10833_ clknet_leaf_2_clk _00684_ VGND VGND VPWR VPWR picorv32_core.cpuregs\[17\]\[10\]
+ sky130_fd_sc_hd__dfxtp_1
XTAP_TAPCELL_ROW_43_925 VGND VPWR sky130_fd_sc_hd__tapvpwrvgnd_1
X_10764_ clknet_leaf_138_clk _00615_ VGND VGND VPWR VPWR picorv32_core.cpuregs\[14\]\[5\]
+ sky130_fd_sc_hd__dfxtp_1
XFILLER_40_440 VGND VGND VPWR VPWR sky130_fd_sc_hd__fill_2
XFILLER_9_669 VGND VGND VPWR VPWR sky130_fd_sc_hd__decap_3
X_10695_ clknet_leaf_137_clk _00546_ VGND VGND VPWR VPWR net131 sky130_fd_sc_hd__dfxtp_1
XTAP_TAPCELL_ROW_97_1710 VGND VPWR sky130_fd_sc_hd__tapvpwrvgnd_1
Xclkbuf_leaf_101_clk clknet_4_11_0_clk VGND VGND VPWR VPWR clknet_leaf_101_clk sky130_fd_sc_hd__clkbuf_8
X_11316_ clknet_leaf_134_clk _01157_ VGND VGND VPWR VPWR picorv32_core.cpuregs\[29\]\[0\]
+ sky130_fd_sc_hd__dfxtp_1
X_11247_ clknet_leaf_135_clk _01095_ VGND VGND VPWR VPWR picorv32_core.cpuregs\[4\]\[2\]
+ sky130_fd_sc_hd__dfxtp_1
XFILLER_79_164 VGND VGND VPWR VPWR sky130_fd_sc_hd__decap_4
X_11178_ clknet_leaf_119_clk _01029_ VGND VGND VPWR VPWR picorv32_core.cpuregs\[6\]\[0\]
+ sky130_fd_sc_hd__dfxtp_1
X_10129_ clknet_leaf_5_clk _00051_ VGND VGND VPWR VPWR picorv32_core.cpuregs\[22\]\[12\]
+ sky130_fd_sc_hd__dfxtp_1
XTAP_TAPCELL_ROW_124_2106 VGND VPWR sky130_fd_sc_hd__tapvpwrvgnd_1
XFILLER_83_819 VGND VGND VPWR VPWR sky130_fd_sc_hd__fill_2
XFILLER_75_381 VGND VGND VPWR VPWR sky130_fd_sc_hd__decap_3
X_05670_ net766 net193 VGND VGND VPWR VPWR _02154_ sky130_fd_sc_hd__nand2_1
XFILLER_63_554 VGND VGND VPWR VPWR sky130_fd_sc_hd__decap_6
XFILLER_36_757 VGND VGND VPWR VPWR sky130_fd_sc_hd__fill_1
X_07340_ net805 picorv32_core.decoded_imm\[8\] VGND VGND VPWR VPWR _03480_ sky130_fd_sc_hd__or2_1
XTAP_TAPCELL_ROW_21_608 VGND VPWR sky130_fd_sc_hd__tapvpwrvgnd_1
X_09010_ net237 net2231 net346 VGND VGND VPWR VPWR _01180_ sky130_fd_sc_hd__mux2_1
X_07271_ net775 picorv32_core.decoded_imm\[23\] VGND VGND VPWR VPWR _03411_ sky130_fd_sc_hd__and2_1
XFILLER_117_501 VGND VGND VPWR VPWR sky130_fd_sc_hd__decap_3
XTAP_TAPCELL_ROW_61_1190 VGND VPWR sky130_fd_sc_hd__tapvpwrvgnd_1
X_06222_ picorv32_core.cpuregs\[20\]\[4\] picorv32_core.cpuregs\[21\]\[4\] picorv32_core.cpuregs\[22\]\[4\]
+ picorv32_core.cpuregs\[23\]\[4\] net744 net711 VGND VGND VPWR VPWR _02652_ sky130_fd_sc_hd__mux4_1
XTAP_TAPCELL_ROW_135_2268 VGND VPWR sky130_fd_sc_hd__tapvpwrvgnd_1
XTAP_TAPCELL_ROW_135_2257 VGND VPWR sky130_fd_sc_hd__tapvpwrvgnd_1
X_06153_ net2309 net12 net520 VGND VGND VPWR VPWR _00758_ sky130_fd_sc_hd__mux2_1
Xhold102 picorv32_core.cpuregs\[7\]\[24\] VGND VGND VPWR VPWR net1211 sky130_fd_sc_hd__dlygate4sd3_1
X_05104_ net667 net979 VGND VGND VPWR VPWR _01636_ sky130_fd_sc_hd__nor2_1
Xhold124 picorv32_core.cpuregs\[11\]\[13\] VGND VGND VPWR VPWR net1233 sky130_fd_sc_hd__dlygate4sd3_1
Xhold113 picorv32_core.cpuregs\[12\]\[1\] VGND VGND VPWR VPWR net1222 sky130_fd_sc_hd__dlygate4sd3_1
Xhold135 picorv32_core.cpuregs\[15\]\[7\] VGND VGND VPWR VPWR net1244 sky130_fd_sc_hd__dlygate4sd3_1
Xhold168 picorv32_core.cpuregs\[19\]\[20\] VGND VGND VPWR VPWR net1277 sky130_fd_sc_hd__dlygate4sd3_1
XFILLER_105_729 VGND VGND VPWR VPWR sky130_fd_sc_hd__decap_8
X_06084_ net191 _02541_ VGND VGND VPWR VPWR _02542_ sky130_fd_sc_hd__xnor2_1
XFILLER_104_206 VGND VGND VPWR VPWR sky130_fd_sc_hd__decap_4
Xhold157 picorv32_core.cpuregs\[23\]\[3\] VGND VGND VPWR VPWR net1266 sky130_fd_sc_hd__dlygate4sd3_1
Xhold146 picorv32_core.cpuregs\[23\]\[10\] VGND VGND VPWR VPWR net1255 sky130_fd_sc_hd__dlygate4sd3_1
Xfanout604 net605 VGND VGND VPWR VPWR net604 sky130_fd_sc_hd__buf_2
Xfanout615 net616 VGND VGND VPWR VPWR net615 sky130_fd_sc_hd__dlymetal6s2s_1
Xhold179 picorv32_core.cpuregs\[19\]\[14\] VGND VGND VPWR VPWR net1288 sky130_fd_sc_hd__dlygate4sd3_1
X_09912_ net286 net2126 net320 VGND VGND VPWR VPWR _01396_ sky130_fd_sc_hd__mux2_1
Xfanout637 net638 VGND VGND VPWR VPWR net637 sky130_fd_sc_hd__clkbuf_4
XFILLER_100_401 VGND VGND VPWR VPWR sky130_fd_sc_hd__decap_4
X_09843_ net765 net545 _04947_ net471 VGND VGND VPWR VPWR _05012_ sky130_fd_sc_hd__o211a_1
XFILLER_98_451 VGND VGND VPWR VPWR sky130_fd_sc_hd__fill_1
XFILLER_86_602 VGND VGND VPWR VPWR sky130_fd_sc_hd__fill_1
Xfanout626 _01620_ VGND VGND VPWR VPWR net626 sky130_fd_sc_hd__buf_4
XFILLER_59_816 VGND VGND VPWR VPWR sky130_fd_sc_hd__fill_1
Xfanout648 net649 VGND VGND VPWR VPWR net648 sky130_fd_sc_hd__buf_4
XFILLER_100_412 VGND VGND VPWR VPWR sky130_fd_sc_hd__decap_8
Xfanout659 net662 VGND VGND VPWR VPWR net659 sky130_fd_sc_hd__clkbuf_4
X_09774_ _03531_ _03532_ VGND VGND VPWR VPWR _04946_ sky130_fd_sc_hd__xnor2_1
X_06986_ _03195_ _03197_ _03198_ net989 VGND VGND VPWR VPWR _00252_ sky130_fd_sc_hd__o31a_1
XFILLER_85_167 VGND VGND VPWR VPWR sky130_fd_sc_hd__fill_1
XTAP_TAPCELL_ROW_29_719 VGND VPWR sky130_fd_sc_hd__tapvpwrvgnd_1
X_05937_ _02186_ net571 net609 VGND VGND VPWR VPWR _02407_ sky130_fd_sc_hd__a21o_1
XFILLER_54_510 VGND VGND VPWR VPWR sky130_fd_sc_hd__fill_1
X_08725_ net2012 net465 net381 VGND VGND VPWR VPWR _00873_ sky130_fd_sc_hd__mux2_1
XTAP_TAPCELL_ROW_1_322 VGND VPWR sky130_fd_sc_hd__tapvpwrvgnd_1
XFILLER_39_573 VPWR VGND VPWR VGND sky130_ef_sc_hd__decap_12
XFILLER_66_392 VGND VGND VPWR VPWR sky130_fd_sc_hd__decap_3
X_05868_ net803 _02342_ VGND VGND VPWR VPWR _02343_ sky130_fd_sc_hd__nor2_1
X_08656_ net498 net1919 net387 VGND VGND VPWR VPWR _00806_ sky130_fd_sc_hd__mux2_1
X_07607_ picorv32_core.cpuregs\[16\]\[5\] picorv32_core.cpuregs\[17\]\[5\] picorv32_core.cpuregs\[18\]\[5\]
+ picorv32_core.cpuregs\[19\]\[5\] net733 net700 VGND VGND VPWR VPWR _03707_ sky130_fd_sc_hd__mux4_1
X_08587_ net493 net1840 net395 VGND VGND VPWR VPWR _00710_ sky130_fd_sc_hd__mux2_1
X_05799_ net815 _02278_ VGND VGND VPWR VPWR _02280_ sky130_fd_sc_hd__or2_1
X_07538_ _01699_ _03645_ _03646_ VGND VGND VPWR VPWR _00356_ sky130_fd_sc_hd__and3_1
XFILLER_139_125 VPWR VGND VPWR VGND sky130_ef_sc_hd__decap_12
XFILLER_50_782 VGND VGND VPWR VPWR sky130_fd_sc_hd__fill_1
X_07469_ net2103 _03600_ net460 VGND VGND VPWR VPWR _00333_ sky130_fd_sc_hd__mux2_1
XFILLER_139_169 VPWR VGND VPWR VGND sky130_ef_sc_hd__decap_12
X_09208_ net836 _04402_ net831 VGND VGND VPWR VPWR _04405_ sky130_fd_sc_hd__a21oi_1
X_10480_ clknet_leaf_130_clk _00366_ VGND VGND VPWR VPWR picorv32_core.mem_la_wdata\[6\]
+ sky130_fd_sc_hd__dfxtp_1
X_09139_ net1915 net250 net331 VGND VGND VPWR VPWR _01305_ sky130_fd_sc_hd__mux2_1
XTAP_TAPCELL_ROW_79_1451 VGND VPWR sky130_fd_sc_hd__tapvpwrvgnd_1
XFILLER_5_105 VGND VGND VPWR VPWR sky130_fd_sc_hd__decap_6
XFILLER_108_545 VGND VGND VPWR VPWR sky130_fd_sc_hd__fill_1
XFILLER_5_149 VPWR VGND VPWR VGND sky130_ef_sc_hd__decap_12
X_11101_ clknet_leaf_30_clk _00952_ VGND VGND VPWR VPWR picorv32_core.cpuregs\[0\]\[19\]
+ sky130_fd_sc_hd__dfxtp_1
XTAP_TAPCELL_ROW_9_433 VGND VPWR sky130_fd_sc_hd__tapvpwrvgnd_1
XFILLER_118_85 VGND VGND VPWR VPWR sky130_fd_sc_hd__decap_3
XTAP_TAPCELL_ROW_92_1640 VGND VPWR sky130_fd_sc_hd__tapvpwrvgnd_1
Xhold680 picorv32_core.cpuregs\[7\]\[7\] VGND VGND VPWR VPWR net1789 sky130_fd_sc_hd__dlygate4sd3_1
Xhold691 picorv32_core.cpuregs\[20\]\[23\] VGND VGND VPWR VPWR net1800 sky130_fd_sc_hd__dlygate4sd3_1
X_11032_ clknet_leaf_25_clk _00883_ VGND VGND VPWR VPWR picorv32_core.cpuregs\[11\]\[14\]
+ sky130_fd_sc_hd__dfxtp_1
XFILLER_94_11 VGND VGND VPWR VPWR sky130_fd_sc_hd__decap_8
XFILLER_49_337 VGND VGND VPWR VPWR sky130_fd_sc_hd__fill_1
XFILLER_17_201 VGND VGND VPWR VPWR sky130_fd_sc_hd__decap_4
XFILLER_18_757 VPWR VGND VPWR VGND sky130_ef_sc_hd__decap_12
XFILLER_60_502 VPWR VGND VPWR VGND sky130_ef_sc_hd__decap_12
XFILLER_33_727 VGND VGND VPWR VPWR sky130_fd_sc_hd__fill_1
XFILLER_45_587 VGND VGND VPWR VPWR sky130_fd_sc_hd__decap_4
X_11865_ net962 VGND VGND VPWR VPWR net202 sky130_fd_sc_hd__clkbuf_2
X_10816_ clknet_leaf_67_clk _00667_ VGND VGND VPWR VPWR picorv32_core.cpuregs\[15\]\[25\]
+ sky130_fd_sc_hd__dfxtp_1
X_10747_ clknet_leaf_92_clk _00598_ VGND VGND VPWR VPWR picorv32_core.decoded_imm\[12\]
+ sky130_fd_sc_hd__dfxtp_2
XFILLER_71_7 VGND VGND VPWR VPWR sky130_fd_sc_hd__fill_1
X_10678_ clknet_leaf_97_clk _00031_ VGND VGND VPWR VPWR picorv32_core.is_lui_auipc_jal
+ sky130_fd_sc_hd__dfxtp_1
XFILLER_127_821 VPWR VGND VPWR VGND sky130_ef_sc_hd__decap_12
Xpicorv32_axi_1090 VGND VGND VPWR VPWR picorv32_axi_1090/HI trace_data[17] sky130_fd_sc_hd__conb_1
XFILLER_141_345 VGND VGND VPWR VPWR sky130_fd_sc_hd__decap_3
XFILLER_141_334 VGND VGND VPWR VPWR sky130_fd_sc_hd__fill_2
XFILLER_141_389 VGND VGND VPWR VPWR sky130_fd_sc_hd__decap_3
XTAP_TAPCELL_ROW_130_2187 VGND VPWR sky130_fd_sc_hd__tapvpwrvgnd_1
XFILLER_4_53 VPWR VGND VPWR VGND sky130_ef_sc_hd__decap_12
X_06840_ _03061_ _03063_ net663 VGND VGND VPWR VPWR _03064_ sky130_fd_sc_hd__mux2_1
XFILLER_4_97 VPWR VGND VPWR VGND sky130_ef_sc_hd__decap_12
XFILLER_110_754 VGND VGND VPWR VPWR sky130_fd_sc_hd__fill_2
XFILLER_95_454 VGND VGND VPWR VPWR sky130_fd_sc_hd__decap_8
X_06771_ picorv32_core.decoded_imm_j\[7\] _02919_ VGND VGND VPWR VPWR _03000_ sky130_fd_sc_hd__nand2_1
X_08510_ net1504 net210 net409 VGND VGND VPWR VPWR _00640_ sky130_fd_sc_hd__mux2_1
X_05722_ net769 _02159_ net191 VGND VGND VPWR VPWR _02206_ sky130_fd_sc_hd__or3b_1
X_09490_ net785 net547 VGND VGND VPWR VPWR _04675_ sky130_fd_sc_hd__or2_1
XTAP_TAPCELL_ROW_104_1809 VGND VPWR sky130_fd_sc_hd__tapvpwrvgnd_1
X_08441_ net676 picorv32_core.decoded_imm_j\[16\] net616 picorv32_core.mem_rdata_q\[16\]
+ VGND VGND VPWR VPWR _04301_ sky130_fd_sc_hd__a22o_1
XFILLER_51_513 VGND VGND VPWR VPWR sky130_fd_sc_hd__decap_4
X_05653_ _02135_ _02136_ VGND VGND VPWR VPWR _02137_ sky130_fd_sc_hd__and2_1
X_05584_ net919 net768 VGND VGND VPWR VPWR _02073_ sky130_fd_sc_hd__nand2_1
X_08372_ net189 net581 net451 _04237_ VGND VGND VPWR VPWR _04261_ sky130_fd_sc_hd__a211o_2
X_07323_ net817 picorv32_core.decoded_imm\[2\] VGND VGND VPWR VPWR _03463_ sky130_fd_sc_hd__or2_1
XTAP_TAPCELL_ROW_34_799 VGND VPWR sky130_fd_sc_hd__tapvpwrvgnd_1
XFILLER_109_309 VGND VGND VPWR VPWR sky130_fd_sc_hd__fill_1
XFILLER_31_281 VGND VGND VPWR VPWR sky130_fd_sc_hd__fill_1
X_07254_ _01635_ _03386_ _03393_ VGND VGND VPWR VPWR _03394_ sky130_fd_sc_hd__and3_2
XFILLER_136_139 VGND VGND VPWR VPWR sky130_fd_sc_hd__fill_1
X_06205_ picorv32_core.cpuregs\[20\]\[3\] picorv32_core.cpuregs\[21\]\[3\] picorv32_core.cpuregs\[22\]\[3\]
+ picorv32_core.cpuregs\[23\]\[3\] net742 net709 VGND VGND VPWR VPWR _02636_ sky130_fd_sc_hd__mux4_1
X_07185_ picorv32_core.count_cycle\[40\] picorv32_core.count_cycle\[41\] _03344_ VGND
+ VGND VPWR VPWR _03348_ sky130_fd_sc_hd__and3_1
X_06136_ _02167_ _02249_ net609 VGND VGND VPWR VPWR _02590_ sky130_fd_sc_hd__a21o_1
XFILLER_105_548 VGND VGND VPWR VPWR sky130_fd_sc_hd__decap_4
X_06067_ net507 _02522_ _02523_ _02526_ VGND VGND VPWR VPWR picorv32_core.alu_out\[24\]
+ sky130_fd_sc_hd__a31o_1
Xfanout412 _04226_ VGND VGND VPWR VPWR net412 sky130_fd_sc_hd__clkbuf_8
Xfanout401 _04328_ VGND VGND VPWR VPWR net401 sky130_fd_sc_hd__buf_4
XTAP_TAPCELL_ROW_74_1381 VGND VPWR sky130_fd_sc_hd__tapvpwrvgnd_1
Xfanout423 _02796_ VGND VGND VPWR VPWR net423 sky130_fd_sc_hd__buf_4
XFILLER_113_570 VGND VGND VPWR VPWR sky130_fd_sc_hd__fill_2
XFILLER_86_410 VGND VGND VPWR VPWR sky130_fd_sc_hd__decap_8
Xfanout456 _04235_ VGND VGND VPWR VPWR net456 sky130_fd_sc_hd__clkbuf_2
Xfanout434 _02667_ VGND VGND VPWR VPWR net434 sky130_fd_sc_hd__buf_4
Xfanout445 net446 VGND VGND VPWR VPWR net445 sky130_fd_sc_hd__clkbuf_2
X_09826_ net660 _04995_ VGND VGND VPWR VPWR _04996_ sky130_fd_sc_hd__or2_1
XFILLER_100_253 VGND VGND VPWR VPWR sky130_fd_sc_hd__fill_2
Xfanout489 net490 VGND VGND VPWR VPWR net489 sky130_fd_sc_hd__clkbuf_4
Xfanout478 _03574_ VGND VGND VPWR VPWR net478 sky130_fd_sc_hd__buf_4
Xfanout467 net468 VGND VGND VPWR VPWR net467 sky130_fd_sc_hd__clkbuf_2
X_09757_ picorv32_core.cpuregs\[4\]\[26\] picorv32_core.cpuregs\[5\]\[26\] picorv32_core.cpuregs\[6\]\[26\]
+ picorv32_core.cpuregs\[7\]\[26\] net901 net867 VGND VGND VPWR VPWR _04930_ sky130_fd_sc_hd__mux4_1
X_06969_ _03178_ _03181_ _03182_ VGND VGND VPWR VPWR _03183_ sky130_fd_sc_hd__a21o_1
XFILLER_39_370 VGND VGND VPWR VPWR sky130_fd_sc_hd__fill_1
X_08708_ net1731 net250 net384 VGND VGND VPWR VPWR _00857_ sky130_fd_sc_hd__mux2_1
XFILLER_64_25 VGND VGND VPWR VPWR sky130_fd_sc_hd__decap_3
X_09688_ net284 _04849_ _04864_ _04843_ VGND VGND VPWR VPWR _01341_ sky130_fd_sc_hd__a31o_1
XFILLER_27_576 VPWR VGND VPWR VGND sky130_ef_sc_hd__decap_12
X_08639_ net1442 net259 net392 VGND VGND VPWR VPWR _00790_ sky130_fd_sc_hd__mux2_1
X_11650_ clknet_leaf_60_clk _01481_ VGND VGND VPWR VPWR picorv32_core.cpuregs\[28\]\[31\]
+ sky130_fd_sc_hd__dfxtp_1
X_11581_ clknet_leaf_37_clk _01412_ VGND VGND VPWR VPWR picorv32_core.cpuregs\[2\]\[28\]
+ sky130_fd_sc_hd__dfxtp_1
XFILLER_23_793 VGND VGND VPWR VPWR sky130_fd_sc_hd__fill_1
X_10601_ clknet_leaf_107_clk _00455_ VGND VGND VPWR VPWR picorv32_core.latched_rd\[3\]
+ sky130_fd_sc_hd__dfxtp_1
X_10532_ clknet_leaf_53_clk picorv32_core.alu_out\[20\] VGND VGND VPWR VPWR picorv32_core.alu_out_q\[20\]
+ sky130_fd_sc_hd__dfxtp_1
XFILLER_10_432 VGND VGND VPWR VPWR sky130_fd_sc_hd__decap_4
XFILLER_10_421 VGND VGND VPWR VPWR sky130_fd_sc_hd__fill_2
XFILLER_13_51 VGND VGND VPWR VPWR sky130_fd_sc_hd__decap_4
XFILLER_129_51 VGND VGND VPWR VPWR sky130_fd_sc_hd__decap_4
X_10463_ clknet_leaf_73_clk _00350_ VGND VGND VPWR VPWR net55 sky130_fd_sc_hd__dfxtp_1
XFILLER_124_813 VPWR VGND VPWR VGND sky130_ef_sc_hd__decap_12
XFILLER_89_55 VGND VGND VPWR VPWR sky130_fd_sc_hd__fill_1
X_10394_ clknet_leaf_80_clk _00313_ VGND VGND VPWR VPWR picorv32_core.count_cycle\[52\]
+ sky130_fd_sc_hd__dfxtp_1
XFILLER_97_719 VGND VGND VPWR VPWR sky130_fd_sc_hd__decap_8
XFILLER_123_389 VGND VGND VPWR VPWR sky130_fd_sc_hd__decap_3
X_11015_ clknet_leaf_69_clk _00866_ VGND VGND VPWR VPWR picorv32_core.cpuregs\[12\]\[29\]
+ sky130_fd_sc_hd__dfxtp_1
XFILLER_2_697 VGND VGND VPWR VPWR sky130_fd_sc_hd__decap_3
XFILLER_77_443 VGND VGND VPWR VPWR sky130_fd_sc_hd__fill_1
Xfanout990 net38 VGND VGND VPWR VPWR net990 sky130_fd_sc_hd__clkbuf_2
XFILLER_45_373 VGND VGND VPWR VPWR sky130_fd_sc_hd__decap_3
X_11848_ net51 VGND VGND VPWR VPWR net83 sky130_fd_sc_hd__clkbuf_1
XFILLER_60_376 VPWR VGND VPWR VGND sky130_ef_sc_hd__decap_12
XFILLER_14_793 VPWR VGND VPWR VGND sky130_ef_sc_hd__decap_12
XTAP_TAPCELL_ROW_119_2027 VGND VPWR sky130_fd_sc_hd__tapvpwrvgnd_1
XFILLER_13_281 VGND VGND VPWR VPWR sky130_fd_sc_hd__decap_4
XTAP_TAPCELL_ROW_31_758 VGND VPWR sky130_fd_sc_hd__tapvpwrvgnd_1
XFILLER_118_117 VGND VGND VPWR VPWR sky130_fd_sc_hd__fill_2
XTAP_TAPCELL_ROW_132_2216 VGND VPWR sky130_fd_sc_hd__tapvpwrvgnd_1
Xclkload11 clknet_4_12_0_clk VGND VGND VPWR VPWR clkload11/Y sky130_fd_sc_hd__inv_8
Xclkload22 clknet_leaf_5_clk VGND VGND VPWR VPWR clkload22/Y sky130_fd_sc_hd__inv_8
XTAP_TAPCELL_ROW_11_471 VGND VPWR sky130_fd_sc_hd__tapvpwrvgnd_1
Xclkload33 clknet_leaf_135_clk VGND VGND VPWR VPWR clkload33/Y sky130_fd_sc_hd__clkinv_4
XTAP_TAPCELL_ROW_11_460 VGND VPWR sky130_fd_sc_hd__tapvpwrvgnd_1
Xclkload44 clknet_leaf_129_clk VGND VGND VPWR VPWR clkload44/Y sky130_fd_sc_hd__bufinv_16
Xclkload77 clknet_leaf_48_clk VGND VGND VPWR VPWR clkload77/Y sky130_fd_sc_hd__inv_8
Xclkload55 clknet_leaf_32_clk VGND VGND VPWR VPWR clkload55/X sky130_fd_sc_hd__clkbuf_4
Xclkload66 clknet_leaf_51_clk VGND VGND VPWR VPWR clkload66/Y sky130_fd_sc_hd__clkinv_2
Xclkload88 clknet_leaf_121_clk VGND VGND VPWR VPWR clkload88/Y sky130_fd_sc_hd__clkinvlp_4
Xclkload99 clknet_leaf_105_clk VGND VGND VPWR VPWR clkload99/Y sky130_fd_sc_hd__inv_6
XFILLER_141_153 VPWR VGND VPWR VGND sky130_ef_sc_hd__decap_12
XFILLER_130_805 VGND VGND VPWR VPWR sky130_fd_sc_hd__decap_6
XTAP_TAPCELL_ROW_114_1960 VGND VPWR sky130_fd_sc_hd__tapvpwrvgnd_1
X_08990_ net494 net1816 net345 VGND VGND VPWR VPWR _01160_ sky130_fd_sc_hd__mux2_1
XFILLER_141_197 VPWR VGND VPWR VGND sky130_ef_sc_hd__decap_12
X_07941_ _04012_ _04013_ net638 VGND VGND VPWR VPWR _04023_ sky130_fd_sc_hd__mux2_1
XFILLER_68_421 VGND VGND VPWR VPWR sky130_fd_sc_hd__fill_1
X_07872_ net183 net512 _03956_ _03957_ VGND VGND VPWR VPWR _00379_ sky130_fd_sc_hd__o22a_1
XFILLER_68_443 VGND VGND VPWR VPWR sky130_fd_sc_hd__fill_1
X_09611_ picorv32_core.cpuregs\[24\]\[19\] picorv32_core.cpuregs\[25\]\[19\] picorv32_core.cpuregs\[26\]\[19\]
+ picorv32_core.cpuregs\[27\]\[19\] net890 net857 VGND VGND VPWR VPWR _04791_ sky130_fd_sc_hd__mux4_1
X_06823_ _03046_ _03047_ VGND VGND VPWR VPWR _03048_ sky130_fd_sc_hd__nor2_1
XFILLER_18_29 VPWR VGND VPWR VGND sky130_ef_sc_hd__decap_12
X_09542_ picorv32_core.cpuregs\[4\]\[16\] picorv32_core.cpuregs\[5\]\[16\] picorv32_core.cpuregs\[6\]\[16\]
+ picorv32_core.cpuregs\[7\]\[16\] net891 net857 VGND VGND VPWR VPWR _04725_ sky130_fd_sc_hd__mux4_1
XTAP_TAPCELL_ROW_39_869 VGND VPWR sky130_fd_sc_hd__tapvpwrvgnd_1
X_06754_ _02980_ _02981_ _02982_ _02984_ VGND VGND VPWR VPWR _02985_ sky130_fd_sc_hd__a2bb2o_1
X_05705_ net795 net177 VGND VGND VPWR VPWR _02189_ sky130_fd_sc_hd__or2_1
XFILLER_64_660 VGND VGND VPWR VPWR sky130_fd_sc_hd__fill_2
X_06685_ _02745_ picorv32_core.reg_next_pc\[20\] net560 VGND VGND VPWR VPWR _02932_
+ sky130_fd_sc_hd__mux2_1
Xclkbuf_leaf_90_clk clknet_4_9_0_clk VGND VGND VPWR VPWR clknet_leaf_90_clk sky130_fd_sc_hd__clkbuf_8
XFILLER_64_682 VGND VGND VPWR VPWR sky130_fd_sc_hd__fill_1
X_09473_ picorv32_core.cpuregs\[8\]\[13\] picorv32_core.cpuregs\[9\]\[13\] picorv32_core.cpuregs\[10\]\[13\]
+ picorv32_core.cpuregs\[11\]\[13\] net882 net849 VGND VGND VPWR VPWR _04659_ sky130_fd_sc_hd__mux4_1
XTAP_TAPCELL_ROW_19_582 VGND VPWR sky130_fd_sc_hd__tapvpwrvgnd_1
X_05636_ net911 net302 _02116_ _02120_ VGND VGND VPWR VPWR _02121_ sky130_fd_sc_hd__a31o_1
X_08424_ picorv32_core.decoded_imm\[25\] net528 net442 _04292_ VGND VGND VPWR VPWR
+ _00585_ sky130_fd_sc_hd__o22a_1
X_05567_ _02043_ _02046_ _02055_ VGND VGND VPWR VPWR _02057_ sky130_fd_sc_hd__a21o_1
X_08355_ net1189 net454 _04252_ VGND VGND VPWR VPWR _00556_ sky130_fd_sc_hd__o21a_1
XFILLER_137_404 VGND VGND VPWR VPWR sky130_fd_sc_hd__decap_6
Xclkload5 clknet_4_6_0_clk VGND VGND VPWR VPWR clkload5/Y sky130_fd_sc_hd__clkinvlp_4
X_07306_ _03441_ _03444_ VGND VGND VPWR VPWR _03446_ sky130_fd_sc_hd__nand2_1
X_08286_ net1524 net233 net412 VGND VGND VPWR VPWR _00510_ sky130_fd_sc_hd__mux2_1
X_05498_ picorv32_core.reg_pc\[21\] picorv32_core.decoded_imm\[21\] VGND VGND VPWR
+ VPWR _01993_ sky130_fd_sc_hd__or2_1
X_07237_ net2276 _03379_ net995 VGND VGND VPWR VPWR _03381_ sky130_fd_sc_hd__o21ai_1
XFILLER_106_813 VGND VGND VPWR VPWR sky130_fd_sc_hd__fill_2
XTAP_TAPCELL_ROW_76_1410 VGND VPWR sky130_fd_sc_hd__tapvpwrvgnd_1
XFILLER_3_417 VGND VGND VPWR VPWR sky130_fd_sc_hd__decap_6
X_07168_ picorv32_core.count_cycle\[34\] _03334_ picorv32_core.count_cycle\[35\] VGND
+ VGND VPWR VPWR _03337_ sky130_fd_sc_hd__a21o_1
X_06119_ net765 net954 net608 _02573_ VGND VGND VPWR VPWR _02574_ sky130_fd_sc_hd__o22a_1
X_07099_ picorv32_core.count_cycle\[7\] picorv32_core.count_cycle\[8\] picorv32_core.count_cycle\[9\]
+ _03289_ VGND VGND VPWR VPWR _03294_ sky130_fd_sc_hd__and4_1
Xfanout231 _02770_ VGND VGND VPWR VPWR net231 sky130_fd_sc_hd__buf_1
Xfanout220 _02781_ VGND VGND VPWR VPWR net220 sky130_fd_sc_hd__buf_1
Xfanout242 net243 VGND VGND VPWR VPWR net242 sky130_fd_sc_hd__clkbuf_2
Xfanout253 net254 VGND VGND VPWR VPWR net253 sky130_fd_sc_hd__clkbuf_2
XFILLER_86_240 VGND VGND VPWR VPWR sky130_fd_sc_hd__fill_1
Xfanout264 net265 VGND VGND VPWR VPWR net264 sky130_fd_sc_hd__clkbuf_2
X_09809_ picorv32_core.cpuregs\[16\]\[28\] picorv32_core.cpuregs\[17\]\[28\] picorv32_core.cpuregs\[18\]\[28\]
+ picorv32_core.cpuregs\[19\]\[28\] net896 net862 VGND VGND VPWR VPWR _04980_ sky130_fd_sc_hd__mux4_1
XFILLER_87_796 VGND VGND VPWR VPWR sky130_fd_sc_hd__decap_6
Xfanout275 _02723_ VGND VGND VPWR VPWR net275 sky130_fd_sc_hd__buf_1
Xfanout286 net287 VGND VGND VPWR VPWR net286 sky130_fd_sc_hd__clkbuf_2
Xfanout297 _02706_ VGND VGND VPWR VPWR net297 sky130_fd_sc_hd__buf_1
XFILLER_75_57 VGND VGND VPWR VPWR sky130_fd_sc_hd__decap_4
XTAP_TAPCELL_ROW_87_1572 VGND VPWR sky130_fd_sc_hd__tapvpwrvgnd_1
XTAP_TAPCELL_ROW_87_1561 VGND VPWR sky130_fd_sc_hd__tapvpwrvgnd_1
XFILLER_15_502 VGND VGND VPWR VPWR sky130_fd_sc_hd__fill_2
X_11702_ clknet_leaf_31_clk _01533_ VGND VGND VPWR VPWR picorv32_core.cpuregs\[27\]\[19\]
+ sky130_fd_sc_hd__dfxtp_1
Xclkbuf_leaf_81_clk clknet_4_14_0_clk VGND VGND VPWR VPWR clknet_leaf_81_clk sky130_fd_sc_hd__clkbuf_8
XFILLER_70_641 VGND VGND VPWR VPWR sky130_fd_sc_hd__decap_3
X_11633_ clknet_leaf_9_clk _01464_ VGND VGND VPWR VPWR picorv32_core.cpuregs\[28\]\[14\]
+ sky130_fd_sc_hd__dfxtp_1
XFILLER_42_387 VGND VGND VPWR VPWR sky130_fd_sc_hd__fill_2
XFILLER_11_741 VPWR VGND VPWR VGND sky130_ef_sc_hd__decap_12
X_11564_ clknet_leaf_4_clk _01395_ VGND VGND VPWR VPWR picorv32_core.cpuregs\[2\]\[11\]
+ sky130_fd_sc_hd__dfxtp_1
XFILLER_11_785 VPWR VGND VPWR VGND sky130_ef_sc_hd__decap_12
X_11495_ clknet_leaf_126_clk _01331_ VGND VGND VPWR VPWR net144 sky130_fd_sc_hd__dfxtp_1
X_10515_ clknet_leaf_132_clk picorv32_core.alu_out\[3\] VGND VGND VPWR VPWR picorv32_core.alu_out_q\[3\]
+ sky130_fd_sc_hd__dfxtp_1
XFILLER_109_673 VGND VGND VPWR VPWR sky130_fd_sc_hd__fill_2
X_10446_ clknet_leaf_117_clk _00333_ VGND VGND VPWR VPWR net68 sky130_fd_sc_hd__dfxtp_1
XFILLER_112_805 VGND VGND VPWR VPWR sky130_fd_sc_hd__decap_6
X_10377_ clknet_leaf_104_clk _00296_ VGND VGND VPWR VPWR picorv32_core.count_cycle\[35\]
+ sky130_fd_sc_hd__dfxtp_1
XFILLER_124_698 VGND VGND VPWR VPWR sky130_fd_sc_hd__fill_2
XFILLER_111_337 VGND VGND VPWR VPWR sky130_fd_sc_hd__fill_1
XFILLER_2_472 VGND VGND VPWR VPWR sky130_fd_sc_hd__fill_1
XFILLER_78_752 VGND VGND VPWR VPWR sky130_fd_sc_hd__fill_1
XFILLER_93_711 VGND VGND VPWR VPWR sky130_fd_sc_hd__fill_1
XFILLER_1_21 VPWR VGND VPWR VGND sky130_ef_sc_hd__decap_12
XFILLER_33_310 VGND VGND VPWR VPWR sky130_fd_sc_hd__decap_3
XTAP_TAPCELL_ROW_36_828 VGND VPWR sky130_fd_sc_hd__tapvpwrvgnd_1
Xclkbuf_leaf_72_clk clknet_4_15_0_clk VGND VGND VPWR VPWR clknet_leaf_72_clk sky130_fd_sc_hd__clkbuf_8
XFILLER_61_663 VGND VGND VPWR VPWR sky130_fd_sc_hd__fill_1
XTAP_TAPCELL_ROW_16_530 VGND VPWR sky130_fd_sc_hd__tapvpwrvgnd_1
XTAP_TAPCELL_ROW_16_541 VGND VPWR sky130_fd_sc_hd__tapvpwrvgnd_1
X_06470_ net2328 net588 _02799_ VGND VGND VPWR VPWR _00135_ sky130_fd_sc_hd__o21a_1
X_05421_ net575 _01920_ VGND VGND VPWR VPWR _01922_ sky130_fd_sc_hd__or2_1
XFILLER_61_685 VGND VGND VPWR VPWR sky130_fd_sc_hd__decap_8
XFILLER_21_538 VGND VGND VPWR VPWR sky130_fd_sc_hd__fill_1
X_08140_ picorv32_core.mem_rdata_q\[2\] net26 net521 VGND VGND VPWR VPWR _00743_ sky130_fd_sc_hd__mux2_1
X_05352_ _01856_ _01857_ VGND VGND VPWR VPWR _01858_ sky130_fd_sc_hd__xnor2_1
Xclkload122 clknet_leaf_63_clk VGND VGND VPWR VPWR clkload122/Y sky130_fd_sc_hd__clkinv_4
X_08071_ picorv32_core.cpuregs\[20\]\[31\] picorv32_core.cpuregs\[21\]\[31\] picorv32_core.cpuregs\[22\]\[31\]
+ picorv32_core.cpuregs\[23\]\[31\] net761 net728 VGND VGND VPWR VPWR _04145_ sky130_fd_sc_hd__mux4_1
Xclkload100 clknet_leaf_106_clk VGND VGND VPWR VPWR clkload100/Y sky130_fd_sc_hd__bufinv_16
X_05283_ _01790_ _01792_ VGND VGND VPWR VPWR _01793_ sky130_fd_sc_hd__or2_1
Xclkload111 clknet_leaf_103_clk VGND VGND VPWR VPWR clkload111/Y sky130_fd_sc_hd__inv_6
X_07022_ net932 _02939_ VGND VGND VPWR VPWR _03231_ sky130_fd_sc_hd__nand2_1
Xclkload133 clknet_leaf_84_clk VGND VGND VPWR VPWR clkload133/Y sky130_fd_sc_hd__clkinv_2
XFILLER_115_621 VGND VGND VPWR VPWR sky130_fd_sc_hd__fill_1
XTAP_TAPCELL_ROW_58_1151 VGND VPWR sky130_fd_sc_hd__tapvpwrvgnd_1
XTAP_TAPCELL_ROW_58_1140 VGND VPWR sky130_fd_sc_hd__tapvpwrvgnd_1
XFILLER_88_516 VGND VGND VPWR VPWR sky130_fd_sc_hd__decap_8
X_08973_ net1399 net248 net350 VGND VGND VPWR VPWR _01145_ sky130_fd_sc_hd__mux2_1
XFILLER_114_175 VGND VGND VPWR VPWR sky130_fd_sc_hd__decap_8
XFILLER_102_304 VGND VGND VPWR VPWR sky130_fd_sc_hd__decap_4
Xhold28 picorv32_core.cpuregs\[0\]\[31\] VGND VGND VPWR VPWR net1137 sky130_fd_sc_hd__dlygate4sd3_1
X_07924_ _03994_ _03995_ net695 VGND VGND VPWR VPWR _04007_ sky130_fd_sc_hd__mux2_1
XTAP_TAPCELL_ROW_71_1340 VGND VPWR sky130_fd_sc_hd__tapvpwrvgnd_1
Xhold17 picorv32_core.cpuregs\[0\]\[2\] VGND VGND VPWR VPWR net1126 sky130_fd_sc_hd__dlygate4sd3_1
Xhold39 picorv32_core.cpuregs\[0\]\[18\] VGND VGND VPWR VPWR net1148 sky130_fd_sc_hd__dlygate4sd3_1
XFILLER_84_711 VPWR VGND VPWR VGND sky130_ef_sc_hd__decap_12
X_07855_ picorv32_core.cpuregs\[16\]\[19\] picorv32_core.cpuregs\[17\]\[19\] picorv32_core.cpuregs\[18\]\[19\]
+ picorv32_core.cpuregs\[19\]\[19\] net748 net715 VGND VGND VPWR VPWR _03941_ sky130_fd_sc_hd__mux4_1
XFILLER_83_254 VGND VGND VPWR VPWR sky130_fd_sc_hd__fill_1
X_07786_ picorv32_core.cpuregs\[4\]\[15\] picorv32_core.cpuregs\[5\]\[15\] picorv32_core.cpuregs\[6\]\[15\]
+ picorv32_core.cpuregs\[7\]\[15\] net751 net718 VGND VGND VPWR VPWR _03876_ sky130_fd_sc_hd__mux4_1
X_06806_ net665 picorv32_core.reg_next_pc\[9\] _02921_ net491 VGND VGND VPWR VPWR
+ _03033_ sky130_fd_sc_hd__a22o_1
XFILLER_45_27 VGND VGND VPWR VPWR sky130_fd_sc_hd__decap_4
X_09525_ _04700_ _04701_ _04704_ _04705_ net659 net828 VGND VGND VPWR VPWR _04709_
+ sky130_fd_sc_hd__mux4_1
XFILLER_71_449 VGND VGND VPWR VPWR sky130_fd_sc_hd__fill_2
XFILLER_37_671 VGND VGND VPWR VPWR sky130_fd_sc_hd__fill_1
X_06737_ _02914_ _02915_ _02916_ VGND VGND VPWR VPWR _02969_ sky130_fd_sc_hd__and3_1
Xclkbuf_leaf_63_clk clknet_4_13_0_clk VGND VGND VPWR VPWR clknet_leaf_63_clk sky130_fd_sc_hd__clkbuf_8
X_06668_ picorv32_core.reg_pc\[11\] net552 _02923_ net515 VGND VGND VPWR VPWR _00209_
+ sky130_fd_sc_hd__a22o_1
X_09456_ picorv32_core.cpuregs\[0\]\[12\] picorv32_core.cpuregs\[1\]\[12\] picorv32_core.cpuregs\[2\]\[12\]
+ picorv32_core.cpuregs\[3\]\[12\] net879 net846 VGND VGND VPWR VPWR _04643_ sky130_fd_sc_hd__mux4_1
XFILLER_24_354 VGND VGND VPWR VPWR sky130_fd_sc_hd__fill_1
X_05619_ _02092_ _02104_ _02103_ _02102_ VGND VGND VPWR VPWR _02105_ sky130_fd_sc_hd__o211a_1
XFILLER_51_151 VGND VGND VPWR VPWR sky130_fd_sc_hd__fill_1
X_08407_ net931 picorv32_core.is_sb_sh_sw VGND VGND VPWR VPWR _04282_ sky130_fd_sc_hd__or2_1
XTAP_TAPCELL_ROW_82_1491 VGND VPWR sky130_fd_sc_hd__tapvpwrvgnd_1
X_06599_ picorv32_core.count_instr\[48\] _02879_ VGND VGND VPWR VPWR _02881_ sky130_fd_sc_hd__and2_1
X_09387_ net652 _04576_ VGND VGND VPWR VPWR _04577_ sky130_fd_sc_hd__or2_1
XFILLER_138_713 VPWR VGND VPWR VGND sky130_ef_sc_hd__decap_12
X_08338_ net928 picorv32_core.mem_la_wdata\[2\] net958 net927 VGND VGND VPWR VPWR
+ _04241_ sky130_fd_sc_hd__a22o_1
XFILLER_138_757 VPWR VGND VPWR VGND sky130_ef_sc_hd__decap_12
XFILLER_20_571 VGND VGND VPWR VPWR sky130_fd_sc_hd__fill_2
X_08269_ net1286 net430 net410 VGND VGND VPWR VPWR _00493_ sky130_fd_sc_hd__mux2_1
X_10300_ clknet_leaf_87_clk _00219_ VGND VGND VPWR VPWR picorv32_core.reg_pc\[21\]
+ sky130_fd_sc_hd__dfxtp_1
X_11280_ clknet_leaf_117_clk _01128_ VGND VGND VPWR VPWR picorv32_core.cpuregs\[3\]\[3\]
+ sky130_fd_sc_hd__dfxtp_1
X_10231_ clknet_leaf_81_clk _00150_ VGND VGND VPWR VPWR picorv32_core.count_instr\[15\]
+ sky130_fd_sc_hd__dfxtp_1
XFILLER_4_737 VPWR VGND VPWR VGND sky130_ef_sc_hd__decap_12
XFILLER_3_225 VPWR VGND VPWR VGND sky130_ef_sc_hd__decap_12
XFILLER_106_676 VGND VGND VPWR VPWR sky130_fd_sc_hd__fill_1
XFILLER_79_505 VGND VGND VPWR VPWR sky130_fd_sc_hd__fill_1
XFILLER_10_41 VPWR VGND VPWR VGND sky130_ef_sc_hd__decap_12
XFILLER_126_41 VPWR VGND VPWR VGND sky130_ef_sc_hd__decap_12
XFILLER_105_186 VGND VGND VPWR VPWR sky130_fd_sc_hd__fill_1
XFILLER_10_85 VGND VGND VPWR VPWR sky130_fd_sc_hd__decap_8
X_10162_ clknet_leaf_3_clk _00081_ VGND VGND VPWR VPWR picorv32_core.cpuregs\[21\]\[10\]
+ sky130_fd_sc_hd__dfxtp_1
XFILLER_126_85 VGND VGND VPWR VPWR sky130_fd_sc_hd__decap_3
X_10093_ net1142 VGND VGND VPWR VPWR _00943_ sky130_fd_sc_hd__clkbuf_1
XFILLER_120_167 VGND VGND VPWR VPWR sky130_fd_sc_hd__fill_1
XTAP_TAPCELL_ROW_89_1601 VGND VPWR sky130_fd_sc_hd__tapvpwrvgnd_1
XFILLER_86_89 VGND VGND VPWR VPWR sky130_fd_sc_hd__fill_1
XFILLER_101_370 VPWR VGND VPWR VGND sky130_ef_sc_hd__decap_12
XPHY_EDGE_ROW_137_Left_279 VGND VGND VPWR VPWR sky130_fd_sc_hd__decap_3
XFILLER_75_777 VGND VGND VPWR VPWR sky130_fd_sc_hd__fill_1
XFILLER_16_811 VGND VGND VPWR VPWR sky130_fd_sc_hd__fill_1
Xclkbuf_leaf_54_clk clknet_4_6_0_clk VGND VGND VPWR VPWR clknet_leaf_54_clk sky130_fd_sc_hd__clkbuf_8
X_10995_ clknet_leaf_140_clk _00846_ VGND VGND VPWR VPWR picorv32_core.cpuregs\[12\]\[9\]
+ sky130_fd_sc_hd__dfxtp_1
XTAP_TAPCELL_ROW_13_500 VGND VPWR sky130_fd_sc_hd__tapvpwrvgnd_1
X_11616_ clknet_leaf_67_clk _01447_ VGND VGND VPWR VPWR picorv32_core.cpuregs\[23\]\[29\]
+ sky130_fd_sc_hd__dfxtp_1
X_11547_ clknet_leaf_38_clk _01378_ VGND VGND VPWR VPWR picorv32_core.cpuregs\[30\]\[28\]
+ sky130_fd_sc_hd__dfxtp_1
XTAP_TAPCELL_ROW_41_897 VGND VPWR sky130_fd_sc_hd__tapvpwrvgnd_1
Xhold509 picorv32_core.cpuregs\[1\]\[14\] VGND VGND VPWR VPWR net1618 sky130_fd_sc_hd__dlygate4sd3_1
X_11478_ clknet_leaf_75_clk _01314_ VGND VGND VPWR VPWR picorv32_core.cpuregs\[24\]\[29\]
+ sky130_fd_sc_hd__dfxtp_1
X_10429_ clknet_leaf_58_clk _01561_ VGND VGND VPWR VPWR picorv32_core.reg_out\[22\]
+ sky130_fd_sc_hd__dfxtp_1
XFILLER_97_335 VGND VGND VPWR VPWR sky130_fd_sc_hd__fill_1
X_05970_ net956 _02429_ net671 VGND VGND VPWR VPWR _02437_ sky130_fd_sc_hd__o21a_1
XFILLER_97_379 VPWR VGND VPWR VGND sky130_ef_sc_hd__decap_12
Xhold1209 picorv32_core.decoded_imm_j\[8\] VGND VGND VPWR VPWR net2318 sky130_fd_sc_hd__dlygate4sd3_1
XTAP_TAPCELL_ROW_53_1070 VGND VPWR sky130_fd_sc_hd__tapvpwrvgnd_1
XFILLER_25_3 VPWR VGND VPWR VGND sky130_ef_sc_hd__decap_12
XTAP_TAPCELL_ROW_127_2148 VGND VPWR sky130_fd_sc_hd__tapvpwrvgnd_1
X_07640_ net693 _03737_ VGND VGND VPWR VPWR _03738_ sky130_fd_sc_hd__or2_1
XTAP_TAPCELL_ROW_140_2337 VGND VPWR sky130_fd_sc_hd__tapvpwrvgnd_1
XTAP_TAPCELL_ROW_109_1892 VGND VPWR sky130_fd_sc_hd__tapvpwrvgnd_1
XTAP_TAPCELL_ROW_109_1881 VGND VPWR sky130_fd_sc_hd__tapvpwrvgnd_1
XFILLER_93_585 VGND VGND VPWR VPWR sky130_fd_sc_hd__fill_1
X_07571_ _03673_ _03674_ net633 VGND VGND VPWR VPWR _03675_ sky130_fd_sc_hd__mux2_1
XFILLER_25_107 VGND VGND VPWR VPWR sky130_fd_sc_hd__decap_4
Xclkbuf_leaf_45_clk clknet_4_7_0_clk VGND VGND VPWR VPWR clknet_leaf_45_clk sky130_fd_sc_hd__clkbuf_8
X_06522_ _02831_ _02832_ VGND VGND VPWR VPWR _00154_ sky130_fd_sc_hd__nor2_1
XFILLER_80_257 VGND VGND VPWR VPWR sky130_fd_sc_hd__fill_1
XFILLER_34_641 VGND VGND VPWR VPWR sky130_fd_sc_hd__decap_3
X_09310_ net812 net540 VGND VGND VPWR VPWR _04503_ sky130_fd_sc_hd__or2_1
X_06453_ net264 net1869 net419 VGND VGND VPWR VPWR _00119_ sky130_fd_sc_hd__mux2_1
X_09241_ picorv32_core.cpuregs\[4\]\[3\] picorv32_core.cpuregs\[5\]\[3\] picorv32_core.cpuregs\[6\]\[3\]
+ picorv32_core.cpuregs\[7\]\[3\] net885 net852 VGND VGND VPWR VPWR _04437_ sky130_fd_sc_hd__mux4_1
XFILLER_33_173 VGND VGND VPWR VPWR sky130_fd_sc_hd__fill_1
X_06384_ net1586 net217 net435 VGND VGND VPWR VPWR _00067_ sky130_fd_sc_hd__mux2_1
X_05404_ picorv32_core.count_instr\[46\] net938 net942 picorv32_core.count_instr\[14\]
+ VGND VGND VPWR VPWR _01906_ sky130_fd_sc_hd__a22o_1
X_09172_ net819 net814 _01689_ VGND VGND VPWR VPWR _04371_ sky130_fd_sc_hd__mux2_1
XTAP_TAPCELL_ROW_138_2299 VGND VPWR sky130_fd_sc_hd__tapvpwrvgnd_1
X_08123_ net255 net1823 net416 VGND VGND VPWR VPWR _00416_ sky130_fd_sc_hd__mux2_1
X_05335_ _01822_ _01840_ _01841_ _01817_ VGND VGND VPWR VPWR _01842_ sky130_fd_sc_hd__a31o_1
X_08054_ net697 _04128_ VGND VGND VPWR VPWR _04129_ sky130_fd_sc_hd__or2_1
X_07005_ _03211_ _03214_ VGND VGND VPWR VPWR _03216_ sky130_fd_sc_hd__or2_1
X_05266_ _01766_ _01768_ _01765_ VGND VGND VPWR VPWR _01777_ sky130_fd_sc_hd__a21o_1
XFILLER_134_248 VGND VGND VPWR VPWR sky130_fd_sc_hd__decap_4
X_05197_ axi_adapter.ack_awvalid _01713_ VGND VGND VPWR VPWR net101 sky130_fd_sc_hd__nor2_1
XFILLER_1_729 VPWR VGND VPWR VGND sky130_ef_sc_hd__decap_12
X_08956_ net1275 net492 net349 VGND VGND VPWR VPWR _01128_ sky130_fd_sc_hd__mux2_1
X_07907_ net684 _03990_ net626 VGND VGND VPWR VPWR _03991_ sky130_fd_sc_hd__a21o_1
X_08887_ net505 net1341 net359 VGND VGND VPWR VPWR _01061_ sky130_fd_sc_hd__mux2_1
XFILLER_29_446 VGND VGND VPWR VPWR sky130_fd_sc_hd__fill_2
X_07838_ picorv32_core.cpuregs\[28\]\[18\] picorv32_core.cpuregs\[29\]\[18\] picorv32_core.cpuregs\[30\]\[18\]
+ picorv32_core.cpuregs\[31\]\[18\] net750 net717 VGND VGND VPWR VPWR _03925_ sky130_fd_sc_hd__mux4_1
XFILLER_44_405 VGND VGND VPWR VPWR sky130_fd_sc_hd__fill_1
XTAP_TAPCELL_ROW_84_1520 VGND VPWR sky130_fd_sc_hd__tapvpwrvgnd_1
Xclkbuf_leaf_36_clk clknet_4_5_0_clk VGND VGND VPWR VPWR clknet_leaf_36_clk sky130_fd_sc_hd__clkbuf_8
X_09508_ net791 net280 VGND VGND VPWR VPWR _04692_ sky130_fd_sc_hd__and2_1
XFILLER_71_246 VGND VGND VPWR VPWR sky130_fd_sc_hd__fill_1
X_07769_ picorv32_core.cpuregs\[0\]\[14\] picorv32_core.cpuregs\[1\]\[14\] picorv32_core.cpuregs\[2\]\[14\]
+ picorv32_core.cpuregs\[3\]\[14\] net737 net704 VGND VGND VPWR VPWR _03860_ sky130_fd_sc_hd__mux4_1
X_10780_ clknet_leaf_50_clk _00631_ VGND VGND VPWR VPWR picorv32_core.cpuregs\[14\]\[21\]
+ sky130_fd_sc_hd__dfxtp_1
XFILLER_80_780 VGND VGND VPWR VPWR sky130_fd_sc_hd__decap_4
XFILLER_40_600 VGND VGND VPWR VPWR sky130_fd_sc_hd__decap_8
X_09439_ net836 _04617_ net643 VGND VGND VPWR VPWR _04627_ sky130_fd_sc_hd__o21a_1
XFILLER_40_666 VPWR VGND VPWR VGND sky130_ef_sc_hd__decap_12
X_11401_ clknet_leaf_20_clk _01237_ VGND VGND VPWR VPWR picorv32_core.cpuregs\[31\]\[16\]
+ sky130_fd_sc_hd__dfxtp_1
XANTENNA_80 net20 VGND VGND VPWR VPWR sky130_fd_sc_hd__diode_2
XANTENNA_91 net758 VGND VGND VPWR VPWR sky130_fd_sc_hd__diode_2
XFILLER_126_749 VGND VGND VPWR VPWR sky130_fd_sc_hd__decap_6
X_11332_ clknet_leaf_18_clk _01173_ VGND VGND VPWR VPWR picorv32_core.cpuregs\[29\]\[16\]
+ sky130_fd_sc_hd__dfxtp_1
XFILLER_21_51 VGND VGND VPWR VPWR sky130_fd_sc_hd__decap_4
XFILLER_137_51 VGND VGND VPWR VPWR sky130_fd_sc_hd__decap_4
XTAP_TAPCELL_ROW_95_1682 VGND VPWR sky130_fd_sc_hd__tapvpwrvgnd_1
X_11263_ clknet_leaf_51_clk _01111_ VGND VGND VPWR VPWR picorv32_core.cpuregs\[4\]\[18\]
+ sky130_fd_sc_hd__dfxtp_1
XFILLER_134_793 VPWR VGND VPWR VGND sky130_ef_sc_hd__decap_12
X_10214_ clknet_leaf_65_clk _00133_ VGND VGND VPWR VPWR picorv32_core.cpuregs\[9\]\[30\]
+ sky130_fd_sc_hd__dfxtp_1
X_11194_ clknet_leaf_22_clk _01045_ VGND VGND VPWR VPWR picorv32_core.cpuregs\[6\]\[16\]
+ sky130_fd_sc_hd__dfxtp_1
X_10145_ clknet_leaf_36_clk _00067_ VGND VGND VPWR VPWR picorv32_core.cpuregs\[22\]\[28\]
+ sky130_fd_sc_hd__dfxtp_1
XFILLER_79_379 VPWR VGND VPWR VGND sky130_ef_sc_hd__decap_12
X_10076_ net2349 _00757_ net439 VGND VGND VPWR VPWR _00524_ sky130_fd_sc_hd__mux2_1
XFILLER_48_733 VGND VGND VPWR VPWR sky130_fd_sc_hd__decap_4
XTAP_TAPCELL_ROW_122_2067 VGND VPWR sky130_fd_sc_hd__tapvpwrvgnd_1
Xclkbuf_leaf_27_clk clknet_4_4_0_clk VGND VGND VPWR VPWR clknet_leaf_27_clk sky130_fd_sc_hd__clkbuf_8
XFILLER_16_641 VGND VGND VPWR VPWR sky130_fd_sc_hd__decap_3
XTAP_TAPCELL_ROW_46_967 VGND VPWR sky130_fd_sc_hd__tapvpwrvgnd_1
XTAP_TAPCELL_ROW_122_2078 VGND VPWR sky130_fd_sc_hd__tapvpwrvgnd_1
X_10978_ clknet_leaf_33_clk _00829_ VGND VGND VPWR VPWR picorv32_core.cpuregs\[13\]\[24\]
+ sky130_fd_sc_hd__dfxtp_1
XFILLER_50_419 VGND VGND VPWR VPWR sky130_fd_sc_hd__fill_1
XTAP_TAPCELL_ROW_46_978 VGND VPWR sky130_fd_sc_hd__tapvpwrvgnd_1
XTAP_TAPCELL_ROW_26_680 VGND VPWR sky130_fd_sc_hd__tapvpwrvgnd_1
XFILLER_31_633 VPWR VGND VPWR VGND sky130_ef_sc_hd__decap_12
XFILLER_62_80 VGND VGND VPWR VPWR sky130_fd_sc_hd__decap_4
X_05120_ net937 net941 net945 VGND VGND VPWR VPWR _01651_ sky130_fd_sc_hd__nor3_1
XFILLER_7_42 VPWR VGND VPWR VGND sky130_ef_sc_hd__decap_12
XFILLER_116_215 VGND VGND VPWR VPWR sky130_fd_sc_hd__fill_2
Xhold317 picorv32_core.instr_slli VGND VGND VPWR VPWR net1426 sky130_fd_sc_hd__dlygate4sd3_1
Xhold306 picorv32_core.cpuregs\[3\]\[8\] VGND VGND VPWR VPWR net1415 sky130_fd_sc_hd__dlygate4sd3_1
Xhold339 picorv32_core.cpuregs\[11\]\[19\] VGND VGND VPWR VPWR net1448 sky130_fd_sc_hd__dlygate4sd3_1
X_05051_ net2209 VGND VGND VPWR VPWR _01586_ sky130_fd_sc_hd__inv_2
Xhold328 picorv32_core.cpuregs\[26\]\[11\] VGND VGND VPWR VPWR net1437 sky130_fd_sc_hd__dlygate4sd3_1
X_08810_ net236 net2060 net372 VGND VGND VPWR VPWR _00988_ sky130_fd_sc_hd__mux2_1
XFILLER_124_281 VGND VGND VPWR VPWR sky130_fd_sc_hd__decap_3
Xfanout819 net152 VGND VGND VPWR VPWR net819 sky130_fd_sc_hd__buf_2
Xfanout808 net170 VGND VGND VPWR VPWR net808 sky130_fd_sc_hd__dlymetal6s2s_1
X_09790_ _04958_ _04959_ net658 VGND VGND VPWR VPWR _04962_ sky130_fd_sc_hd__mux2_1
XFILLER_97_165 VGND VGND VPWR VPWR sky130_fd_sc_hd__decap_3
Xhold1006 picorv32_core.cpuregs\[21\]\[19\] VGND VGND VPWR VPWR net2115 sky130_fd_sc_hd__dlygate4sd3_1
XFILLER_58_519 VGND VGND VPWR VPWR sky130_fd_sc_hd__fill_2
Xhold1028 picorv32_core.cpuregs\[8\]\[22\] VGND VGND VPWR VPWR net2137 sky130_fd_sc_hd__dlygate4sd3_1
X_08741_ net1884 net247 net380 VGND VGND VPWR VPWR _00889_ sky130_fd_sc_hd__mux2_1
Xhold1039 picorv32_core.cpuregs\[16\]\[18\] VGND VGND VPWR VPWR net2148 sky130_fd_sc_hd__dlygate4sd3_1
X_05953_ net789 net956 net569 _02420_ VGND VGND VPWR VPWR _02421_ sky130_fd_sc_hd__a31o_1
Xhold1017 picorv32_core.cpuregs\[2\]\[12\] VGND VGND VPWR VPWR net2126 sky130_fd_sc_hd__dlygate4sd3_1
X_08672_ net261 net1786 net388 VGND VGND VPWR VPWR _00822_ sky130_fd_sc_hd__mux2_1
X_05884_ _02356_ _02357_ VGND VGND VPWR VPWR _02358_ sky130_fd_sc_hd__nand2b_1
X_07623_ net627 _03721_ VGND VGND VPWR VPWR _03722_ sky130_fd_sc_hd__or2_1
XFILLER_26_29 VGND VGND VPWR VPWR sky130_fd_sc_hd__decap_8
Xclkbuf_leaf_18_clk clknet_4_6_0_clk VGND VGND VPWR VPWR clknet_leaf_18_clk sky130_fd_sc_hd__clkbuf_8
XPHY_EDGE_ROW_5_Right_5 VGND VGND VPWR VPWR sky130_fd_sc_hd__decap_3
XFILLER_81_599 VGND VGND VPWR VPWR sky130_fd_sc_hd__fill_1
XTAP_TAPCELL_ROW_66_1261 VGND VPWR sky130_fd_sc_hd__tapvpwrvgnd_1
XFILLER_53_279 VGND VGND VPWR VPWR sky130_fd_sc_hd__fill_1
X_07554_ picorv32_core.cpuregs\[8\]\[0\] picorv32_core.cpuregs\[9\]\[0\] picorv32_core.cpuregs\[10\]\[0\]
+ picorv32_core.cpuregs\[11\]\[0\] net734 net701 VGND VGND VPWR VPWR _03659_ sky130_fd_sc_hd__mux4_1
XFILLER_41_419 VGND VGND VPWR VPWR sky130_fd_sc_hd__decap_4
X_07485_ picorv32_core.reg_out\[15\] picorv32_core.reg_next_pc\[15\] net558 VGND VGND
+ VPWR VPWR _03611_ sky130_fd_sc_hd__mux2_1
X_06505_ _02820_ _02821_ VGND VGND VPWR VPWR _00148_ sky130_fd_sc_hd__nor2_1
X_06436_ _02795_ _02797_ VGND VGND VPWR VPWR _02798_ sky130_fd_sc_hd__or2_1
X_09224_ net819 net541 VGND VGND VPWR VPWR _04421_ sky130_fd_sc_hd__or2_1
XFILLER_22_688 VGND VGND VPWR VPWR sky130_fd_sc_hd__fill_2
XFILLER_22_699 VGND VGND VPWR VPWR sky130_fd_sc_hd__fill_1
X_06367_ picorv32_core.reg_pc\[25\] _02763_ VGND VGND VPWR VPWR _02768_ sky130_fd_sc_hd__and2_1
X_09155_ _04352_ _04353_ net837 VGND VGND VPWR VPWR _04354_ sky130_fd_sc_hd__mux2_1
XFILLER_107_237 VGND VGND VPWR VPWR sky130_fd_sc_hd__decap_3
X_05318_ picorv32_core.count_instr\[40\] net935 net939 picorv32_core.count_instr\[8\]
+ VGND VGND VPWR VPWR _01826_ sky130_fd_sc_hd__a22o_1
X_08106_ net500 net2223 net415 VGND VGND VPWR VPWR _00399_ sky130_fd_sc_hd__mux2_1
X_09086_ net504 net1807 net333 VGND VGND VPWR VPWR _01253_ sky130_fd_sc_hd__mux2_1
X_06298_ net1934 net291 net434 VGND VGND VPWR VPWR _00050_ sky130_fd_sc_hd__mux2_1
X_08037_ picorv32_core.cpuregs\[24\]\[29\] picorv32_core.cpuregs\[25\]\[29\] picorv32_core.cpuregs\[26\]\[29\]
+ picorv32_core.cpuregs\[27\]\[29\] net762 net729 VGND VGND VPWR VPWR _04113_ sky130_fd_sc_hd__mux4_1
X_05249_ picorv32_core.count_cycle\[3\] net599 net576 _01761_ VGND VGND VPWR VPWR
+ _01762_ sky130_fd_sc_hd__o211a_1
Xhold873 picorv32_core.cpuregs\[28\]\[26\] VGND VGND VPWR VPWR net1982 sky130_fd_sc_hd__dlygate4sd3_1
XFILLER_116_793 VPWR VGND VPWR VGND sky130_ef_sc_hd__decap_12
Xhold840 picorv32_core.cpuregs\[9\]\[19\] VGND VGND VPWR VPWR net1949 sky130_fd_sc_hd__dlygate4sd3_1
Xhold862 picorv32_core.cpuregs\[10\]\[10\] VGND VGND VPWR VPWR net1971 sky130_fd_sc_hd__dlygate4sd3_1
Xhold851 picorv32_core.cpuregs\[18\]\[8\] VGND VGND VPWR VPWR net1960 sky130_fd_sc_hd__dlygate4sd3_1
XFILLER_131_741 VPWR VGND VPWR VGND sky130_ef_sc_hd__decap_12
Xhold895 picorv32_core.cpuregs\[4\]\[14\] VGND VGND VPWR VPWR net2004 sky130_fd_sc_hd__dlygate4sd3_1
XFILLER_1_559 VGND VGND VPWR VPWR sky130_fd_sc_hd__fill_1
Xhold884 picorv32_core.cpuregs\[16\]\[6\] VGND VGND VPWR VPWR net1993 sky130_fd_sc_hd__dlygate4sd3_1
XFILLER_131_785 VPWR VGND VPWR VGND sky130_ef_sc_hd__decap_12
X_09988_ net1601 net270 net313 VGND VGND VPWR VPWR _01465_ sky130_fd_sc_hd__mux2_1
X_08939_ net251 net1957 net355 VGND VGND VPWR VPWR _01112_ sky130_fd_sc_hd__mux2_1
XTAP_TAPCELL_ROW_4_364 VGND VPWR sky130_fd_sc_hd__tapvpwrvgnd_1
XFILLER_17_405 VGND VGND VPWR VPWR sky130_fd_sc_hd__fill_1
X_10901_ clknet_leaf_105_clk _00752_ VGND VGND VPWR VPWR picorv32_core.mem_rdata_q\[11\]
+ sky130_fd_sc_hd__dfxtp_1
XFILLER_83_57 VGND VGND VPWR VPWR sky130_fd_sc_hd__decap_4
XFILLER_72_533 VGND VGND VPWR VPWR sky130_fd_sc_hd__decap_6
XFILLER_17_449 VGND VGND VPWR VPWR sky130_fd_sc_hd__fill_1
XFILLER_29_298 VGND VGND VPWR VPWR sky130_fd_sc_hd__fill_1
X_10832_ clknet_leaf_0_clk _00683_ VGND VGND VPWR VPWR picorv32_core.cpuregs\[17\]\[9\]
+ sky130_fd_sc_hd__dfxtp_1
XTAP_TAPCELL_ROW_43_926 VGND VPWR sky130_fd_sc_hd__tapvpwrvgnd_1
X_10763_ clknet_leaf_115_clk _00614_ VGND VGND VPWR VPWR picorv32_core.cpuregs\[14\]\[4\]
+ sky130_fd_sc_hd__dfxtp_1
XFILLER_16_73 VGND VGND VPWR VPWR sky130_fd_sc_hd__decap_3
X_10694_ clknet_leaf_131_clk _00545_ VGND VGND VPWR VPWR net130 sky130_fd_sc_hd__dfxtp_1
XFILLER_40_485 VGND VGND VPWR VPWR sky130_fd_sc_hd__decap_3
XFILLER_138_362 VGND VGND VPWR VPWR sky130_fd_sc_hd__fill_2
XFILLER_126_502 VGND VGND VPWR VPWR sky130_fd_sc_hd__decap_4
XTAP_TAPCELL_ROW_97_1711 VGND VPWR sky130_fd_sc_hd__tapvpwrvgnd_1
XFILLER_8_158 VPWR VGND VPWR VGND sky130_ef_sc_hd__decap_12
XFILLER_5_821 VPWR VGND VPWR VGND sky130_ef_sc_hd__decap_12
XFILLER_126_557 VGND VGND VPWR VPWR sky130_fd_sc_hd__fill_2
X_11315_ clknet_leaf_95_clk _00016_ VGND VGND VPWR VPWR picorv32_core.cpu_state\[6\]
+ sky130_fd_sc_hd__dfxtp_1
XFILLER_122_741 VPWR VGND VPWR VGND sky130_ef_sc_hd__decap_12
X_11246_ clknet_leaf_110_clk _01094_ VGND VGND VPWR VPWR picorv32_core.cpuregs\[4\]\[1\]
+ sky130_fd_sc_hd__dfxtp_1
X_11177_ clknet_leaf_68_clk _01028_ VGND VGND VPWR VPWR picorv32_core.cpuregs\[7\]\[31\]
+ sky130_fd_sc_hd__dfxtp_1
X_10128_ clknet_leaf_4_clk _00050_ VGND VGND VPWR VPWR picorv32_core.cpuregs\[22\]\[11\]
+ sky130_fd_sc_hd__dfxtp_1
XTAP_TAPCELL_ROW_124_2107 VGND VPWR sky130_fd_sc_hd__tapvpwrvgnd_1
X_10059_ net1926 net249 net307 VGND VGND VPWR VPWR _01534_ sky130_fd_sc_hd__mux2_1
XFILLER_95_669 VGND VGND VPWR VPWR sky130_fd_sc_hd__decap_3
XFILLER_94_179 VGND VGND VPWR VPWR sky130_fd_sc_hd__decap_3
XTAP_TAPCELL_ROW_106_1840 VGND VPWR sky130_fd_sc_hd__tapvpwrvgnd_1
XFILLER_75_393 VPWR VGND VPWR VGND sky130_ef_sc_hd__decap_12
XFILLER_90_385 VGND VGND VPWR VPWR sky130_fd_sc_hd__decap_3
X_07270_ net773 picorv32_core.decoded_imm\[24\] VGND VGND VPWR VPWR _03410_ sky130_fd_sc_hd__nand2_1
XFILLER_92_3 VGND VGND VPWR VPWR sky130_fd_sc_hd__fill_1
XTAP_TAPCELL_ROW_21_609 VGND VPWR sky130_fd_sc_hd__tapvpwrvgnd_1
X_06221_ net624 _02646_ _02650_ VGND VGND VPWR VPWR _02651_ sky130_fd_sc_hd__a21oi_1
XFILLER_31_474 VGND VGND VPWR VPWR sky130_fd_sc_hd__decap_6
XTAP_TAPCELL_ROW_61_1191 VGND VPWR sky130_fd_sc_hd__tapvpwrvgnd_1
XTAP_TAPCELL_ROW_135_2269 VGND VPWR sky130_fd_sc_hd__tapvpwrvgnd_1
XTAP_TAPCELL_ROW_135_2258 VGND VPWR sky130_fd_sc_hd__tapvpwrvgnd_1
XFILLER_117_513 VGND VGND VPWR VPWR sky130_fd_sc_hd__decap_3
X_06152_ net2349 _00757_ net439 VGND VGND VPWR VPWR _00026_ sky130_fd_sc_hd__mux2_1
Xhold114 picorv32_core.cpuregs\[30\]\[25\] VGND VGND VPWR VPWR net1223 sky130_fd_sc_hd__dlygate4sd3_1
X_06083_ net670 net190 _02527_ VGND VGND VPWR VPWR _02541_ sky130_fd_sc_hd__a21o_1
Xhold125 picorv32_core.cpuregs\[24\]\[16\] VGND VGND VPWR VPWR net1234 sky130_fd_sc_hd__dlygate4sd3_1
Xhold103 picorv32_core.cpuregs\[3\]\[2\] VGND VGND VPWR VPWR net1212 sky130_fd_sc_hd__dlygate4sd3_1
X_05103_ picorv32_core.mem_do_rdata _01631_ net908 VGND VGND VPWR VPWR _01635_ sky130_fd_sc_hd__o21ai_2
Xhold136 picorv32_core.cpuregs\[3\]\[28\] VGND VGND VPWR VPWR net1245 sky130_fd_sc_hd__dlygate4sd3_1
Xclkbuf_leaf_7_clk clknet_4_1_0_clk VGND VGND VPWR VPWR clknet_leaf_7_clk sky130_fd_sc_hd__clkbuf_8
Xhold158 picorv32_core.instr_lb VGND VGND VPWR VPWR net1267 sky130_fd_sc_hd__dlygate4sd3_1
X_09911_ net290 net2216 net320 VGND VGND VPWR VPWR _01395_ sky130_fd_sc_hd__mux2_1
Xhold147 picorv32_core.cpuregs\[31\]\[7\] VGND VGND VPWR VPWR net1256 sky130_fd_sc_hd__dlygate4sd3_1
XFILLER_113_741 VPWR VGND VPWR VGND sky130_ef_sc_hd__decap_12
Xfanout605 _01651_ VGND VGND VPWR VPWR net605 sky130_fd_sc_hd__clkbuf_2
Xhold169 picorv32_core.cpuregs\[27\]\[10\] VGND VGND VPWR VPWR net1278 sky130_fd_sc_hd__dlygate4sd3_1
XFILLER_113_785 VPWR VGND VPWR VGND sky130_ef_sc_hd__decap_12
X_09842_ net770 net545 _04970_ VGND VGND VPWR VPWR _05011_ sky130_fd_sc_hd__o21ba_1
Xfanout638 net641 VGND VGND VPWR VPWR net638 sky130_fd_sc_hd__buf_4
Xfanout616 _01623_ VGND VGND VPWR VPWR net616 sky130_fd_sc_hd__clkbuf_2
XFILLER_58_305 VGND VGND VPWR VPWR sky130_fd_sc_hd__decap_3
Xfanout649 _01617_ VGND VGND VPWR VPWR net649 sky130_fd_sc_hd__buf_4
Xfanout627 net628 VGND VGND VPWR VPWR net627 sky130_fd_sc_hd__clkbuf_4
XFILLER_112_295 VGND VGND VPWR VPWR sky130_fd_sc_hd__fill_2
X_09773_ _01599_ net284 VGND VGND VPWR VPWR _04945_ sky130_fd_sc_hd__nor2_1
XFILLER_100_468 VGND VGND VPWR VPWR sky130_fd_sc_hd__decap_8
X_06985_ net666 picorv32_core.reg_next_pc\[23\] _02935_ net489 VGND VGND VPWR VPWR
+ _03198_ sky130_fd_sc_hd__a22o_1
X_08724_ net1501 net492 net381 VGND VGND VPWR VPWR _00872_ sky130_fd_sc_hd__mux2_1
X_05936_ _02404_ _02405_ VGND VGND VPWR VPWR _02406_ sky130_fd_sc_hd__xor2_1
XTAP_TAPCELL_ROW_1_323 VGND VPWR sky130_fd_sc_hd__tapvpwrvgnd_1
XFILLER_39_585 VGND VGND VPWR VPWR sky130_fd_sc_hd__decap_6
X_05867_ net959 _02341_ VGND VGND VPWR VPWR _02342_ sky130_fd_sc_hd__xnor2_1
X_08655_ net503 net1664 net386 VGND VGND VPWR VPWR _00805_ sky130_fd_sc_hd__mux2_1
X_08586_ net495 net2059 net394 VGND VGND VPWR VPWR _00709_ sky130_fd_sc_hd__mux2_1
X_07606_ picorv32_core.cpuregs\[20\]\[5\] picorv32_core.cpuregs\[21\]\[5\] picorv32_core.cpuregs\[22\]\[5\]
+ picorv32_core.cpuregs\[23\]\[5\] net733 net700 VGND VGND VPWR VPWR _03706_ sky130_fd_sc_hd__mux4_1
X_05798_ net815 _02278_ VGND VGND VPWR VPWR _02279_ sky130_fd_sc_hd__nand2_1
X_07537_ net984 net663 net589 picorv32_core.mem_do_prefetch VGND VGND VPWR VPWR _03646_
+ sky130_fd_sc_hd__a31o_1
XFILLER_22_430 VGND VGND VPWR VPWR sky130_fd_sc_hd__fill_2
XFILLER_139_137 VPWR VGND VPWR VGND sky130_ef_sc_hd__decap_12
X_07468_ net804 _03599_ net532 VGND VGND VPWR VPWR _03600_ sky130_fd_sc_hd__mux2_1
XFILLER_22_485 VGND VGND VPWR VPWR sky130_fd_sc_hd__decap_6
XFILLER_136_811 VGND VGND VPWR VPWR sky130_fd_sc_hd__fill_1
XFILLER_108_502 VGND VGND VPWR VPWR sky130_fd_sc_hd__fill_2
X_07399_ net971 picorv32_core.decoded_imm\[31\] VGND VGND VPWR VPWR _03539_ sky130_fd_sc_hd__xnor2_1
X_06419_ net265 net1720 net424 VGND VGND VPWR VPWR _00087_ sky130_fd_sc_hd__mux2_1
X_09207_ net656 _04403_ VGND VGND VPWR VPWR _04404_ sky130_fd_sc_hd__nand2_1
XFILLER_136_833 VGND VGND VPWR VPWR sky130_fd_sc_hd__fill_1
XFILLER_108_513 VGND VGND VPWR VPWR sky130_fd_sc_hd__decap_3
X_09138_ net1402 net254 net330 VGND VGND VPWR VPWR _01304_ sky130_fd_sc_hd__mux2_1
XTAP_TAPCELL_ROW_79_1452 VGND VPWR sky130_fd_sc_hd__tapvpwrvgnd_1
XFILLER_123_505 VGND VGND VPWR VPWR sky130_fd_sc_hd__fill_1
X_11100_ clknet_leaf_50_clk _00951_ VGND VGND VPWR VPWR picorv32_core.cpuregs\[0\]\[18\]
+ sky130_fd_sc_hd__dfxtp_1
X_09069_ net1200 net265 net338 VGND VGND VPWR VPWR _01237_ sky130_fd_sc_hd__mux2_1
XTAP_TAPCELL_ROW_9_434 VGND VPWR sky130_fd_sc_hd__tapvpwrvgnd_1
XFILLER_2_813 VPWR VGND VPWR VGND sky130_ef_sc_hd__decap_12
XFILLER_104_730 VGND VGND VPWR VPWR sky130_fd_sc_hd__fill_2
Xhold670 picorv32_core.cpuregs\[23\]\[18\] VGND VGND VPWR VPWR net1779 sky130_fd_sc_hd__dlygate4sd3_1
XTAP_TAPCELL_ROW_92_1641 VGND VPWR sky130_fd_sc_hd__tapvpwrvgnd_1
Xhold681 picorv32_core.cpuregs\[8\]\[16\] VGND VGND VPWR VPWR net1790 sky130_fd_sc_hd__dlygate4sd3_1
Xhold692 picorv32_core.cpuregs\[2\]\[31\] VGND VGND VPWR VPWR net1801 sky130_fd_sc_hd__dlygate4sd3_1
X_11031_ clknet_leaf_13_clk _00882_ VGND VGND VPWR VPWR picorv32_core.cpuregs\[11\]\[13\]
+ sky130_fd_sc_hd__dfxtp_1
XFILLER_134_41 VPWR VGND VPWR VGND sky130_ef_sc_hd__decap_12
XFILLER_103_262 VGND VGND VPWR VPWR sky130_fd_sc_hd__fill_2
XFILLER_134_85 VPWR VGND VPWR VGND sky130_ef_sc_hd__decap_12
XFILLER_57_393 VGND VGND VPWR VPWR sky130_fd_sc_hd__fill_2
XFILLER_18_769 VPWR VGND VPWR VGND sky130_ef_sc_hd__decap_12
XFILLER_60_514 VGND VGND VPWR VPWR sky130_fd_sc_hd__decap_3
X_11864_ net963 VGND VGND VPWR VPWR net201 sky130_fd_sc_hd__clkbuf_2
X_10815_ clknet_leaf_33_clk _00666_ VGND VGND VPWR VPWR picorv32_core.cpuregs\[15\]\[24\]
+ sky130_fd_sc_hd__dfxtp_1
XFILLER_32_227 VGND VGND VPWR VPWR sky130_fd_sc_hd__fill_2
XFILLER_60_558 VGND VGND VPWR VPWR sky130_fd_sc_hd__fill_1
XTAP_TAPCELL_ROW_101_1770 VGND VPWR sky130_fd_sc_hd__tapvpwrvgnd_1
X_10746_ clknet_leaf_92_clk _00597_ VGND VGND VPWR VPWR picorv32_core.decoded_imm\[13\]
+ sky130_fd_sc_hd__dfxtp_2
X_10677_ clknet_leaf_94_clk _00531_ VGND VGND VPWR VPWR picorv32_core.decoded_imm\[0\]
+ sky130_fd_sc_hd__dfxtp_1
XFILLER_139_671 VGND VGND VPWR VPWR sky130_fd_sc_hd__fill_1
XFILLER_127_833 VGND VGND VPWR VPWR sky130_fd_sc_hd__fill_1
XFILLER_126_332 VGND VGND VPWR VPWR sky130_fd_sc_hd__fill_2
XFILLER_126_365 VGND VGND VPWR VPWR sky130_fd_sc_hd__fill_2
Xpicorv32_axi_1080 VGND VGND VPWR VPWR picorv32_axi_1080/HI trace_data[7] sky130_fd_sc_hd__conb_1
Xpicorv32_axi_1091 VGND VGND VPWR VPWR picorv32_axi_1091/HI trace_data[18] sky130_fd_sc_hd__conb_1
XFILLER_99_249 VGND VGND VPWR VPWR sky130_fd_sc_hd__fill_2
XTAP_TAPCELL_ROW_130_2188 VGND VPWR sky130_fd_sc_hd__tapvpwrvgnd_1
X_11229_ clknet_leaf_28_clk _01080_ VGND VGND VPWR VPWR picorv32_core.cpuregs\[5\]\[19\]
+ sky130_fd_sc_hd__dfxtp_1
XFILLER_4_65 VPWR VGND VPWR VGND sky130_ef_sc_hd__decap_12
XFILLER_122_593 VGND VGND VPWR VPWR sky130_fd_sc_hd__fill_1
XFILLER_110_722 VPWR VGND VPWR VGND sky130_ef_sc_hd__decap_12
X_06770_ picorv32_core.decoded_imm_j\[7\] _02919_ VGND VGND VPWR VPWR _02999_ sky130_fd_sc_hd__and2_1
XFILLER_48_371 VGND VGND VPWR VPWR sky130_fd_sc_hd__fill_1
X_05721_ net771 _01613_ _02204_ net773 VGND VGND VPWR VPWR _02205_ sky130_fd_sc_hd__o22a_1
XFILLER_36_533 VGND VGND VPWR VPWR sky130_fd_sc_hd__decap_4
X_08440_ picorv32_core.decoded_imm\[17\] net528 _04284_ _04300_ VGND VGND VPWR VPWR
+ _00593_ sky130_fd_sc_hd__o22a_1
XFILLER_51_503 VGND VGND VPWR VPWR sky130_fd_sc_hd__fill_1
XFILLER_36_566 VGND VGND VPWR VPWR sky130_fd_sc_hd__decap_4
XFILLER_36_577 VGND VGND VPWR VPWR sky130_fd_sc_hd__decap_4
X_05652_ net815 net966 VGND VGND VPWR VPWR _02136_ sky130_fd_sc_hd__nand2_1
XTAP_TAPCELL_ROW_63_1220 VGND VPWR sky130_fd_sc_hd__tapvpwrvgnd_1
XFILLER_51_536 VGND VGND VPWR VPWR sky130_fd_sc_hd__fill_2
X_05583_ picorv32_core.count_cycle\[27\] net600 net579 _02071_ VGND VGND VPWR VPWR
+ _02072_ sky130_fd_sc_hd__o211a_1
X_08371_ net1159 _04260_ net455 VGND VGND VPWR VPWR _00564_ sky130_fd_sc_hd__mux2_1
X_07322_ _03461_ _03460_ _03459_ VGND VGND VPWR VPWR _03462_ sky130_fd_sc_hd__and3b_1
X_07253_ picorv32_core.cpu_state\[2\] net482 _01707_ net980 _03389_ VGND VGND VPWR
+ VPWR _03393_ sky130_fd_sc_hd__o2111a_1
XFILLER_118_811 VGND VGND VPWR VPWR sky130_fd_sc_hd__fill_1
X_07184_ picorv32_core.count_cycle\[40\] _03344_ picorv32_core.count_cycle\[41\] VGND
+ VGND VPWR VPWR _03347_ sky130_fd_sc_hd__a21o_1
X_06204_ _02633_ _02634_ net694 VGND VGND VPWR VPWR _02635_ sky130_fd_sc_hd__mux2_1
X_06135_ _02578_ _02581_ _02587_ VGND VGND VPWR VPWR _02589_ sky130_fd_sc_hd__or3_1
XFILLER_2_109 VPWR VGND VPWR VGND sky130_ef_sc_hd__decap_12
X_06066_ net773 net189 net570 _02525_ VGND VGND VPWR VPWR _02526_ sky130_fd_sc_hd__a31o_1
Xfanout413 _04226_ VGND VGND VPWR VPWR net413 sky130_fd_sc_hd__buf_2
XFILLER_120_519 VGND VGND VPWR VPWR sky130_fd_sc_hd__decap_3
XTAP_TAPCELL_ROW_74_1382 VGND VPWR sky130_fd_sc_hd__tapvpwrvgnd_1
XTAP_TAPCELL_ROW_74_1371 VGND VPWR sky130_fd_sc_hd__tapvpwrvgnd_1
Xfanout402 net403 VGND VGND VPWR VPWR net402 sky130_fd_sc_hd__clkbuf_8
X_09825_ picorv32_core.cpuregs\[28\]\[29\] picorv32_core.cpuregs\[29\]\[29\] picorv32_core.cpuregs\[30\]\[29\]
+ picorv32_core.cpuregs\[31\]\[29\] net903 net871 VGND VGND VPWR VPWR _04995_ sky130_fd_sc_hd__mux4_1
Xfanout424 _02796_ VGND VGND VPWR VPWR net424 sky130_fd_sc_hd__clkbuf_8
Xfanout435 _02667_ VGND VGND VPWR VPWR net435 sky130_fd_sc_hd__clkbuf_8
Xfanout446 _02690_ VGND VGND VPWR VPWR net446 sky130_fd_sc_hd__dlymetal6s2s_1
Xfanout457 _03702_ VGND VGND VPWR VPWR net457 sky130_fd_sc_hd__buf_4
XFILLER_48_27 VGND VGND VPWR VPWR sky130_fd_sc_hd__fill_1
XFILLER_101_744 VGND VGND VPWR VPWR sky130_fd_sc_hd__fill_1
Xfanout468 _02682_ VGND VGND VPWR VPWR net468 sky130_fd_sc_hd__clkbuf_2
Xfanout479 _03574_ VGND VGND VPWR VPWR net479 sky130_fd_sc_hd__clkbuf_2
X_09756_ net611 _03530_ _04925_ _04928_ net487 VGND VGND VPWR VPWR _04929_ sky130_fd_sc_hd__a311o_1
X_06968_ _03178_ _03181_ net678 VGND VGND VPWR VPWR _03182_ sky130_fd_sc_hd__o21ai_1
XFILLER_58_168 VGND VGND VPWR VPWR sky130_fd_sc_hd__decap_3
X_09687_ picorv32_core.reg_pc\[22\] net537 _04863_ net483 VGND VGND VPWR VPWR _04864_
+ sky130_fd_sc_hd__a211o_1
X_08707_ net1694 net253 net384 VGND VGND VPWR VPWR _00856_ sky130_fd_sc_hd__mux2_1
X_05919_ net177 _02389_ VGND VGND VPWR VPWR _02390_ sky130_fd_sc_hd__xnor2_1
XFILLER_39_382 VGND VGND VPWR VPWR sky130_fd_sc_hd__decap_4
X_08638_ net1324 net266 net392 VGND VGND VPWR VPWR _00789_ sky130_fd_sc_hd__mux2_1
XFILLER_82_672 VGND VGND VPWR VPWR sky130_fd_sc_hd__decap_3
X_06899_ _03094_ _03098_ _03108_ _03117_ _03107_ VGND VGND VPWR VPWR _03118_ sky130_fd_sc_hd__o32a_1
XFILLER_27_588 VGND VGND VPWR VPWR sky130_fd_sc_hd__decap_3
X_08569_ net249 net2090 net400 VGND VGND VPWR VPWR _00694_ sky130_fd_sc_hd__mux2_1
X_11580_ clknet_leaf_42_clk _01411_ VGND VGND VPWR VPWR picorv32_core.cpuregs\[2\]\[27\]
+ sky130_fd_sc_hd__dfxtp_1
XFILLER_23_783 VGND VGND VPWR VPWR sky130_fd_sc_hd__fill_1
X_10600_ clknet_leaf_111_clk _00454_ VGND VGND VPWR VPWR picorv32_core.latched_rd\[2\]
+ sky130_fd_sc_hd__dfxtp_1
XFILLER_128_619 VGND VGND VPWR VPWR sky130_fd_sc_hd__fill_1
X_10531_ clknet_leaf_56_clk picorv32_core.alu_out\[19\] VGND VGND VPWR VPWR picorv32_core.alu_out_q\[19\]
+ sky130_fd_sc_hd__dfxtp_1
XFILLER_50_580 VGND VGND VPWR VPWR sky130_fd_sc_hd__decap_8
X_10462_ clknet_leaf_65_clk _00349_ VGND VGND VPWR VPWR net54 sky130_fd_sc_hd__dfxtp_1
XFILLER_89_23 VGND VGND VPWR VPWR sky130_fd_sc_hd__fill_2
XFILLER_124_825 VGND VGND VPWR VPWR sky130_fd_sc_hd__fill_1
X_10393_ clknet_leaf_80_clk _00312_ VGND VGND VPWR VPWR picorv32_core.count_cycle\[51\]
+ sky130_fd_sc_hd__dfxtp_1
XFILLER_2_643 VGND VGND VPWR VPWR sky130_fd_sc_hd__fill_1
X_11014_ clknet_leaf_38_clk _00865_ VGND VGND VPWR VPWR picorv32_core.cpuregs\[12\]\[28\]
+ sky130_fd_sc_hd__dfxtp_1
XFILLER_49_113 VGND VGND VPWR VPWR sky130_fd_sc_hd__decap_4
Xfanout991 net993 VGND VGND VPWR VPWR net991 sky130_fd_sc_hd__clkbuf_2
XFILLER_64_116 VGND VGND VPWR VPWR sky130_fd_sc_hd__fill_1
Xfanout980 net981 VGND VGND VPWR VPWR net980 sky130_fd_sc_hd__buf_2
XFILLER_92_447 VGND VGND VPWR VPWR sky130_fd_sc_hd__fill_1
XFILLER_18_533 VGND VGND VPWR VPWR sky130_fd_sc_hd__fill_2
X_11847_ net50 VGND VGND VPWR VPWR net82 sky130_fd_sc_hd__clkbuf_1
XFILLER_60_344 VGND VGND VPWR VPWR sky130_fd_sc_hd__decap_6
XFILLER_54_81 VGND VGND VPWR VPWR sky130_fd_sc_hd__decap_3
XTAP_TAPCELL_ROW_119_2028 VGND VPWR sky130_fd_sc_hd__tapvpwrvgnd_1
X_10729_ clknet_leaf_89_clk _00580_ VGND VGND VPWR VPWR picorv32_core.decoded_imm\[30\]
+ sky130_fd_sc_hd__dfxtp_2
XTAP_TAPCELL_ROW_31_748 VGND VPWR sky130_fd_sc_hd__tapvpwrvgnd_1
XTAP_TAPCELL_ROW_31_759 VGND VPWR sky130_fd_sc_hd__tapvpwrvgnd_1
XTAP_TAPCELL_ROW_132_2217 VGND VPWR sky130_fd_sc_hd__tapvpwrvgnd_1
Xclkload12 clknet_4_13_0_clk VGND VGND VPWR VPWR clkload12/X sky130_fd_sc_hd__clkbuf_8
Xclkload23 clknet_leaf_6_clk VGND VGND VPWR VPWR clkload23/X sky130_fd_sc_hd__clkbuf_4
XTAP_TAPCELL_ROW_11_461 VGND VPWR sky130_fd_sc_hd__tapvpwrvgnd_1
Xclkload34 clknet_leaf_136_clk VGND VGND VPWR VPWR clkload34/Y sky130_fd_sc_hd__inv_6
XFILLER_115_825 VGND VGND VPWR VPWR sky130_fd_sc_hd__fill_1
Xclkload78 clknet_leaf_49_clk VGND VGND VPWR VPWR clkload78/Y sky130_fd_sc_hd__inv_12
Xclkload56 clknet_leaf_34_clk VGND VGND VPWR VPWR clkload56/Y sky130_fd_sc_hd__clkinv_4
Xclkload67 clknet_leaf_52_clk VGND VGND VPWR VPWR clkload67/Y sky130_fd_sc_hd__inv_12
Xclkload45 clknet_leaf_22_clk VGND VGND VPWR VPWR clkload45/Y sky130_fd_sc_hd__bufinv_16
Xclkload89 clknet_leaf_90_clk VGND VGND VPWR VPWR clkload89/Y sky130_fd_sc_hd__inv_8
X_07940_ _04016_ _04017_ net636 VGND VGND VPWR VPWR _04022_ sky130_fd_sc_hd__mux2_1
XTAP_TAPCELL_ROW_114_1961 VGND VPWR sky130_fd_sc_hd__tapvpwrvgnd_1
XFILLER_141_165 VGND VGND VPWR VPWR sky130_fd_sc_hd__decap_3
XFILLER_68_411 VGND VGND VPWR VPWR sky130_fd_sc_hd__decap_8
X_07871_ picorv32_core.decoded_imm\[19\] net591 net596 VGND VGND VPWR VPWR _03957_
+ sky130_fd_sc_hd__a21o_1
XFILLER_29_809 VPWR VGND VPWR VGND sky130_ef_sc_hd__decap_12
XFILLER_110_585 VGND VGND VPWR VPWR sky130_fd_sc_hd__decap_3
X_09610_ picorv32_core.cpuregs\[28\]\[19\] picorv32_core.cpuregs\[29\]\[19\] picorv32_core.cpuregs\[30\]\[19\]
+ picorv32_core.cpuregs\[31\]\[19\] net891 net856 VGND VGND VPWR VPWR _04790_ sky130_fd_sc_hd__mux4_1
XFILLER_68_477 VPWR VGND VPWR VGND sky130_ef_sc_hd__decap_12
X_06822_ picorv32_core.decoded_imm_j\[11\] _02923_ VGND VGND VPWR VPWR _03047_ sky130_fd_sc_hd__nor2_1
XFILLER_55_105 VGND VGND VPWR VPWR sky130_fd_sc_hd__decap_6
XFILLER_83_447 VGND VGND VPWR VPWR sky130_fd_sc_hd__fill_1
X_09541_ picorv32_core.cpuregs\[24\]\[16\] picorv32_core.cpuregs\[25\]\[16\] picorv32_core.cpuregs\[26\]\[16\]
+ picorv32_core.cpuregs\[27\]\[16\] net893 net859 VGND VGND VPWR VPWR _04724_ sky130_fd_sc_hd__mux4_1
X_06753_ net673 _02983_ VGND VGND VPWR VPWR _02984_ sky130_fd_sc_hd__nor2_1
X_05704_ net795 net177 VGND VGND VPWR VPWR _02188_ sky130_fd_sc_hd__nand2_1
XFILLER_91_491 VPWR VGND VPWR VGND sky130_ef_sc_hd__decap_12
X_06684_ picorv32_core.reg_pc\[19\] net554 _02931_ net517 VGND VGND VPWR VPWR _00217_
+ sky130_fd_sc_hd__a22o_1
X_09472_ net473 _04656_ _04657_ net471 VGND VGND VPWR VPWR _04658_ sky130_fd_sc_hd__a22o_1
XTAP_TAPCELL_ROW_19_583 VGND VPWR sky130_fd_sc_hd__tapvpwrvgnd_1
X_05635_ net578 _02118_ _02119_ net971 net917 VGND VGND VPWR VPWR _02120_ sky130_fd_sc_hd__a32o_1
X_08423_ picorv32_core.mem_rdata_q\[25\] net614 VGND VGND VPWR VPWR _04292_ sky130_fd_sc_hd__and2_1
XFILLER_34_29 VGND VGND VPWR VPWR sky130_fd_sc_hd__decap_4
X_05566_ _02043_ _02046_ _02055_ VGND VGND VPWR VPWR _02056_ sky130_fd_sc_hd__nand3_1
X_08354_ _01595_ net179 net451 _04251_ VGND VGND VPWR VPWR _04252_ sky130_fd_sc_hd__a211o_1
X_07305_ _03442_ _03443_ _03441_ VGND VGND VPWR VPWR _03445_ sky130_fd_sc_hd__o21a_1
X_08285_ net1800 net239 net413 VGND VGND VPWR VPWR _00509_ sky130_fd_sc_hd__mux2_1
Xclkload6 clknet_4_7_0_clk VGND VGND VPWR VPWR clkload6/X sky130_fd_sc_hd__clkbuf_8
X_05497_ net922 _01985_ _01986_ _01992_ VGND VGND VPWR VPWR _01559_ sky130_fd_sc_hd__a31o_1
X_07236_ picorv32_core.count_cycle\[58\] picorv32_core.count_cycle\[59\] picorv32_core.count_cycle\[60\]
+ _03375_ VGND VGND VPWR VPWR _03380_ sky130_fd_sc_hd__and4_2
XTAP_TAPCELL_ROW_76_1400 VGND VPWR sky130_fd_sc_hd__tapvpwrvgnd_1
XTAP_TAPCELL_ROW_76_1411 VGND VPWR sky130_fd_sc_hd__tapvpwrvgnd_1
X_07167_ picorv32_core.count_cycle\[34\] _03334_ _03336_ VGND VGND VPWR VPWR _00295_
+ sky130_fd_sc_hd__o21a_1
X_06118_ net765 net954 _02248_ VGND VGND VPWR VPWR _02573_ sky130_fd_sc_hd__a21oi_1
X_07098_ _03293_ net986 _03292_ VGND VGND VPWR VPWR _00269_ sky130_fd_sc_hd__and3b_1
Xfanout221 net224 VGND VGND VPWR VPWR net221 sky130_fd_sc_hd__clkbuf_2
Xfanout210 net211 VGND VGND VPWR VPWR net210 sky130_fd_sc_hd__clkbuf_2
XFILLER_120_305 VGND VGND VPWR VPWR sky130_fd_sc_hd__decap_3
Xfanout232 net235 VGND VGND VPWR VPWR net232 sky130_fd_sc_hd__clkbuf_2
XFILLER_105_379 VPWR VGND VPWR VGND sky130_ef_sc_hd__decap_12
X_06049_ net775 _02509_ VGND VGND VPWR VPWR _02510_ sky130_fd_sc_hd__nor2_1
XFILLER_59_411 VGND VGND VPWR VPWR sky130_fd_sc_hd__decap_3
Xfanout243 _02757_ VGND VGND VPWR VPWR net243 sky130_fd_sc_hd__clkbuf_2
Xfanout254 _02744_ VGND VGND VPWR VPWR net254 sky130_fd_sc_hd__clkbuf_2
Xfanout265 net267 VGND VGND VPWR VPWR net265 sky130_fd_sc_hd__clkbuf_2
X_09808_ picorv32_core.cpuregs\[20\]\[28\] picorv32_core.cpuregs\[21\]\[28\] picorv32_core.cpuregs\[22\]\[28\]
+ picorv32_core.cpuregs\[23\]\[28\] net896 net862 VGND VGND VPWR VPWR _04979_ sky130_fd_sc_hd__mux4_1
Xfanout276 net277 VGND VGND VPWR VPWR net276 sky130_fd_sc_hd__clkbuf_2
Xfanout287 net289 VGND VGND VPWR VPWR net287 sky130_fd_sc_hd__clkbuf_2
XFILLER_19_308 VGND VGND VPWR VPWR sky130_fd_sc_hd__decap_3
Xfanout298 _02703_ VGND VGND VPWR VPWR net298 sky130_fd_sc_hd__clkbuf_2
X_09739_ picorv32_core.cpuregs\[28\]\[25\] picorv32_core.cpuregs\[29\]\[25\] picorv32_core.cpuregs\[30\]\[25\]
+ picorv32_core.cpuregs\[31\]\[25\] net904 net870 VGND VGND VPWR VPWR _04913_ sky130_fd_sc_hd__mux4_1
XTAP_TAPCELL_ROW_87_1562 VGND VPWR sky130_fd_sc_hd__tapvpwrvgnd_1
XFILLER_39_190 VGND VGND VPWR VPWR sky130_fd_sc_hd__decap_4
XTAP_TAPCELL_ROW_87_1573 VGND VPWR sky130_fd_sc_hd__tapvpwrvgnd_1
X_11701_ clknet_leaf_20_clk _01532_ VGND VGND VPWR VPWR picorv32_core.cpuregs\[27\]\[18\]
+ sky130_fd_sc_hd__dfxtp_1
XFILLER_70_653 VGND VGND VPWR VPWR sky130_fd_sc_hd__fill_2
X_11632_ clknet_leaf_13_clk _01463_ VGND VGND VPWR VPWR picorv32_core.cpuregs\[28\]\[13\]
+ sky130_fd_sc_hd__dfxtp_1
XFILLER_128_416 VGND VGND VPWR VPWR sky130_fd_sc_hd__decap_4
XFILLER_11_753 VPWR VGND VPWR VGND sky130_ef_sc_hd__decap_12
XFILLER_7_713 VPWR VGND VPWR VGND sky130_ef_sc_hd__decap_12
X_11563_ clknet_leaf_3_clk _01394_ VGND VGND VPWR VPWR picorv32_core.cpuregs\[2\]\[10\]
+ sky130_fd_sc_hd__dfxtp_1
X_11494_ clknet_leaf_126_clk _01330_ VGND VGND VPWR VPWR net143 sky130_fd_sc_hd__dfxtp_1
XFILLER_11_797 VPWR VGND VPWR VGND sky130_ef_sc_hd__decap_12
X_10514_ clknet_leaf_128_clk picorv32_core.alu_out\[2\] VGND VGND VPWR VPWR picorv32_core.alu_out_q\[2\]
+ sky130_fd_sc_hd__dfxtp_1
XFILLER_109_652 VGND VGND VPWR VPWR sky130_fd_sc_hd__fill_1
X_10445_ clknet_leaf_117_clk _00332_ VGND VGND VPWR VPWR net67 sky130_fd_sc_hd__dfxtp_1
XFILLER_136_493 VGND VGND VPWR VPWR sky130_fd_sc_hd__decap_6
X_10376_ clknet_leaf_104_clk _00295_ VGND VGND VPWR VPWR picorv32_core.count_cycle\[34\]
+ sky130_fd_sc_hd__dfxtp_1
XFILLER_69_219 VGND VGND VPWR VPWR sky130_fd_sc_hd__decap_4
XFILLER_77_263 VPWR VGND VPWR VGND sky130_ef_sc_hd__decap_12
XFILLER_1_33 VPWR VGND VPWR VGND sky130_ef_sc_hd__decap_12
XFILLER_53_609 VGND VGND VPWR VPWR sky130_fd_sc_hd__fill_1
XTAP_TAPCELL_ROW_36_829 VGND VPWR sky130_fd_sc_hd__tapvpwrvgnd_1
XFILLER_61_653 VGND VGND VPWR VPWR sky130_fd_sc_hd__decap_4
XTAP_TAPCELL_ROW_16_531 VGND VPWR sky130_fd_sc_hd__tapvpwrvgnd_1
XTAP_TAPCELL_ROW_16_542 VGND VPWR sky130_fd_sc_hd__tapvpwrvgnd_1
X_05420_ picorv32_core.latched_is_lh _01920_ _01820_ _01817_ VGND VGND VPWR VPWR _01921_
+ sky130_fd_sc_hd__a211o_1
X_05351_ _01836_ _01838_ VGND VGND VPWR VPWR _01857_ sky130_fd_sc_hd__nand2_1
X_08070_ net196 net511 _04143_ _04144_ VGND VGND VPWR VPWR _00390_ sky130_fd_sc_hd__o22a_1
Xclkload101 clknet_leaf_107_clk VGND VGND VPWR VPWR clkload101/Y sky130_fd_sc_hd__inv_6
Xclkload112 clknet_leaf_104_clk VGND VGND VPWR VPWR clkload112/Y sky130_fd_sc_hd__clkinvlp_4
X_05282_ picorv32_core.reg_pc\[6\] picorv32_core.decoded_imm\[6\] VGND VGND VPWR VPWR
+ _01792_ sky130_fd_sc_hd__nor2_1
Xclkload123 clknet_leaf_64_clk VGND VGND VPWR VPWR clkload123/Y sky130_fd_sc_hd__clkinv_2
X_07021_ net933 _02939_ VGND VGND VPWR VPWR _03230_ sky130_fd_sc_hd__or2_1
Xclkload134 clknet_leaf_85_clk VGND VGND VPWR VPWR clkload134/Y sky130_fd_sc_hd__inv_6
XFILLER_127_493 VGND VGND VPWR VPWR sky130_fd_sc_hd__fill_1
XTAP_TAPCELL_ROW_58_1152 VGND VPWR sky130_fd_sc_hd__tapvpwrvgnd_1
XTAP_TAPCELL_ROW_58_1141 VGND VPWR sky130_fd_sc_hd__tapvpwrvgnd_1
X_08972_ net1881 net251 net350 VGND VGND VPWR VPWR _01144_ sky130_fd_sc_hd__mux2_1
XTAP_TAPCELL_ROW_71_1330 VGND VPWR sky130_fd_sc_hd__tapvpwrvgnd_1
X_07923_ _03999_ _04004_ _04005_ net684 net689 VGND VGND VPWR VPWR _04006_ sky130_fd_sc_hd__a221o_1
Xhold29 picorv32_core.cpuregs\[0\]\[17\] VGND VGND VPWR VPWR net1138 sky130_fd_sc_hd__dlygate4sd3_1
XTAP_TAPCELL_ROW_71_1341 VGND VPWR sky130_fd_sc_hd__tapvpwrvgnd_1
Xhold18 picorv32_core.cpuregs\[0\]\[5\] VGND VGND VPWR VPWR net1127 sky130_fd_sc_hd__dlygate4sd3_1
XFILLER_110_360 VGND VGND VPWR VPWR sky130_fd_sc_hd__decap_4
X_07854_ picorv32_core.cpuregs\[20\]\[19\] picorv32_core.cpuregs\[21\]\[19\] picorv32_core.cpuregs\[22\]\[19\]
+ picorv32_core.cpuregs\[23\]\[19\] net748 net715 VGND VGND VPWR VPWR _03940_ sky130_fd_sc_hd__mux4_1
XFILLER_84_723 VGND VGND VPWR VPWR sky130_fd_sc_hd__decap_6
XFILLER_84_701 VGND VGND VPWR VPWR sky130_fd_sc_hd__decap_4
X_06805_ net675 _03027_ _03029_ _03030_ _03031_ VGND VGND VPWR VPWR _03032_ sky130_fd_sc_hd__a32o_1
XFILLER_84_789 VGND VGND VPWR VPWR sky130_fd_sc_hd__decap_3
X_07785_ picorv32_core.cpuregs\[24\]\[15\] picorv32_core.cpuregs\[25\]\[15\] picorv32_core.cpuregs\[26\]\[15\]
+ picorv32_core.cpuregs\[27\]\[15\] net740 net707 VGND VGND VPWR VPWR _03875_ sky130_fd_sc_hd__mux4_1
X_09524_ picorv32_core.cpuregs\[24\]\[15\] picorv32_core.cpuregs\[25\]\[15\] picorv32_core.cpuregs\[26\]\[15\]
+ picorv32_core.cpuregs\[27\]\[15\] net882 net849 VGND VGND VPWR VPWR _04708_ sky130_fd_sc_hd__mux4_1
X_06736_ _02963_ _02966_ net663 VGND VGND VPWR VPWR _02968_ sky130_fd_sc_hd__a21o_1
X_06667_ _02707_ picorv32_core.reg_next_pc\[11\] net557 VGND VGND VPWR VPWR _02923_
+ sky130_fd_sc_hd__mux2_2
X_09455_ picorv32_core.cpuregs\[4\]\[12\] picorv32_core.cpuregs\[5\]\[12\] picorv32_core.cpuregs\[6\]\[12\]
+ picorv32_core.cpuregs\[7\]\[12\] net879 net846 VGND VGND VPWR VPWR _04642_ sky130_fd_sc_hd__mux4_1
X_05618_ _02081_ _02084_ _02091_ VGND VGND VPWR VPWR _02104_ sky130_fd_sc_hd__a21oi_1
XFILLER_12_506 VGND VGND VPWR VPWR sky130_fd_sc_hd__fill_1
X_08406_ net2257 _04281_ net461 VGND VGND VPWR VPWR _00578_ sky130_fd_sc_hd__a21o_1
XTAP_TAPCELL_ROW_82_1492 VGND VPWR sky130_fd_sc_hd__tapvpwrvgnd_1
X_06598_ _02879_ _02880_ VGND VGND VPWR VPWR _00182_ sky130_fd_sc_hd__nor2_1
X_09386_ picorv32_core.cpuregs\[28\]\[9\] picorv32_core.cpuregs\[29\]\[9\] picorv32_core.cpuregs\[30\]\[9\]
+ picorv32_core.cpuregs\[31\]\[9\] net873 net840 VGND VGND VPWR VPWR _04576_ sky130_fd_sc_hd__mux4_1
XFILLER_138_725 VPWR VGND VPWR VGND sky130_ef_sc_hd__decap_12
X_05549_ net912 net302 _02036_ _02040_ VGND VGND VPWR VPWR _02041_ sky130_fd_sc_hd__a31o_1
X_08337_ net1165 net456 _04240_ VGND VGND VPWR VPWR _00550_ sky130_fd_sc_hd__o21a_1
XFILLER_138_769 VPWR VGND VPWR VGND sky130_ef_sc_hd__decap_12
XFILLER_137_235 VGND VGND VPWR VPWR sky130_fd_sc_hd__decap_3
X_08268_ net1242 net443 net410 VGND VGND VPWR VPWR _00492_ sky130_fd_sc_hd__mux2_1
XFILLER_118_460 VGND VGND VPWR VPWR sky130_fd_sc_hd__fill_1
X_07219_ _03369_ net994 _03368_ VGND VGND VPWR VPWR _00314_ sky130_fd_sc_hd__and3b_1
X_10230_ clknet_leaf_81_clk _00149_ VGND VGND VPWR VPWR picorv32_core.count_instr\[14\]
+ sky130_fd_sc_hd__dfxtp_1
X_08199_ picorv32_core.mem_rdata_q\[30\] _04202_ _04203_ VGND VGND VPWR VPWR _04204_
+ sky130_fd_sc_hd__and3b_1
XFILLER_4_749 VGND VGND VPWR VPWR sky130_fd_sc_hd__decap_6
XFILLER_10_53 VPWR VGND VPWR VGND sky130_ef_sc_hd__decap_12
XFILLER_3_237 VPWR VGND VPWR VGND sky130_ef_sc_hd__decap_12
XFILLER_126_53 VPWR VGND VPWR VGND sky130_ef_sc_hd__decap_12
XFILLER_106_699 VGND VGND VPWR VPWR sky130_fd_sc_hd__fill_1
XPHY_EDGE_ROW_58_Left_200 VGND VGND VPWR VPWR sky130_fd_sc_hd__decap_3
X_10161_ clknet_leaf_0_clk _00080_ VGND VGND VPWR VPWR picorv32_core.cpuregs\[21\]\[9\]
+ sky130_fd_sc_hd__dfxtp_1
X_10092_ net1130 VGND VGND VPWR VPWR _00942_ sky130_fd_sc_hd__clkbuf_1
XTAP_TAPCELL_ROW_89_1602 VGND VPWR sky130_fd_sc_hd__tapvpwrvgnd_1
XFILLER_87_561 VGND VGND VPWR VPWR sky130_fd_sc_hd__decap_6
XFILLER_19_105 VGND VGND VPWR VPWR sky130_fd_sc_hd__fill_1
XFILLER_101_382 VGND VGND VPWR VPWR sky130_fd_sc_hd__decap_8
XFILLER_87_594 VGND VGND VPWR VPWR sky130_fd_sc_hd__decap_6
XFILLER_47_425 VGND VGND VPWR VPWR sky130_fd_sc_hd__fill_1
XFILLER_74_266 VGND VGND VPWR VPWR sky130_fd_sc_hd__fill_1
X_10994_ clknet_leaf_13_clk _00845_ VGND VGND VPWR VPWR picorv32_core.cpuregs\[12\]\[8\]
+ sky130_fd_sc_hd__dfxtp_1
XFILLER_70_450 VGND VGND VPWR VPWR sky130_fd_sc_hd__fill_1
XFILLER_31_826 VGND VGND VPWR VPWR sky130_fd_sc_hd__decap_6
XFILLER_42_141 VGND VGND VPWR VPWR sky130_fd_sc_hd__decap_3
X_11615_ clknet_leaf_36_clk _01446_ VGND VGND VPWR VPWR picorv32_core.cpuregs\[23\]\[28\]
+ sky130_fd_sc_hd__dfxtp_1
XFILLER_128_213 VGND VGND VPWR VPWR sky130_fd_sc_hd__decap_3
X_11546_ clknet_leaf_41_clk _01377_ VGND VGND VPWR VPWR picorv32_core.cpuregs\[30\]\[27\]
+ sky130_fd_sc_hd__dfxtp_1
XFILLER_11_561 VGND VGND VPWR VPWR sky130_fd_sc_hd__decap_4
XTAP_TAPCELL_ROW_41_898 VGND VPWR sky130_fd_sc_hd__tapvpwrvgnd_1
X_11477_ clknet_leaf_41_clk _01313_ VGND VGND VPWR VPWR picorv32_core.cpuregs\[24\]\[28\]
+ sky130_fd_sc_hd__dfxtp_1
X_10428_ clknet_leaf_87_clk _01560_ VGND VGND VPWR VPWR picorv32_core.reg_out\[21\]
+ sky130_fd_sc_hd__dfxtp_1
XFILLER_112_625 VGND VGND VPWR VPWR sky130_fd_sc_hd__fill_1
XTAP_TAPCELL_ROW_111_1920 VGND VPWR sky130_fd_sc_hd__tapvpwrvgnd_1
X_10359_ clknet_leaf_82_clk _00278_ VGND VGND VPWR VPWR picorv32_core.count_cycle\[17\]
+ sky130_fd_sc_hd__dfxtp_1
XTAP_TAPCELL_ROW_53_1071 VGND VPWR sky130_fd_sc_hd__tapvpwrvgnd_1
XTAP_TAPCELL_ROW_127_2149 VGND VPWR sky130_fd_sc_hd__tapvpwrvgnd_1
XFILLER_18_3 VPWR VGND VPWR VGND sky130_ef_sc_hd__decap_12
XFILLER_93_575 VGND VGND VPWR VPWR sky130_fd_sc_hd__fill_1
XTAP_TAPCELL_ROW_140_2338 VGND VPWR sky130_fd_sc_hd__tapvpwrvgnd_1
XTAP_TAPCELL_ROW_109_1882 VGND VPWR sky130_fd_sc_hd__tapvpwrvgnd_1
X_07570_ picorv32_core.cpuregs\[0\]\[1\] picorv32_core.cpuregs\[1\]\[1\] picorv32_core.cpuregs\[2\]\[1\]
+ picorv32_core.cpuregs\[3\]\[1\] net745 net712 VGND VGND VPWR VPWR _03674_ sky130_fd_sc_hd__mux4_1
X_06521_ net2321 _02829_ net991 VGND VGND VPWR VPWR _02832_ sky130_fd_sc_hd__o21ai_1
X_09240_ net827 _04431_ _04433_ _04435_ net831 VGND VGND VPWR VPWR _04436_ sky130_fd_sc_hd__o221a_1
XFILLER_33_130 VGND VGND VPWR VPWR sky130_fd_sc_hd__fill_2
X_06452_ net268 net1269 net419 VGND VGND VPWR VPWR _00118_ sky130_fd_sc_hd__mux2_1
XFILLER_34_697 VGND VGND VPWR VPWR sky130_fd_sc_hd__decap_3
X_06383_ _02779_ _02780_ net565 VGND VGND VPWR VPWR _02781_ sky130_fd_sc_hd__mux2_4
X_05403_ net918 net794 _01904_ net910 net578 VGND VGND VPWR VPWR _01905_ sky130_fd_sc_hd__a221o_1
X_09171_ net823 picorv32_core.decoded_imm\[0\] VGND VGND VPWR VPWR _04370_ sky130_fd_sc_hd__or2_1
X_08122_ net261 net1968 net416 VGND VGND VPWR VPWR _00415_ sky130_fd_sc_hd__mux2_1
X_05334_ net925 _01730_ net585 VGND VGND VPWR VPWR _01841_ sky130_fd_sc_hd__a21o_1
X_08053_ picorv32_core.cpuregs\[16\]\[30\] picorv32_core.cpuregs\[17\]\[30\] picorv32_core.cpuregs\[18\]\[30\]
+ picorv32_core.cpuregs\[19\]\[30\] net761 net728 VGND VGND VPWR VPWR _04128_ sky130_fd_sc_hd__mux4_1
X_07004_ _03211_ _03214_ VGND VGND VPWR VPWR _03215_ sky130_fd_sc_hd__nand2_1
X_05265_ net920 _01769_ _01775_ _01776_ VGND VGND VPWR VPWR _01573_ sky130_fd_sc_hd__a211o_1
XPHY_EDGE_ROW_131_Right_131 VGND VGND VPWR VPWR sky130_fd_sc_hd__decap_3
XFILLER_115_441 VGND VGND VPWR VPWR sky130_fd_sc_hd__decap_3
X_05196_ axi_adapter.ack_arvalid net103 VGND VGND VPWR VPWR net70 sky130_fd_sc_hd__and2b_1
XFILLER_88_303 VGND VGND VPWR VPWR sky130_fd_sc_hd__decap_4
X_08955_ net1212 net496 net349 VGND VGND VPWR VPWR _01127_ sky130_fd_sc_hd__mux2_1
XFILLER_130_477 VGND VGND VPWR VPWR sky130_fd_sc_hd__decap_4
X_07906_ _03979_ _03980_ net636 VGND VGND VPWR VPWR _03990_ sky130_fd_sc_hd__mux2_1
XFILLER_84_531 VGND VGND VPWR VPWR sky130_fd_sc_hd__fill_1
XFILLER_69_594 VGND VGND VPWR VPWR sky130_fd_sc_hd__decap_4
X_08886_ _02795_ _04340_ VGND VGND VPWR VPWR _04343_ sky130_fd_sc_hd__or2_4
X_07837_ net696 _03923_ VGND VGND VPWR VPWR _03924_ sky130_fd_sc_hd__or2_1
XFILLER_72_726 VPWR VGND VPWR VGND sky130_ef_sc_hd__decap_12
X_07768_ picorv32_core.cpuregs\[4\]\[14\] picorv32_core.cpuregs\[5\]\[14\] picorv32_core.cpuregs\[6\]\[14\]
+ picorv32_core.cpuregs\[7\]\[14\] net737 net704 VGND VGND VPWR VPWR _03859_ sky130_fd_sc_hd__mux4_1
XFILLER_44_417 VGND VGND VPWR VPWR sky130_fd_sc_hd__decap_3
XTAP_TAPCELL_ROW_84_1521 VGND VPWR sky130_fd_sc_hd__tapvpwrvgnd_1
X_09507_ net285 _04678_ _04691_ _04673_ VGND VGND VPWR VPWR _01333_ sky130_fd_sc_hd__a31o_1
X_06719_ net970 _02914_ VGND VGND VPWR VPWR _02953_ sky130_fd_sc_hd__or2_1
X_07699_ net627 _03793_ VGND VGND VPWR VPWR _03794_ sky130_fd_sc_hd__or2_1
XFILLER_24_174 VGND VGND VPWR VPWR sky130_fd_sc_hd__fill_1
X_09438_ _04620_ _04621_ _04622_ _04623_ net654 net825 VGND VGND VPWR VPWR _04626_
+ sky130_fd_sc_hd__mux4_1
XFILLER_40_656 VGND VGND VPWR VPWR sky130_fd_sc_hd__fill_1
XFILLER_40_678 VGND VGND VPWR VPWR sky130_fd_sc_hd__fill_2
X_09369_ _04554_ _04555_ _04556_ _04557_ net655 net826 VGND VGND VPWR VPWR _04560_
+ sky130_fd_sc_hd__mux4_1
X_11400_ clknet_leaf_14_clk _01236_ VGND VGND VPWR VPWR picorv32_core.cpuregs\[31\]\[15\]
+ sky130_fd_sc_hd__dfxtp_1
XFILLER_122_3 VPWR VGND VPWR VGND sky130_ef_sc_hd__decap_12
XANTENNA_92 net758 VGND VGND VPWR VPWR sky130_fd_sc_hd__diode_2
XANTENNA_81 net180 VGND VGND VPWR VPWR sky130_fd_sc_hd__diode_2
XANTENNA_70 _00001_ VGND VGND VPWR VPWR sky130_fd_sc_hd__diode_2
X_11331_ clknet_leaf_14_clk _01172_ VGND VGND VPWR VPWR picorv32_core.cpuregs\[29\]\[15\]
+ sky130_fd_sc_hd__dfxtp_1
XTAP_TAPCELL_ROW_95_1683 VGND VPWR sky130_fd_sc_hd__tapvpwrvgnd_1
X_11262_ clknet_leaf_25_clk _01110_ VGND VGND VPWR VPWR picorv32_core.cpuregs\[4\]\[17\]
+ sky130_fd_sc_hd__dfxtp_1
X_10213_ clknet_leaf_69_clk _00132_ VGND VGND VPWR VPWR picorv32_core.cpuregs\[9\]\[29\]
+ sky130_fd_sc_hd__dfxtp_1
X_11193_ clknet_leaf_15_clk _01044_ VGND VGND VPWR VPWR picorv32_core.cpuregs\[6\]\[15\]
+ sky130_fd_sc_hd__dfxtp_1
X_10144_ clknet_leaf_42_clk _00066_ VGND VGND VPWR VPWR picorv32_core.cpuregs\[22\]\[27\]
+ sky130_fd_sc_hd__dfxtp_1
XFILLER_0_741 VGND VGND VPWR VPWR sky130_fd_sc_hd__decap_8
XFILLER_102_691 VGND VGND VPWR VPWR sky130_fd_sc_hd__decap_8
X_10075_ picorv32_core.decoded_imm_j\[15\] _00756_ net439 VGND VGND VPWR VPWR _00523_
+ sky130_fd_sc_hd__mux2_1
XFILLER_0_785 VGND VGND VPWR VPWR sky130_fd_sc_hd__fill_2
XFILLER_75_575 VPWR VGND VPWR VGND sky130_ef_sc_hd__decap_12
XFILLER_35_428 VGND VGND VPWR VPWR sky130_fd_sc_hd__fill_1
XTAP_TAPCELL_ROW_46_968 VGND VPWR sky130_fd_sc_hd__tapvpwrvgnd_1
X_10977_ clknet_leaf_44_clk _00828_ VGND VGND VPWR VPWR picorv32_core.cpuregs\[13\]\[23\]
+ sky130_fd_sc_hd__dfxtp_1
XTAP_TAPCELL_ROW_122_2079 VGND VPWR sky130_fd_sc_hd__tapvpwrvgnd_1
XTAP_TAPCELL_ROW_122_2068 VGND VPWR sky130_fd_sc_hd__tapvpwrvgnd_1
XTAP_TAPCELL_ROW_46_979 VGND VPWR sky130_fd_sc_hd__tapvpwrvgnd_1
XTAP_TAPCELL_ROW_26_681 VGND VPWR sky130_fd_sc_hd__tapvpwrvgnd_1
XFILLER_31_612 VGND VGND VPWR VPWR sky130_fd_sc_hd__decap_4
XFILLER_31_645 VGND VGND VPWR VPWR sky130_fd_sc_hd__decap_4
XFILLER_31_667 VGND VGND VPWR VPWR sky130_fd_sc_hd__decap_4
XFILLER_129_577 VGND VGND VPWR VPWR sky130_fd_sc_hd__decap_4
XFILLER_7_54 VGND VGND VPWR VPWR sky130_fd_sc_hd__fill_2
Xhold307 picorv32_core.cpuregs\[26\]\[10\] VGND VGND VPWR VPWR net1416 sky130_fd_sc_hd__dlygate4sd3_1
X_11529_ clknet_leaf_1_clk _01360_ VGND VGND VPWR VPWR picorv32_core.cpuregs\[30\]\[10\]
+ sky130_fd_sc_hd__dfxtp_1
X_05050_ net2001 VGND VGND VPWR VPWR _01585_ sky130_fd_sc_hd__inv_2
XTAP_TAPCELL_ROW_55_1100 VGND VPWR sky130_fd_sc_hd__tapvpwrvgnd_1
Xhold318 picorv32_core.cpuregs\[27\]\[2\] VGND VGND VPWR VPWR net1427 sky130_fd_sc_hd__dlygate4sd3_1
Xhold329 picorv32_core.cpuregs\[5\]\[10\] VGND VGND VPWR VPWR net1438 sky130_fd_sc_hd__dlygate4sd3_1
XFILLER_131_208 VGND VGND VPWR VPWR sky130_fd_sc_hd__decap_4
XFILLER_125_783 VGND VGND VPWR VPWR sky130_fd_sc_hd__fill_1
XFILLER_98_623 VGND VGND VPWR VPWR sky130_fd_sc_hd__decap_4
XFILLER_98_601 VGND VGND VPWR VPWR sky130_fd_sc_hd__fill_1
XFILLER_98_645 VPWR VGND VPWR VGND sky130_ef_sc_hd__decap_12
Xfanout809 net810 VGND VGND VPWR VPWR net809 sky130_fd_sc_hd__buf_2
XFILLER_97_188 VGND VGND VPWR VPWR sky130_fd_sc_hd__decap_4
X_08740_ net1448 net253 net379 VGND VGND VPWR VPWR _00888_ sky130_fd_sc_hd__mux2_1
X_05952_ net789 net956 net609 _02419_ VGND VGND VPWR VPWR _02420_ sky130_fd_sc_hd__o22a_1
Xhold1007 picorv32_core.cpuregs\[9\]\[13\] VGND VGND VPWR VPWR net2116 sky130_fd_sc_hd__dlygate4sd3_1
Xhold1029 picorv32_core.cpuregs\[17\]\[1\] VGND VGND VPWR VPWR net2138 sky130_fd_sc_hd__dlygate4sd3_1
Xhold1018 picorv32_core.cpuregs\[21\]\[7\] VGND VGND VPWR VPWR net2127 sky130_fd_sc_hd__dlygate4sd3_1
X_08671_ net264 net1662 net388 VGND VGND VPWR VPWR _00821_ sky130_fd_sc_hd__mux2_1
X_05883_ _02344_ _02346_ _02343_ VGND VGND VPWR VPWR _02357_ sky130_fd_sc_hd__a21oi_1
XFILLER_81_523 VGND VGND VPWR VPWR sky130_fd_sc_hd__decap_8
XFILLER_53_214 VGND VGND VPWR VPWR sky130_fd_sc_hd__fill_2
X_07622_ picorv32_core.cpuregs\[12\]\[6\] picorv32_core.cpuregs\[13\]\[6\] picorv32_core.cpuregs\[14\]\[6\]
+ picorv32_core.cpuregs\[15\]\[6\] net732 net699 VGND VGND VPWR VPWR _03721_ sky130_fd_sc_hd__mux4_1
XFILLER_38_288 VGND VGND VPWR VPWR sky130_fd_sc_hd__fill_1
XTAP_TAPCELL_ROW_66_1262 VGND VPWR sky130_fd_sc_hd__tapvpwrvgnd_1
X_07553_ picorv32_core.cpuregs\[12\]\[0\] picorv32_core.cpuregs\[13\]\[0\] picorv32_core.cpuregs\[14\]\[0\]
+ picorv32_core.cpuregs\[15\]\[0\] net734 net701 VGND VGND VPWR VPWR _03658_ sky130_fd_sc_hd__mux4_1
XFILLER_34_461 VGND VGND VPWR VPWR sky130_fd_sc_hd__decap_8
X_07484_ net1395 _03610_ net462 VGND VGND VPWR VPWR _00338_ sky130_fd_sc_hd__mux2_1
X_06504_ net2269 _02819_ net992 VGND VGND VPWR VPWR _02821_ sky130_fd_sc_hd__o21ai_1
XFILLER_34_472 VGND VGND VPWR VPWR sky130_fd_sc_hd__decap_4
XFILLER_139_319 VGND VGND VPWR VPWR sky130_fd_sc_hd__fill_1
X_09223_ _04410_ _04419_ VGND VGND VPWR VPWR _04420_ sky130_fd_sc_hd__nand2_1
X_06435_ net947 net949 net948 VGND VGND VPWR VPWR _02797_ sky130_fd_sc_hd__or3b_1
XFILLER_42_29 VGND VGND VPWR VPWR sky130_fd_sc_hd__fill_2
XFILLER_21_166 VGND VGND VPWR VPWR sky130_fd_sc_hd__fill_2
X_09154_ picorv32_core.cpuregs\[4\]\[0\] picorv32_core.cpuregs\[5\]\[0\] picorv32_core.cpuregs\[6\]\[0\]
+ picorv32_core.cpuregs\[7\]\[0\] net885 net854 VGND VGND VPWR VPWR _04353_ sky130_fd_sc_hd__mux4_1
X_06366_ picorv32_core.reg_pc\[25\] _02763_ VGND VGND VPWR VPWR _02767_ sky130_fd_sc_hd__nor2_1
X_08105_ net502 net2075 net414 VGND VGND VPWR VPWR _00398_ sky130_fd_sc_hd__mux2_1
X_06297_ _02707_ _02711_ net563 VGND VGND VPWR VPWR _02712_ sky130_fd_sc_hd__mux2_1
X_05317_ net914 net805 _01824_ net909 net577 VGND VGND VPWR VPWR _01825_ sky130_fd_sc_hd__a221o_1
X_09085_ net947 net948 net949 _02795_ VGND VGND VPWR VPWR _04350_ sky130_fd_sc_hd__or4_4
X_08036_ picorv32_core.cpuregs\[28\]\[29\] picorv32_core.cpuregs\[29\]\[29\] picorv32_core.cpuregs\[30\]\[29\]
+ picorv32_core.cpuregs\[31\]\[29\] net762 net729 VGND VGND VPWR VPWR _04112_ sky130_fd_sc_hd__mux4_1
XFILLER_107_249 VGND VGND VPWR VPWR sky130_fd_sc_hd__fill_1
Xhold830 net67 VGND VGND VPWR VPWR net1939 sky130_fd_sc_hd__dlygate4sd3_1
X_05248_ net943 picorv32_core.count_cycle\[35\] net602 _01760_ VGND VGND VPWR VPWR
+ _01761_ sky130_fd_sc_hd__a211o_1
Xhold841 picorv32_core.cpuregs\[4\]\[28\] VGND VGND VPWR VPWR net1950 sky130_fd_sc_hd__dlygate4sd3_1
Xhold863 picorv32_core.cpuregs\[10\]\[15\] VGND VGND VPWR VPWR net1972 sky130_fd_sc_hd__dlygate4sd3_1
Xhold852 picorv32_core.cpuregs\[13\]\[8\] VGND VGND VPWR VPWR net1961 sky130_fd_sc_hd__dlygate4sd3_1
XFILLER_103_433 VGND VGND VPWR VPWR sky130_fd_sc_hd__decap_6
Xhold896 picorv32_core.cpuregs\[7\]\[18\] VGND VGND VPWR VPWR net2005 sky130_fd_sc_hd__dlygate4sd3_1
XFILLER_88_111 VGND VGND VPWR VPWR sky130_fd_sc_hd__decap_4
Xhold885 picorv32_core.cpuregs\[29\]\[12\] VGND VGND VPWR VPWR net1994 sky130_fd_sc_hd__dlygate4sd3_1
Xhold874 picorv32_core.cpuregs\[16\]\[7\] VGND VGND VPWR VPWR net1983 sky130_fd_sc_hd__dlygate4sd3_1
X_05179_ net663 net970 VGND VGND VPWR VPWR _01702_ sky130_fd_sc_hd__nand2_1
XFILLER_131_753 VPWR VGND VPWR VGND sky130_ef_sc_hd__decap_12
X_09987_ net1506 net274 net313 VGND VGND VPWR VPWR _01464_ sky130_fd_sc_hd__mux2_1
XFILLER_131_797 VPWR VGND VPWR VGND sky130_ef_sc_hd__decap_12
XFILLER_103_499 VGND VGND VPWR VPWR sky130_fd_sc_hd__decap_4
X_08938_ net257 net1880 net355 VGND VGND VPWR VPWR _01111_ sky130_fd_sc_hd__mux2_1
XFILLER_69_380 VGND VGND VPWR VPWR sky130_fd_sc_hd__decap_4
X_08869_ net270 net1552 net363 VGND VGND VPWR VPWR _01044_ sky130_fd_sc_hd__mux2_1
XTAP_TAPCELL_ROW_4_365 VGND VPWR sky130_fd_sc_hd__tapvpwrvgnd_1
XFILLER_72_523 VGND VGND VPWR VPWR sky130_fd_sc_hd__decap_8
XFILLER_29_255 VGND VGND VPWR VPWR sky130_fd_sc_hd__decap_3
X_10900_ clknet_leaf_106_clk _00751_ VGND VGND VPWR VPWR picorv32_core.mem_rdata_q\[10\]
+ sky130_fd_sc_hd__dfxtp_1
XFILLER_45_715 VGND VGND VPWR VPWR sky130_fd_sc_hd__decap_3
XFILLER_16_41 VPWR VGND VPWR VGND sky130_ef_sc_hd__decap_12
XTAP_TAPCELL_ROW_43_927 VGND VPWR sky130_fd_sc_hd__tapvpwrvgnd_1
X_10831_ clknet_leaf_12_clk _00682_ VGND VGND VPWR VPWR picorv32_core.cpuregs\[17\]\[8\]
+ sky130_fd_sc_hd__dfxtp_1
XPHY_EDGE_ROW_11_Right_11 VGND VGND VPWR VPWR sky130_fd_sc_hd__decap_3
X_10762_ clknet_leaf_135_clk _00613_ VGND VGND VPWR VPWR picorv32_core.cpuregs\[14\]\[3\]
+ sky130_fd_sc_hd__dfxtp_1
XTAP_TAPCELL_ROW_23_640 VGND VPWR sky130_fd_sc_hd__tapvpwrvgnd_1
XFILLER_40_453 VGND VGND VPWR VPWR sky130_fd_sc_hd__decap_3
X_10693_ clknet_leaf_136_clk _00544_ VGND VGND VPWR VPWR net129 sky130_fd_sc_hd__dfxtp_1
XTAP_TAPCELL_ROW_97_1712 VGND VPWR sky130_fd_sc_hd__tapvpwrvgnd_1
XFILLER_32_95 VGND VGND VPWR VPWR sky130_fd_sc_hd__fill_2
X_11314_ clknet_leaf_95_clk _00015_ VGND VGND VPWR VPWR picorv32_core.cpu_state\[5\]
+ sky130_fd_sc_hd__dfxtp_2
XFILLER_107_772 VGND VGND VPWR VPWR sky130_fd_sc_hd__fill_1
XFILLER_4_365 VGND VGND VPWR VPWR sky130_fd_sc_hd__decap_3
X_11245_ clknet_leaf_118_clk _01093_ VGND VGND VPWR VPWR picorv32_core.cpuregs\[4\]\[0\]
+ sky130_fd_sc_hd__dfxtp_1
XPHY_EDGE_ROW_20_Right_20 VGND VGND VPWR VPWR sky130_fd_sc_hd__decap_3
X_11176_ clknet_leaf_64_clk _01027_ VGND VGND VPWR VPWR picorv32_core.cpuregs\[7\]\[30\]
+ sky130_fd_sc_hd__dfxtp_1
XFILLER_122_753 VGND VGND VPWR VPWR sky130_fd_sc_hd__decap_3
XFILLER_95_615 VGND VGND VPWR VPWR sky130_fd_sc_hd__fill_1
XFILLER_95_604 VGND VGND VPWR VPWR sky130_fd_sc_hd__decap_4
XFILLER_79_155 VGND VGND VPWR VPWR sky130_fd_sc_hd__fill_1
XFILLER_121_263 VGND VGND VPWR VPWR sky130_fd_sc_hd__fill_1
XFILLER_95_648 VGND VGND VPWR VPWR sky130_fd_sc_hd__fill_2
XTAP_TAPCELL_ROW_50_1030 VGND VPWR sky130_fd_sc_hd__tapvpwrvgnd_1
X_10127_ clknet_leaf_3_clk _00049_ VGND VGND VPWR VPWR picorv32_core.cpuregs\[22\]\[10\]
+ sky130_fd_sc_hd__dfxtp_1
XTAP_TAPCELL_ROW_124_2108 VGND VPWR sky130_fd_sc_hd__tapvpwrvgnd_1
X_10058_ net1325 net254 net306 VGND VGND VPWR VPWR _01533_ sky130_fd_sc_hd__mux2_1
XFILLER_82_309 VGND VGND VPWR VPWR sky130_fd_sc_hd__fill_1
XFILLER_0_593 VPWR VGND VPWR VGND sky130_ef_sc_hd__decap_12
XFILLER_48_542 VPWR VGND VPWR VGND sky130_ef_sc_hd__decap_12
XFILLER_75_361 VGND VGND VPWR VPWR sky130_fd_sc_hd__decap_3
XTAP_TAPCELL_ROW_106_1841 VGND VPWR sky130_fd_sc_hd__tapvpwrvgnd_1
XFILLER_73_91 VGND VGND VPWR VPWR sky130_fd_sc_hd__decap_4
XFILLER_44_781 VGND VGND VPWR VPWR sky130_fd_sc_hd__fill_2
X_06220_ net688 _02649_ net683 VGND VGND VPWR VPWR _02650_ sky130_fd_sc_hd__a21o_1
XTAP_TAPCELL_ROW_61_1192 VGND VPWR sky130_fd_sc_hd__tapvpwrvgnd_1
XTAP_TAPCELL_ROW_135_2259 VGND VPWR sky130_fd_sc_hd__tapvpwrvgnd_1
XFILLER_129_374 VGND VGND VPWR VPWR sky130_fd_sc_hd__fill_1
X_06151_ net2304 net11 net520 VGND VGND VPWR VPWR _00757_ sky130_fd_sc_hd__mux2_1
Xhold115 picorv32_core.cpuregs\[31\]\[29\] VGND VGND VPWR VPWR net1224 sky130_fd_sc_hd__dlygate4sd3_1
XFILLER_105_709 VGND VGND VPWR VPWR sky130_fd_sc_hd__decap_3
X_06082_ net608 _02160_ _02538_ VGND VGND VPWR VPWR _02540_ sky130_fd_sc_hd__a21o_1
X_05102_ _01632_ _01633_ picorv32_core.cpu_state\[5\] VGND VGND VPWR VPWR _01634_
+ sky130_fd_sc_hd__a21bo_1
XFILLER_7_181 VPWR VGND VPWR VGND sky130_ef_sc_hd__decap_12
Xhold126 picorv32_core.cpuregs\[31\]\[3\] VGND VGND VPWR VPWR net1235 sky130_fd_sc_hd__dlygate4sd3_1
Xhold104 picorv32_core.cpuregs\[30\]\[3\] VGND VGND VPWR VPWR net1213 sky130_fd_sc_hd__dlygate4sd3_1
Xhold148 picorv32_core.cpuregs\[20\]\[31\] VGND VGND VPWR VPWR net1257 sky130_fd_sc_hd__dlygate4sd3_1
Xhold137 picorv32_core.cpuregs\[28\]\[16\] VGND VGND VPWR VPWR net1246 sky130_fd_sc_hd__dlygate4sd3_1
Xhold159 _00397_ VGND VGND VPWR VPWR net1268 sky130_fd_sc_hd__dlygate4sd3_1
X_09910_ net294 net1847 net320 VGND VGND VPWR VPWR _01394_ sky130_fd_sc_hd__mux2_1
Xfanout606 net607 VGND VGND VPWR VPWR net606 sky130_fd_sc_hd__clkbuf_4
XFILLER_140_561 VGND VGND VPWR VPWR sky130_fd_sc_hd__fill_2
Xfanout639 net640 VGND VGND VPWR VPWR net639 sky130_fd_sc_hd__clkbuf_4
XFILLER_113_753 VPWR VGND VPWR VGND sky130_ef_sc_hd__decap_12
X_09841_ net611 _03538_ _05009_ VGND VGND VPWR VPWR _05010_ sky130_fd_sc_hd__and3_1
Xfanout617 net619 VGND VGND VPWR VPWR net617 sky130_fd_sc_hd__buf_4
Xfanout628 net631 VGND VGND VPWR VPWR net628 sky130_fd_sc_hd__buf_4
XFILLER_113_797 VGND VGND VPWR VPWR sky130_fd_sc_hd__decap_4
X_09772_ net284 _04929_ _04944_ _04924_ VGND VGND VPWR VPWR _01345_ sky130_fd_sc_hd__a31o_1
X_06984_ _02935_ _03185_ _03196_ VGND VGND VPWR VPWR _03197_ sky130_fd_sc_hd__a21oi_1
XPHY_EDGE_ROW_13_Left_155 VGND VGND VPWR VPWR sky130_fd_sc_hd__decap_3
X_05935_ _02391_ _02394_ _02392_ VGND VGND VPWR VPWR _02405_ sky130_fd_sc_hd__o21a_1
X_08723_ net1409 net495 net378 VGND VGND VPWR VPWR _00871_ sky130_fd_sc_hd__mux2_1
XTAP_TAPCELL_ROW_1_313 VGND VPWR sky130_fd_sc_hd__tapvpwrvgnd_1
XTAP_TAPCELL_ROW_1_324 VGND VPWR sky130_fd_sc_hd__tapvpwrvgnd_1
X_05866_ net961 _02331_ net669 VGND VGND VPWR VPWR _02341_ sky130_fd_sc_hd__o21a_1
X_08654_ _02795_ _04322_ VGND VGND VPWR VPWR _04335_ sky130_fd_sc_hd__or2_2
X_08585_ net498 net1685 net395 VGND VGND VPWR VPWR _00708_ sky130_fd_sc_hd__mux2_1
X_07605_ picorv32_core.cpuregs\[0\]\[5\] picorv32_core.cpuregs\[1\]\[5\] picorv32_core.cpuregs\[2\]\[5\]
+ picorv32_core.cpuregs\[3\]\[5\] net733 net700 VGND VGND VPWR VPWR _03705_ sky130_fd_sc_hd__mux4_1
X_05797_ net966 _02277_ VGND VGND VPWR VPWR _02278_ sky130_fd_sc_hd__xnor2_1
XFILLER_81_375 VPWR VGND VPWR VGND sky130_ef_sc_hd__decap_12
X_07536_ net972 net675 net587 picorv32_core.instr_jalr VGND VGND VPWR VPWR _03645_
+ sky130_fd_sc_hd__or4b_1
XFILLER_139_105 VGND VGND VPWR VPWR sky130_fd_sc_hd__decap_6
X_07467_ picorv32_core.reg_out\[9\] picorv32_core.reg_next_pc\[9\] net557 VGND VGND
+ VPWR VPWR _03599_ sky130_fd_sc_hd__mux2_1
X_09206_ picorv32_core.cpuregs\[0\]\[2\] picorv32_core.cpuregs\[1\]\[2\] picorv32_core.cpuregs\[2\]\[2\]
+ picorv32_core.cpuregs\[3\]\[2\] net884 net851 VGND VGND VPWR VPWR _04403_ sky130_fd_sc_hd__mux4_1
XPHY_EDGE_ROW_22_Left_164 VGND VGND VPWR VPWR sky130_fd_sc_hd__decap_3
XFILLER_22_475 VGND VGND VPWR VPWR sky130_fd_sc_hd__fill_1
XFILLER_139_149 VGND VGND VPWR VPWR sky130_fd_sc_hd__decap_4
X_07398_ _03400_ _03536_ _03397_ _03398_ _03399_ VGND VGND VPWR VPWR _03538_ sky130_fd_sc_hd__o2111ai_2
X_06418_ net269 net1542 net422 VGND VGND VPWR VPWR _00086_ sky130_fd_sc_hd__mux2_1
X_06349_ picorv32_core.reg_out\[22\] picorv32_core.alu_out_q\[22\] net952 VGND VGND
+ VPWR VPWR _02753_ sky130_fd_sc_hd__mux2_1
X_09137_ net1432 net256 net330 VGND VGND VPWR VPWR _01303_ sky130_fd_sc_hd__mux2_1
XTAP_TAPCELL_ROW_79_1453 VGND VPWR sky130_fd_sc_hd__tapvpwrvgnd_1
X_09068_ net1357 net268 net338 VGND VGND VPWR VPWR _01236_ sky130_fd_sc_hd__mux2_1
X_08019_ picorv32_core.cpuregs\[4\]\[28\] picorv32_core.cpuregs\[5\]\[28\] picorv32_core.cpuregs\[6\]\[28\]
+ picorv32_core.cpuregs\[7\]\[28\] net754 net721 VGND VGND VPWR VPWR _04096_ sky130_fd_sc_hd__mux4_1
XFILLER_2_825 VGND VGND VPWR VPWR sky130_fd_sc_hd__decap_8
XTAP_TAPCELL_ROW_92_1642 VGND VPWR sky130_fd_sc_hd__tapvpwrvgnd_1
Xhold660 picorv32_core.cpuregs\[24\]\[13\] VGND VGND VPWR VPWR net1769 sky130_fd_sc_hd__dlygate4sd3_1
XTAP_TAPCELL_ROW_9_435 VGND VPWR sky130_fd_sc_hd__tapvpwrvgnd_1
Xhold671 picorv32_core.cpuregs\[1\]\[1\] VGND VGND VPWR VPWR net1780 sky130_fd_sc_hd__dlygate4sd3_1
Xhold693 picorv32_core.cpuregs\[1\]\[19\] VGND VGND VPWR VPWR net1802 sky130_fd_sc_hd__dlygate4sd3_1
X_11030_ clknet_leaf_8_clk _00881_ VGND VGND VPWR VPWR picorv32_core.cpuregs\[11\]\[12\]
+ sky130_fd_sc_hd__dfxtp_1
XPHY_EDGE_ROW_31_Left_173 VGND VGND VPWR VPWR sky130_fd_sc_hd__decap_3
Xhold682 picorv32_core.cpuregs\[2\]\[8\] VGND VGND VPWR VPWR net1791 sky130_fd_sc_hd__dlygate4sd3_1
XFILLER_134_53 VPWR VGND VPWR VGND sky130_ef_sc_hd__decap_12
XFILLER_134_97 VPWR VGND VPWR VGND sky130_ef_sc_hd__decap_12
XFILLER_91_117 VGND VGND VPWR VPWR sky130_fd_sc_hd__fill_1
XFILLER_85_670 VGND VGND VPWR VPWR sky130_fd_sc_hd__fill_2
XFILLER_64_309 VGND VGND VPWR VPWR sky130_fd_sc_hd__fill_2
XFILLER_57_372 VPWR VGND VPWR VGND sky130_ef_sc_hd__decap_12
XTAP_TAPCELL_ROW_28_710 VGND VPWR sky130_fd_sc_hd__tapvpwrvgnd_1
XFILLER_33_729 VGND VGND VPWR VPWR sky130_fd_sc_hd__fill_2
X_11863_ net964 VGND VGND VPWR VPWR net200 sky130_fd_sc_hd__clkbuf_2
X_10814_ clknet_leaf_43_clk _00665_ VGND VGND VPWR VPWR picorv32_core.cpuregs\[15\]\[23\]
+ sky130_fd_sc_hd__dfxtp_1
XFILLER_26_781 VPWR VGND VPWR VGND sky130_ef_sc_hd__decap_12
XPHY_EDGE_ROW_40_Left_182 VGND VGND VPWR VPWR sky130_fd_sc_hd__decap_3
X_10745_ clknet_leaf_88_clk _00596_ VGND VGND VPWR VPWR picorv32_core.decoded_imm\[14\]
+ sky130_fd_sc_hd__dfxtp_2
XTAP_TAPCELL_ROW_101_1771 VGND VPWR sky130_fd_sc_hd__tapvpwrvgnd_1
X_10676_ clknet_leaf_95_clk _00530_ VGND VGND VPWR VPWR picorv32_core.decoded_imm_j\[3\]
+ sky130_fd_sc_hd__dfxtp_2
Xpicorv32_axi_1070 VGND VGND VPWR VPWR picorv32_axi_1070/HI pcpi_insn[30] sky130_fd_sc_hd__conb_1
Xpicorv32_axi_1081 VGND VGND VPWR VPWR picorv32_axi_1081/HI trace_data[8] sky130_fd_sc_hd__conb_1
Xpicorv32_axi_1092 VGND VGND VPWR VPWR picorv32_axi_1092/HI trace_data[19] sky130_fd_sc_hd__conb_1
XTAP_TAPCELL_ROW_130_2189 VGND VPWR sky130_fd_sc_hd__tapvpwrvgnd_1
X_11228_ clknet_leaf_21_clk _01079_ VGND VGND VPWR VPWR picorv32_core.cpuregs\[5\]\[18\]
+ sky130_fd_sc_hd__dfxtp_1
XFILLER_4_195 VGND VGND VPWR VPWR sky130_fd_sc_hd__fill_1
XFILLER_4_77 VGND VGND VPWR VPWR sky130_fd_sc_hd__decap_6
XFILLER_110_734 VPWR VGND VPWR VGND sky130_ef_sc_hd__decap_12
X_11159_ clknet_leaf_15_clk _01010_ VGND VGND VPWR VPWR picorv32_core.cpuregs\[7\]\[13\]
+ sky130_fd_sc_hd__dfxtp_1
XFILLER_95_445 VGND VGND VPWR VPWR sky130_fd_sc_hd__decap_3
XFILLER_67_169 VGND VGND VPWR VPWR sky130_fd_sc_hd__decap_4
X_05720_ net189 _02157_ VGND VGND VPWR VPWR _02204_ sky130_fd_sc_hd__nand2_1
XFILLER_63_353 VPWR VGND VPWR VGND sky130_ef_sc_hd__decap_12
X_05651_ net815 net966 VGND VGND VPWR VPWR _02135_ sky130_fd_sc_hd__or2_1
X_08370_ net962 net188 net581 VGND VGND VPWR VPWR _04260_ sky130_fd_sc_hd__mux2_1
X_05582_ net945 picorv32_core.count_cycle\[59\] net603 _02070_ VGND VGND VPWR VPWR
+ _02071_ sky130_fd_sc_hd__a211o_1
XTAP_TAPCELL_ROW_63_1221 VGND VPWR sky130_fd_sc_hd__tapvpwrvgnd_1
X_07321_ net823 picorv32_core.decoded_imm\[0\] VGND VGND VPWR VPWR _03461_ sky130_fd_sc_hd__nand2_1
X_07252_ _01591_ _01637_ VGND VGND VPWR VPWR _03392_ sky130_fd_sc_hd__nand2_2
X_07183_ picorv32_core.count_cycle\[40\] _03344_ _03346_ VGND VGND VPWR VPWR _00301_
+ sky130_fd_sc_hd__o21a_1
X_06203_ picorv32_core.cpuregs\[28\]\[3\] picorv32_core.cpuregs\[29\]\[3\] picorv32_core.cpuregs\[30\]\[3\]
+ picorv32_core.cpuregs\[31\]\[3\] net743 net710 VGND VGND VPWR VPWR _02634_ sky130_fd_sc_hd__mux4_1
X_06134_ _02578_ _02581_ _02587_ VGND VGND VPWR VPWR _02588_ sky130_fd_sc_hd__o21ai_1
X_06065_ net773 net189 net608 _02524_ VGND VGND VPWR VPWR _02525_ sky130_fd_sc_hd__o22a_1
XFILLER_132_347 VGND VGND VPWR VPWR sky130_fd_sc_hd__decap_4
XTAP_TAPCELL_ROW_74_1383 VGND VPWR sky130_fd_sc_hd__tapvpwrvgnd_1
XTAP_TAPCELL_ROW_74_1372 VGND VPWR sky130_fd_sc_hd__tapvpwrvgnd_1
Xfanout403 _04326_ VGND VGND VPWR VPWR net403 sky130_fd_sc_hd__buf_4
Xfanout414 net415 VGND VGND VPWR VPWR net414 sky130_fd_sc_hd__buf_4
X_09824_ picorv32_core.cpuregs\[16\]\[29\] picorv32_core.cpuregs\[17\]\[29\] picorv32_core.cpuregs\[18\]\[29\]
+ picorv32_core.cpuregs\[19\]\[29\] net904 net869 VGND VGND VPWR VPWR _04994_ sky130_fd_sc_hd__mux4_1
Xfanout425 _02796_ VGND VGND VPWR VPWR net425 sky130_fd_sc_hd__buf_2
Xfanout436 _02667_ VGND VGND VPWR VPWR net436 sky130_fd_sc_hd__buf_2
XFILLER_101_701 VPWR VGND VPWR VGND sky130_ef_sc_hd__decap_12
Xfanout447 _02687_ VGND VGND VPWR VPWR net447 sky130_fd_sc_hd__clkbuf_2
XFILLER_98_294 VGND VGND VPWR VPWR sky130_fd_sc_hd__fill_1
Xfanout458 net459 VGND VGND VPWR VPWR net458 sky130_fd_sc_hd__buf_4
XFILLER_58_125 VGND VGND VPWR VPWR sky130_fd_sc_hd__decap_4
Xfanout469 _01705_ VGND VGND VPWR VPWR net469 sky130_fd_sc_hd__buf_2
X_09755_ net472 _04869_ _04927_ _04926_ VGND VGND VPWR VPWR _04928_ sky130_fd_sc_hd__a31o_1
X_06967_ _03177_ _03179_ VGND VGND VPWR VPWR _03181_ sky130_fd_sc_hd__and2_1
XFILLER_58_158 VGND VGND VPWR VPWR sky130_fd_sc_hd__fill_1
XFILLER_46_309 VGND VGND VPWR VPWR sky130_fd_sc_hd__fill_2
X_09686_ net833 _04859_ _04862_ net480 VGND VGND VPWR VPWR _04863_ sky130_fd_sc_hd__o211a_1
X_08706_ net1828 net255 net384 VGND VGND VPWR VPWR _00855_ sky130_fd_sc_hd__mux2_1
X_06898_ picorv32_core.decoded_imm_j\[15\] _02927_ _03106_ VGND VGND VPWR VPWR _03117_
+ sky130_fd_sc_hd__a21oi_1
XFILLER_73_139 VGND VGND VPWR VPWR sky130_fd_sc_hd__decap_4
X_05918_ net957 _02331_ _02374_ net672 VGND VGND VPWR VPWR _02389_ sky130_fd_sc_hd__o31a_1
X_08637_ net1411 net269 net392 VGND VGND VPWR VPWR _00788_ sky130_fd_sc_hd__mux2_1
XFILLER_70_813 VGND VGND VPWR VPWR sky130_fd_sc_hd__fill_1
X_05849_ net807 net962 net573 VGND VGND VPWR VPWR _02326_ sky130_fd_sc_hd__a21oi_1
XFILLER_15_729 VPWR VGND VPWR VGND sky130_ef_sc_hd__decap_12
X_08568_ net252 net2048 net400 VGND VGND VPWR VPWR _00693_ sky130_fd_sc_hd__mux2_1
XFILLER_81_194 VGND VGND VPWR VPWR sky130_fd_sc_hd__decap_3
X_07519_ net770 _03633_ net535 VGND VGND VPWR VPWR _03634_ sky130_fd_sc_hd__mux2_1
X_08499_ net1775 net252 net408 VGND VGND VPWR VPWR _00629_ sky130_fd_sc_hd__mux2_1
X_10530_ clknet_leaf_56_clk picorv32_core.alu_out\[18\] VGND VGND VPWR VPWR picorv32_core.alu_out_q\[18\]
+ sky130_fd_sc_hd__dfxtp_1
XTAP_TAPCELL_ROW_33_790 VGND VPWR sky130_fd_sc_hd__tapvpwrvgnd_1
X_10461_ clknet_leaf_64_clk _00348_ VGND VGND VPWR VPWR net53 sky130_fd_sc_hd__dfxtp_1
XFILLER_135_163 VGND VGND VPWR VPWR sky130_fd_sc_hd__decap_4
X_10392_ clknet_leaf_82_clk _00311_ VGND VGND VPWR VPWR picorv32_core.count_cycle\[50\]
+ sky130_fd_sc_hd__dfxtp_1
XFILLER_135_185 VGND VGND VPWR VPWR sky130_fd_sc_hd__decap_6
Xhold490 picorv32_core.cpuregs\[20\]\[26\] VGND VGND VPWR VPWR net1599 sky130_fd_sc_hd__dlygate4sd3_1
XFILLER_123_369 VGND VGND VPWR VPWR sky130_fd_sc_hd__decap_3
X_11013_ clknet_leaf_43_clk _00864_ VGND VGND VPWR VPWR picorv32_core.cpuregs\[12\]\[27\]
+ sky130_fd_sc_hd__dfxtp_1
Xfanout970 picorv32_core.decoder_trigger VGND VGND VPWR VPWR net970 sky130_fd_sc_hd__buf_2
XFILLER_77_489 VPWR VGND VPWR VGND sky130_ef_sc_hd__decap_12
Xfanout992 net993 VGND VGND VPWR VPWR net992 sky130_fd_sc_hd__clkbuf_2
Xfanout981 net988 VGND VGND VPWR VPWR net981 sky130_fd_sc_hd__clkbuf_4
XFILLER_58_681 VPWR VGND VPWR VGND sky130_ef_sc_hd__decap_12
Xhold1190 picorv32_core.count_instr\[22\] VGND VGND VPWR VPWR net2299 sky130_fd_sc_hd__dlygate4sd3_1
XTAP_TAPCELL_ROW_103_1800 VGND VPWR sky130_fd_sc_hd__tapvpwrvgnd_1
X_11846_ net49 VGND VGND VPWR VPWR net81 sky130_fd_sc_hd__clkbuf_1
XTAP_TAPCELL_ROW_119_2029 VGND VPWR sky130_fd_sc_hd__tapvpwrvgnd_1
X_10728_ clknet_leaf_87_clk _00579_ VGND VGND VPWR VPWR picorv32_core.decoded_imm\[31\]
+ sky130_fd_sc_hd__dfxtp_2
XTAP_TAPCELL_ROW_31_749 VGND VPWR sky130_fd_sc_hd__tapvpwrvgnd_1
XFILLER_9_254 VGND VGND VPWR VPWR sky130_fd_sc_hd__fill_1
X_10659_ clknet_leaf_43_clk _00513_ VGND VGND VPWR VPWR picorv32_core.cpuregs\[20\]\[27\]
+ sky130_fd_sc_hd__dfxtp_1
XTAP_TAPCELL_ROW_132_2218 VGND VPWR sky130_fd_sc_hd__tapvpwrvgnd_1
Xclkload13 clknet_4_14_0_clk VGND VGND VPWR VPWR clkload13/Y sky130_fd_sc_hd__clkinvlp_4
Xclkload24 clknet_leaf_7_clk VGND VGND VPWR VPWR clkload24/Y sky130_fd_sc_hd__inv_6
XTAP_TAPCELL_ROW_11_462 VGND VPWR sky130_fd_sc_hd__tapvpwrvgnd_1
Xclkload35 clknet_leaf_137_clk VGND VGND VPWR VPWR clkload35/Y sky130_fd_sc_hd__clkinvlp_4
Xclkload57 clknet_leaf_35_clk VGND VGND VPWR VPWR clkload57/Y sky130_fd_sc_hd__inv_6
Xclkload68 clknet_leaf_53_clk VGND VGND VPWR VPWR clkload68/Y sky130_fd_sc_hd__inv_8
Xclkload46 clknet_leaf_23_clk VGND VGND VPWR VPWR clkload46/Y sky130_fd_sc_hd__clkinvlp_4
XFILLER_126_163 VGND VGND VPWR VPWR sky130_fd_sc_hd__fill_1
Xclkload79 clknet_leaf_50_clk VGND VGND VPWR VPWR clkload79/X sky130_fd_sc_hd__clkbuf_8
XFILLER_5_471 VGND VGND VPWR VPWR sky130_fd_sc_hd__fill_1
XTAP_TAPCELL_ROW_114_1962 VGND VPWR sky130_fd_sc_hd__tapvpwrvgnd_1
XTAP_TAPCELL_ROW_114_1951 VGND VPWR sky130_fd_sc_hd__tapvpwrvgnd_1
XFILLER_48_3 VGND VGND VPWR VPWR sky130_fd_sc_hd__fill_1
XFILLER_96_721 VGND VGND VPWR VPWR sky130_fd_sc_hd__decap_8
XFILLER_95_242 VGND VGND VPWR VPWR sky130_fd_sc_hd__fill_1
X_07870_ _03954_ _03955_ net458 _03952_ VGND VGND VPWR VPWR _03956_ sky130_fd_sc_hd__o211a_1
XFILLER_68_489 VGND VGND VPWR VPWR sky130_fd_sc_hd__decap_4
X_06821_ picorv32_core.decoded_imm_j\[11\] _02923_ VGND VGND VPWR VPWR _03046_ sky130_fd_sc_hd__and2_1
X_09540_ net657 _04722_ VGND VGND VPWR VPWR _04723_ sky130_fd_sc_hd__or2_1
XFILLER_55_117 VGND VGND VPWR VPWR sky130_fd_sc_hd__fill_1
XFILLER_37_832 VGND VGND VPWR VPWR sky130_fd_sc_hd__fill_2
X_06752_ _02916_ _02917_ _02960_ VGND VGND VPWR VPWR _02983_ sky130_fd_sc_hd__and3_1
X_05703_ _02185_ _02186_ _02184_ VGND VGND VPWR VPWR _02187_ sky130_fd_sc_hd__a21o_1
X_09471_ net798 net794 net546 VGND VGND VPWR VPWR _04657_ sky130_fd_sc_hd__mux2_1
XFILLER_36_353 VGND VGND VPWR VPWR sky130_fd_sc_hd__fill_1
X_06683_ _02740_ picorv32_core.reg_next_pc\[19\] net558 VGND VGND VPWR VPWR _02931_
+ sky130_fd_sc_hd__mux2_2
X_08422_ picorv32_core.decoded_imm\[26\] net528 net442 _04291_ VGND VGND VPWR VPWR
+ _00584_ sky130_fd_sc_hd__o22a_1
XTAP_TAPCELL_ROW_19_584 VGND VPWR sky130_fd_sc_hd__tapvpwrvgnd_1
XFILLER_34_19 VGND VGND VPWR VPWR sky130_fd_sc_hd__fill_1
X_05634_ picorv32_core.count_cycle\[31\] net601 VGND VGND VPWR VPWR _02119_ sky130_fd_sc_hd__or2_1
XFILLER_63_194 VGND VGND VPWR VPWR sky130_fd_sc_hd__fill_2
XFILLER_63_183 VGND VGND VPWR VPWR sky130_fd_sc_hd__fill_2
XFILLER_24_548 VGND VGND VPWR VPWR sky130_fd_sc_hd__fill_2
X_05565_ _02053_ _02054_ VGND VGND VPWR VPWR _02055_ sky130_fd_sc_hd__nand2_1
X_08353_ net928 net962 net179 net927 VGND VGND VPWR VPWR _04251_ sky130_fd_sc_hd__a22o_1
XFILLER_51_389 VGND VGND VPWR VPWR sky130_fd_sc_hd__decap_3
X_08284_ net1251 net241 net412 VGND VGND VPWR VPWR _00508_ sky130_fd_sc_hd__mux2_1
X_07304_ net803 picorv32_core.decoded_imm\[9\] VGND VGND VPWR VPWR _03444_ sky130_fd_sc_hd__or2_1
X_07235_ _03379_ net995 _03378_ VGND VGND VPWR VPWR _00320_ sky130_fd_sc_hd__and3b_1
X_05496_ net911 net302 _01987_ _01991_ VGND VGND VPWR VPWR _01992_ sky130_fd_sc_hd__a31o_1
XFILLER_50_29 VGND VGND VPWR VPWR sky130_fd_sc_hd__fill_1
XFILLER_50_18 VGND VGND VPWR VPWR sky130_fd_sc_hd__fill_2
Xclkload7 clknet_4_8_0_clk VGND VGND VPWR VPWR clkload7/X sky130_fd_sc_hd__clkbuf_8
XTAP_TAPCELL_ROW_76_1412 VGND VPWR sky130_fd_sc_hd__tapvpwrvgnd_1
XTAP_TAPCELL_ROW_76_1401 VGND VPWR sky130_fd_sc_hd__tapvpwrvgnd_1
X_07166_ picorv32_core.count_cycle\[34\] _03334_ net973 VGND VGND VPWR VPWR _03336_
+ sky130_fd_sc_hd__a21oi_1
XFILLER_117_185 VGND VGND VPWR VPWR sky130_fd_sc_hd__fill_2
X_06117_ net508 _02572_ _02562_ _02560_ VGND VGND VPWR VPWR picorv32_core.alu_out\[28\]
+ sky130_fd_sc_hd__a211o_1
X_07097_ picorv32_core.count_cycle\[7\] picorv32_core.count_cycle\[8\] _03289_ VGND
+ VGND VPWR VPWR _03293_ sky130_fd_sc_hd__and3_1
X_06048_ net188 _02508_ VGND VGND VPWR VPWR _02509_ sky130_fd_sc_hd__xnor2_1
XFILLER_1_9 VPWR VGND VPWR VGND sky130_ef_sc_hd__decap_12
Xfanout222 net224 VGND VGND VPWR VPWR net222 sky130_fd_sc_hd__clkbuf_2
Xfanout211 _02791_ VGND VGND VPWR VPWR net211 sky130_fd_sc_hd__clkbuf_2
XFILLER_113_391 VGND VGND VPWR VPWR sky130_fd_sc_hd__fill_1
Xfanout233 net235 VGND VGND VPWR VPWR net233 sky130_fd_sc_hd__dlymetal6s2s_1
Xfanout244 _02752_ VGND VGND VPWR VPWR net244 sky130_fd_sc_hd__clkbuf_2
Xfanout255 _02739_ VGND VGND VPWR VPWR net255 sky130_fd_sc_hd__clkbuf_2
X_09807_ picorv32_core.cpuregs\[0\]\[28\] picorv32_core.cpuregs\[1\]\[28\] picorv32_core.cpuregs\[2\]\[28\]
+ picorv32_core.cpuregs\[3\]\[28\] net896 net862 VGND VGND VPWR VPWR _04978_ sky130_fd_sc_hd__mux4_1
X_07999_ picorv32_core.cpuregs\[8\]\[27\] picorv32_core.cpuregs\[9\]\[27\] picorv32_core.cpuregs\[10\]\[27\]
+ picorv32_core.cpuregs\[11\]\[27\] net756 net723 VGND VGND VPWR VPWR _04077_ sky130_fd_sc_hd__mux4_1
Xfanout266 net267 VGND VGND VPWR VPWR net266 sky130_fd_sc_hd__clkbuf_2
Xfanout277 net279 VGND VGND VPWR VPWR net277 sky130_fd_sc_hd__clkbuf_2
Xfanout288 net289 VGND VGND VPWR VPWR net288 sky130_fd_sc_hd__clkbuf_2
XFILLER_59_478 VGND VGND VPWR VPWR sky130_fd_sc_hd__decap_3
Xfanout299 _02703_ VGND VGND VPWR VPWR net299 sky130_fd_sc_hd__buf_1
X_09738_ picorv32_core.cpuregs\[16\]\[25\] picorv32_core.cpuregs\[17\]\[25\] picorv32_core.cpuregs\[18\]\[25\]
+ picorv32_core.cpuregs\[19\]\[25\] net904 net869 VGND VGND VPWR VPWR _04912_ sky130_fd_sc_hd__mux4_1
XFILLER_101_597 VGND VGND VPWR VPWR sky130_fd_sc_hd__fill_1
XTAP_TAPCELL_ROW_87_1563 VGND VPWR sky130_fd_sc_hd__tapvpwrvgnd_1
X_09669_ net786 net542 _04845_ net472 VGND VGND VPWR VPWR _04846_ sky130_fd_sc_hd__o211a_1
XFILLER_55_673 VGND VGND VPWR VPWR sky130_fd_sc_hd__fill_2
XFILLER_15_526 VGND VGND VPWR VPWR sky130_fd_sc_hd__fill_1
XTAP_TAPCELL_ROW_38_860 VGND VPWR sky130_fd_sc_hd__tapvpwrvgnd_1
X_11700_ clknet_leaf_22_clk _01531_ VGND VGND VPWR VPWR picorv32_core.cpuregs\[27\]\[17\]
+ sky130_fd_sc_hd__dfxtp_1
XFILLER_54_194 VGND VGND VPWR VPWR sky130_fd_sc_hd__fill_2
X_11631_ clknet_leaf_10_clk _01462_ VGND VGND VPWR VPWR picorv32_core.cpuregs\[28\]\[12\]
+ sky130_fd_sc_hd__dfxtp_1
XFILLER_30_529 VGND VGND VPWR VPWR sky130_fd_sc_hd__decap_3
XFILLER_24_85 VGND VGND VPWR VPWR sky130_fd_sc_hd__fill_2
X_11562_ clknet_leaf_144_clk _01393_ VGND VGND VPWR VPWR picorv32_core.cpuregs\[2\]\[9\]
+ sky130_fd_sc_hd__dfxtp_1
XFILLER_11_765 VPWR VGND VPWR VGND sky130_ef_sc_hd__decap_12
XFILLER_7_725 VGND VGND VPWR VPWR sky130_fd_sc_hd__decap_3
X_10513_ clknet_leaf_128_clk picorv32_core.alu_out\[1\] VGND VGND VPWR VPWR picorv32_core.alu_out_q\[1\]
+ sky130_fd_sc_hd__dfxtp_1
X_11493_ clknet_leaf_126_clk _01329_ VGND VGND VPWR VPWR net142 sky130_fd_sc_hd__dfxtp_1
X_10444_ clknet_leaf_117_clk _00331_ VGND VGND VPWR VPWR net66 sky130_fd_sc_hd__dfxtp_1
X_10375_ clknet_leaf_104_clk _00294_ VGND VGND VPWR VPWR picorv32_core.count_cycle\[33\]
+ sky130_fd_sc_hd__dfxtp_1
XTAP_TAPCELL_ROW_129_2180 VGND VPWR sky130_fd_sc_hd__tapvpwrvgnd_1
XFILLER_1_45 VGND VGND VPWR VPWR sky130_fd_sc_hd__decap_8
XFILLER_80_429 VGND VGND VPWR VPWR sky130_fd_sc_hd__decap_3
XFILLER_34_813 VPWR VGND VPWR VGND sky130_ef_sc_hd__decap_12
XTAP_TAPCELL_ROW_16_532 VGND VPWR sky130_fd_sc_hd__tapvpwrvgnd_1
XFILLER_33_334 VGND VGND VPWR VPWR sky130_fd_sc_hd__fill_2
X_11829_ net62 VGND VGND VPWR VPWR net94 sky130_fd_sc_hd__clkbuf_1
XTAP_TAPCELL_ROW_16_543 VGND VPWR sky130_fd_sc_hd__tapvpwrvgnd_1
X_05350_ _01854_ _01855_ VGND VGND VPWR VPWR _01856_ sky130_fd_sc_hd__nand2_1
XPHY_EDGE_ROW_112_Right_112 VGND VGND VPWR VPWR sky130_fd_sc_hd__decap_3
Xclkload113 clknet_leaf_56_clk VGND VGND VPWR VPWR clkload113/Y sky130_fd_sc_hd__clkinv_8
Xclkload102 clknet_leaf_108_clk VGND VGND VPWR VPWR clkload102/Y sky130_fd_sc_hd__clkinv_4
X_05281_ _01790_ VGND VGND VPWR VPWR _01791_ sky130_fd_sc_hd__inv_2
Xclkload124 clknet_leaf_66_clk VGND VGND VPWR VPWR clkload124/Y sky130_fd_sc_hd__inv_6
X_07020_ _03228_ _03229_ net990 VGND VGND VPWR VPWR _00255_ sky130_fd_sc_hd__o21a_1
Xclkload135 clknet_leaf_86_clk VGND VGND VPWR VPWR clkload135/Y sky130_fd_sc_hd__inv_6
XTAP_TAPCELL_ROW_58_1153 VGND VPWR sky130_fd_sc_hd__tapvpwrvgnd_1
XTAP_TAPCELL_ROW_58_1142 VGND VPWR sky130_fd_sc_hd__tapvpwrvgnd_1
XPHY_EDGE_ROW_49_Right_49 VGND VGND VPWR VPWR sky130_fd_sc_hd__decap_3
XFILLER_103_818 VGND VGND VPWR VPWR sky130_fd_sc_hd__fill_1
X_08971_ net1657 net257 net350 VGND VGND VPWR VPWR _01143_ sky130_fd_sc_hd__mux2_1
Xhold19 picorv32_core.cpuregs\[0\]\[23\] VGND VGND VPWR VPWR net1128 sky130_fd_sc_hd__dlygate4sd3_1
X_07922_ _03996_ _03997_ net637 VGND VGND VPWR VPWR _04005_ sky130_fd_sc_hd__mux2_1
XTAP_TAPCELL_ROW_71_1331 VGND VPWR sky130_fd_sc_hd__tapvpwrvgnd_1
X_07853_ net182 net512 _03938_ _03939_ VGND VGND VPWR VPWR _00378_ sky130_fd_sc_hd__o22a_1
XFILLER_69_765 VGND VGND VPWR VPWR sky130_fd_sc_hd__fill_2
XFILLER_68_253 VGND VGND VPWR VPWR sky130_fd_sc_hd__decap_4
XFILLER_83_201 VGND VGND VPWR VPWR sky130_fd_sc_hd__fill_2
XFILLER_69_798 VGND VGND VPWR VPWR sky130_fd_sc_hd__fill_1
XFILLER_56_437 VGND VGND VPWR VPWR sky130_fd_sc_hd__decap_4
X_06804_ _02921_ _03012_ net663 VGND VGND VPWR VPWR _03031_ sky130_fd_sc_hd__o21a_1
XFILLER_28_128 VGND VGND VPWR VPWR sky130_fd_sc_hd__decap_4
X_07784_ picorv32_core.cpuregs\[28\]\[15\] picorv32_core.cpuregs\[29\]\[15\] picorv32_core.cpuregs\[30\]\[15\]
+ picorv32_core.cpuregs\[31\]\[15\] net740 net707 VGND VGND VPWR VPWR _03874_ sky130_fd_sc_hd__mux4_1
XPHY_EDGE_ROW_58_Right_58 VGND VGND VPWR VPWR sky130_fd_sc_hd__decap_3
X_09523_ net655 _04706_ VGND VGND VPWR VPWR _04707_ sky130_fd_sc_hd__or2_1
XFILLER_24_301 VGND VGND VPWR VPWR sky130_fd_sc_hd__fill_1
XFILLER_37_673 VGND VGND VPWR VPWR sky130_fd_sc_hd__fill_1
X_06735_ _02963_ _02966_ VGND VGND VPWR VPWR _02967_ sky130_fd_sc_hd__nor2_1
X_06666_ picorv32_core.reg_pc\[10\] net552 _02922_ net515 VGND VGND VPWR VPWR _00208_
+ sky130_fd_sc_hd__a22o_1
X_09454_ picorv32_core.cpuregs\[24\]\[12\] picorv32_core.cpuregs\[25\]\[12\] picorv32_core.cpuregs\[26\]\[12\]
+ picorv32_core.cpuregs\[27\]\[12\] net879 net846 VGND VGND VPWR VPWR _04641_ sky130_fd_sc_hd__mux4_1
X_05617_ picorv32_core.reg_pc\[30\] picorv32_core.decoded_imm\[30\] VGND VGND VPWR
+ VPWR _02103_ sky130_fd_sc_hd__or2_1
XFILLER_101_57 VGND VGND VPWR VPWR sky130_fd_sc_hd__decap_6
XFILLER_52_687 VGND VGND VPWR VPWR sky130_fd_sc_hd__decap_4
X_09385_ picorv32_core.cpuregs\[16\]\[9\] picorv32_core.cpuregs\[17\]\[9\] picorv32_core.cpuregs\[18\]\[9\]
+ picorv32_core.cpuregs\[19\]\[9\] net873 net840 VGND VGND VPWR VPWR _04575_ sky130_fd_sc_hd__mux4_1
X_08405_ net982 net205 _01625_ _04278_ _04280_ VGND VGND VPWR VPWR _04281_ sky130_fd_sc_hd__a311o_1
XTAP_TAPCELL_ROW_82_1493 VGND VPWR sky130_fd_sc_hd__tapvpwrvgnd_1
X_06597_ net2247 _02878_ net992 VGND VGND VPWR VPWR _02880_ sky130_fd_sc_hd__o21ai_1
X_08336_ _01595_ net959 net451 _04239_ VGND VGND VPWR VPWR _04240_ sky130_fd_sc_hd__a211o_1
XFILLER_138_737 VPWR VGND VPWR VGND sky130_ef_sc_hd__decap_12
X_05548_ net580 _02038_ _02039_ net774 net916 VGND VGND VPWR VPWR _02040_ sky130_fd_sc_hd__a32o_1
XFILLER_137_225 VGND VGND VPWR VPWR sky130_fd_sc_hd__fill_1
XFILLER_137_214 VGND VGND VPWR VPWR sky130_fd_sc_hd__fill_2
X_05479_ net578 _01974_ _01975_ net784 net917 VGND VGND VPWR VPWR _01976_ sky130_fd_sc_hd__a32o_1
X_08267_ net1350 net449 net410 VGND VGND VPWR VPWR _00491_ sky130_fd_sc_hd__mux2_1
Xclkbuf_leaf_140_clk clknet_4_2_0_clk VGND VGND VPWR VPWR clknet_leaf_140_clk sky130_fd_sc_hd__clkbuf_8
X_07218_ picorv32_core.count_cycle\[52\] picorv32_core.count_cycle\[53\] _03365_ VGND
+ VGND VPWR VPWR _03369_ sky130_fd_sc_hd__and3_1
XPHY_EDGE_ROW_67_Right_67 VGND VGND VPWR VPWR sky130_fd_sc_hd__decap_3
X_08198_ picorv32_core.mem_rdata_q\[29\] picorv32_core.mem_rdata_q\[31\] VGND VGND
+ VPWR VPWR _04203_ sky130_fd_sc_hd__nor2_1
X_07149_ _03324_ _03325_ VGND VGND VPWR VPWR _00288_ sky130_fd_sc_hd__nor2_1
XFILLER_3_205 VPWR VGND VPWR VGND sky130_ef_sc_hd__decap_12
XFILLER_106_645 VPWR VGND VPWR VGND sky130_ef_sc_hd__decap_12
XFILLER_3_249 VGND VGND VPWR VPWR sky130_fd_sc_hd__decap_4
XFILLER_10_65 VPWR VGND VPWR VGND sky130_ef_sc_hd__decap_12
XPHY_EDGE_ROW_5_Left_147 VGND VGND VPWR VPWR sky130_fd_sc_hd__decap_3
X_10160_ clknet_leaf_12_clk _00079_ VGND VGND VPWR VPWR picorv32_core.cpuregs\[21\]\[8\]
+ sky130_fd_sc_hd__dfxtp_1
XFILLER_126_65 VPWR VGND VPWR VGND sky130_ef_sc_hd__decap_12
X_10091_ net1114 VGND VGND VPWR VPWR _00941_ sky130_fd_sc_hd__clkbuf_1
XFILLER_19_30 VPWR VGND VPWR VGND sky130_ef_sc_hd__decap_12
XPHY_EDGE_ROW_76_Right_76 VGND VGND VPWR VPWR sky130_fd_sc_hd__decap_3
XFILLER_90_738 VGND VGND VPWR VPWR sky130_fd_sc_hd__fill_2
XFILLER_16_813 VGND VGND VPWR VPWR sky130_fd_sc_hd__decap_4
XFILLER_28_662 VGND VGND VPWR VPWR sky130_fd_sc_hd__fill_1
X_10993_ clknet_leaf_129_clk _00844_ VGND VGND VPWR VPWR picorv32_core.cpuregs\[12\]\[7\]
+ sky130_fd_sc_hd__dfxtp_1
X_11614_ clknet_leaf_42_clk _01445_ VGND VGND VPWR VPWR picorv32_core.cpuregs\[23\]\[27\]
+ sky130_fd_sc_hd__dfxtp_1
XFILLER_129_726 VGND VGND VPWR VPWR sky130_fd_sc_hd__fill_2
XFILLER_128_203 VGND VGND VPWR VPWR sky130_fd_sc_hd__fill_1
XFILLER_129_737 VPWR VGND VPWR VGND sky130_ef_sc_hd__decap_12
X_11545_ clknet_leaf_46_clk _01376_ VGND VGND VPWR VPWR picorv32_core.cpuregs\[30\]\[26\]
+ sky130_fd_sc_hd__dfxtp_1
XPHY_EDGE_ROW_85_Right_85 VGND VGND VPWR VPWR sky130_fd_sc_hd__decap_3
XFILLER_11_584 VGND VGND VPWR VPWR sky130_fd_sc_hd__decap_3
Xclkbuf_leaf_131_clk clknet_4_2_0_clk VGND VGND VPWR VPWR clknet_leaf_131_clk sky130_fd_sc_hd__clkbuf_8
XTAP_TAPCELL_ROW_41_899 VGND VPWR sky130_fd_sc_hd__tapvpwrvgnd_1
X_11476_ clknet_leaf_41_clk _01312_ VGND VGND VPWR VPWR picorv32_core.cpuregs\[24\]\[27\]
+ sky130_fd_sc_hd__dfxtp_1
XFILLER_11_595 VGND VGND VPWR VPWR sky130_fd_sc_hd__fill_2
X_10427_ clknet_leaf_87_clk _01559_ VGND VGND VPWR VPWR picorv32_core.reg_out\[20\]
+ sky130_fd_sc_hd__dfxtp_1
XTAP_TAPCELL_ROW_111_1921 VGND VPWR sky130_fd_sc_hd__tapvpwrvgnd_1
XTAP_TAPCELL_ROW_111_1910 VGND VPWR sky130_fd_sc_hd__tapvpwrvgnd_1
X_10358_ clknet_leaf_83_clk _00277_ VGND VGND VPWR VPWR picorv32_core.count_cycle\[16\]
+ sky130_fd_sc_hd__dfxtp_1
X_10289_ clknet_leaf_126_clk _00208_ VGND VGND VPWR VPWR picorv32_core.reg_pc\[10\]
+ sky130_fd_sc_hd__dfxtp_1
XFILLER_3_783 VGND VGND VPWR VPWR sky130_fd_sc_hd__fill_1
XFILLER_111_158 VGND VGND VPWR VPWR sky130_fd_sc_hd__fill_1
XPHY_EDGE_ROW_94_Right_94 VGND VGND VPWR VPWR sky130_fd_sc_hd__decap_3
XTAP_TAPCELL_ROW_53_1072 VGND VPWR sky130_fd_sc_hd__tapvpwrvgnd_1
XFILLER_38_415 VGND VGND VPWR VPWR sky130_fd_sc_hd__decap_4
XFILLER_93_543 VPWR VGND VPWR VGND sky130_ef_sc_hd__decap_12
XFILLER_66_757 VGND VGND VPWR VPWR sky130_fd_sc_hd__fill_1
XTAP_TAPCELL_ROW_140_2339 VGND VPWR sky130_fd_sc_hd__tapvpwrvgnd_1
XTAP_TAPCELL_ROW_140_2328 VGND VPWR sky130_fd_sc_hd__tapvpwrvgnd_1
XTAP_TAPCELL_ROW_109_1883 VGND VPWR sky130_fd_sc_hd__tapvpwrvgnd_1
X_06520_ picorv32_core.count_instr\[19\] picorv32_core.count_instr\[18\] _02828_ VGND
+ VGND VPWR VPWR _02831_ sky130_fd_sc_hd__and3_1
X_06451_ net274 net1551 net419 VGND VGND VPWR VPWR _00117_ sky130_fd_sc_hd__mux2_1
X_05402_ _01822_ _01902_ _01903_ _01817_ VGND VGND VPWR VPWR _01904_ sky130_fd_sc_hd__a31o_1
X_06382_ picorv32_core.reg_pc\[28\] _02776_ VGND VGND VPWR VPWR _02780_ sky130_fd_sc_hd__xor2_1
X_09170_ _04368_ net479 net485 _04359_ VGND VGND VPWR VPWR _04369_ sky130_fd_sc_hd__and4b_1
X_08121_ net267 net1943 net416 VGND VGND VPWR VPWR _00414_ sky130_fd_sc_hd__mux2_1
X_05333_ net35 _01818_ VGND VGND VPWR VPWR _01840_ sky130_fd_sc_hd__or2_1
Xclkbuf_leaf_122_clk clknet_4_9_0_clk VGND VGND VPWR VPWR clknet_leaf_122_clk sky130_fd_sc_hd__clkbuf_8
X_08052_ picorv32_core.cpuregs\[20\]\[30\] picorv32_core.cpuregs\[21\]\[30\] picorv32_core.cpuregs\[22\]\[30\]
+ picorv32_core.cpuregs\[23\]\[30\] net761 net728 VGND VGND VPWR VPWR _04127_ sky130_fd_sc_hd__mux4_1
X_05264_ net913 net813 _01772_ net909 VGND VGND VPWR VPWR _01776_ sky130_fd_sc_hd__a22o_1
XFILLER_135_729 VPWR VGND VPWR VGND sky130_ef_sc_hd__decap_12
XFILLER_128_781 VPWR VGND VPWR VGND sky130_ef_sc_hd__decap_12
X_07003_ _03212_ _03213_ VGND VGND VPWR VPWR _03214_ sky130_fd_sc_hd__and2_1
XFILLER_1_709 VPWR VGND VPWR VGND sky130_ef_sc_hd__decap_12
X_05195_ _01588_ _01712_ VGND VGND VPWR VPWR net103 sky130_fd_sc_hd__nor2_1
XFILLER_102_136 VGND VGND VPWR VPWR sky130_fd_sc_hd__decap_4
X_08954_ net1656 net500 net349 VGND VGND VPWR VPWR _01126_ sky130_fd_sc_hd__mux2_1
X_07905_ net697 _03985_ _03984_ net621 VGND VGND VPWR VPWR _03989_ sky130_fd_sc_hd__o211a_1
XFILLER_102_158 VGND VGND VPWR VPWR sky130_fd_sc_hd__fill_2
XFILLER_130_489 VGND VGND VPWR VPWR sky130_fd_sc_hd__fill_1
X_08885_ net207 net2121 net364 VGND VGND VPWR VPWR _01060_ sky130_fd_sc_hd__mux2_1
X_07836_ picorv32_core.cpuregs\[16\]\[18\] picorv32_core.cpuregs\[17\]\[18\] picorv32_core.cpuregs\[18\]\[18\]
+ picorv32_core.cpuregs\[19\]\[18\] net758 net725 VGND VGND VPWR VPWR _03923_ sky130_fd_sc_hd__mux4_1
XFILLER_84_543 VGND VGND VPWR VPWR sky130_fd_sc_hd__decap_3
XFILLER_112_23 VGND VGND VPWR VPWR sky130_fd_sc_hd__decap_4
XFILLER_84_587 VGND VGND VPWR VPWR sky130_fd_sc_hd__fill_1
XFILLER_84_576 VGND VGND VPWR VPWR sky130_fd_sc_hd__fill_1
XFILLER_72_738 VGND VGND VPWR VPWR sky130_fd_sc_hd__fill_2
X_07767_ picorv32_core.cpuregs\[24\]\[14\] picorv32_core.cpuregs\[25\]\[14\] picorv32_core.cpuregs\[26\]\[14\]
+ picorv32_core.cpuregs\[27\]\[14\] net738 net705 VGND VGND VPWR VPWR _03858_ sky130_fd_sc_hd__mux4_1
XTAP_TAPCELL_ROW_84_1522 VGND VPWR sky130_fd_sc_hd__tapvpwrvgnd_1
X_09506_ picorv32_core.reg_pc\[14\] net537 _04690_ net484 VGND VGND VPWR VPWR _04691_
+ sky130_fd_sc_hd__a211o_1
X_06718_ net673 _02950_ _02951_ _02947_ VGND VGND VPWR VPWR _02952_ sky130_fd_sc_hd__a31o_1
XFILLER_112_89 VGND VGND VPWR VPWR sky130_fd_sc_hd__fill_1
XFILLER_72_27 VGND VGND VPWR VPWR sky130_fd_sc_hd__fill_1
X_07698_ picorv32_core.cpuregs\[12\]\[10\] picorv32_core.cpuregs\[13\]\[10\] picorv32_core.cpuregs\[14\]\[10\]
+ picorv32_core.cpuregs\[15\]\[10\] net731 net698 VGND VGND VPWR VPWR _03793_ sky130_fd_sc_hd__mux4_1
X_09437_ picorv32_core.cpuregs\[24\]\[11\] picorv32_core.cpuregs\[25\]\[11\] picorv32_core.cpuregs\[26\]\[11\]
+ picorv32_core.cpuregs\[27\]\[11\] net880 net847 VGND VGND VPWR VPWR _04625_ sky130_fd_sc_hd__mux4_1
XFILLER_9_809 VPWR VGND VPWR VGND sky130_ef_sc_hd__decap_12
X_06649_ _02673_ picorv32_core.reg_next_pc\[2\] net555 VGND VGND VPWR VPWR _02914_
+ sky130_fd_sc_hd__mux2_2
XFILLER_24_197 VGND VGND VPWR VPWR sky130_fd_sc_hd__decap_4
X_09368_ picorv32_core.cpuregs\[24\]\[8\] picorv32_core.cpuregs\[25\]\[8\] picorv32_core.cpuregs\[26\]\[8\]
+ picorv32_core.cpuregs\[27\]\[8\] net881 net848 VGND VGND VPWR VPWR _04559_ sky130_fd_sc_hd__mux4_1
X_08319_ net931 net987 _02600_ _04191_ _04230_ VGND VGND VPWR VPWR _00538_ sky130_fd_sc_hd__a32o_1
X_09299_ net653 _04492_ VGND VGND VPWR VPWR _04493_ sky130_fd_sc_hd__or2_1
Xclkbuf_leaf_113_clk clknet_4_8_0_clk VGND VGND VPWR VPWR clknet_leaf_113_clk sky130_fd_sc_hd__clkbuf_8
XANTENNA_71 _00004_ VGND VGND VPWR VPWR sky130_fd_sc_hd__diode_2
XANTENNA_93 net872 VGND VGND VPWR VPWR sky130_fd_sc_hd__diode_2
X_11330_ clknet_leaf_9_clk _01171_ VGND VGND VPWR VPWR picorv32_core.cpuregs\[29\]\[14\]
+ sky130_fd_sc_hd__dfxtp_1
XANTENNA_82 net181 VGND VGND VPWR VPWR sky130_fd_sc_hd__diode_2
XANTENNA_60 net541 VGND VGND VPWR VPWR sky130_fd_sc_hd__diode_2
XFILLER_115_3 VPWR VGND VPWR VGND sky130_ef_sc_hd__decap_12
X_11261_ clknet_leaf_20_clk _01109_ VGND VGND VPWR VPWR picorv32_core.cpuregs\[4\]\[16\]
+ sky130_fd_sc_hd__dfxtp_1
XFILLER_133_250 VGND VGND VPWR VPWR sky130_fd_sc_hd__fill_1
X_10212_ clknet_leaf_39_clk _00131_ VGND VGND VPWR VPWR picorv32_core.cpuregs\[9\]\[28\]
+ sky130_fd_sc_hd__dfxtp_1
XTAP_TAPCELL_ROW_95_1684 VGND VPWR sky130_fd_sc_hd__tapvpwrvgnd_1
X_11192_ clknet_leaf_26_clk _01043_ VGND VGND VPWR VPWR picorv32_core.cpuregs\[6\]\[14\]
+ sky130_fd_sc_hd__dfxtp_1
X_10143_ clknet_leaf_45_clk _00065_ VGND VGND VPWR VPWR picorv32_core.cpuregs\[22\]\[26\]
+ sky130_fd_sc_hd__dfxtp_1
XFILLER_97_57 VGND VGND VPWR VPWR sky130_fd_sc_hd__decap_4
X_10074_ picorv32_core.decoded_imm_j\[19\] _00760_ net439 VGND VGND VPWR VPWR _00484_
+ sky130_fd_sc_hd__mux2_1
XFILLER_0_797 VGND VGND VPWR VPWR sky130_fd_sc_hd__decap_4
XTAP_TAPCELL_ROW_122_2069 VGND VPWR sky130_fd_sc_hd__tapvpwrvgnd_1
X_10976_ clknet_leaf_31_clk _00827_ VGND VGND VPWR VPWR picorv32_core.cpuregs\[13\]\[22\]
+ sky130_fd_sc_hd__dfxtp_1
XTAP_TAPCELL_ROW_46_969 VGND VPWR sky130_fd_sc_hd__tapvpwrvgnd_1
XFILLER_71_793 VGND VGND VPWR VPWR sky130_fd_sc_hd__fill_1
XTAP_TAPCELL_ROW_26_682 VGND VPWR sky130_fd_sc_hd__tapvpwrvgnd_1
Xclkbuf_leaf_104_clk clknet_4_11_0_clk VGND VGND VPWR VPWR clknet_leaf_104_clk sky130_fd_sc_hd__clkbuf_8
XFILLER_129_556 VGND VGND VPWR VPWR sky130_fd_sc_hd__decap_4
XTAP_TAPCELL_ROW_137_2290 VGND VPWR sky130_fd_sc_hd__tapvpwrvgnd_1
XFILLER_117_729 VPWR VGND VPWR VGND sky130_ef_sc_hd__decap_12
Xhold308 picorv32_core.cpuregs\[22\]\[14\] VGND VGND VPWR VPWR net1417 sky130_fd_sc_hd__dlygate4sd3_1
X_11528_ clknet_leaf_140_clk _01359_ VGND VGND VPWR VPWR picorv32_core.cpuregs\[30\]\[9\]
+ sky130_fd_sc_hd__dfxtp_1
Xhold319 picorv32_core.cpuregs\[24\]\[6\] VGND VGND VPWR VPWR net1428 sky130_fd_sc_hd__dlygate4sd3_1
X_11459_ clknet_leaf_1_clk _01295_ VGND VGND VPWR VPWR picorv32_core.cpuregs\[24\]\[10\]
+ sky130_fd_sc_hd__dfxtp_1
XTAP_TAPCELL_ROW_55_1101 VGND VPWR sky130_fd_sc_hd__tapvpwrvgnd_1
XFILLER_124_272 VGND VGND VPWR VPWR sky130_fd_sc_hd__fill_1
XFILLER_30_3 VPWR VGND VPWR VGND sky130_ef_sc_hd__decap_12
Xhold1019 picorv32_core.cpuregs\[30\]\[19\] VGND VGND VPWR VPWR net2128 sky130_fd_sc_hd__dlygate4sd3_1
XFILLER_78_381 VGND VGND VPWR VPWR sky130_fd_sc_hd__decap_3
X_05951_ net789 net956 net573 VGND VGND VPWR VPWR _02419_ sky130_fd_sc_hd__a21oi_1
Xhold1008 picorv32_core.cpuregs\[10\]\[2\] VGND VGND VPWR VPWR net2117 sky130_fd_sc_hd__dlygate4sd3_1
XPHY_EDGE_ROW_77_Left_219 VGND VGND VPWR VPWR sky130_fd_sc_hd__decap_3
XFILLER_66_554 VGND VGND VPWR VPWR sky130_fd_sc_hd__decap_3
X_08670_ net268 net1817 net386 VGND VGND VPWR VPWR _00820_ sky130_fd_sc_hd__mux2_1
X_05882_ _02354_ _02355_ VGND VGND VPWR VPWR _02356_ sky130_fd_sc_hd__nand2_1
XFILLER_66_587 VGND VGND VPWR VPWR sky130_fd_sc_hd__fill_1
X_07621_ picorv32_core.cpuregs\[0\]\[6\] picorv32_core.cpuregs\[1\]\[6\] picorv32_core.cpuregs\[2\]\[6\]
+ picorv32_core.cpuregs\[3\]\[6\] net732 net699 VGND VGND VPWR VPWR _03720_ sky130_fd_sc_hd__mux4_1
XFILLER_81_557 VGND VGND VPWR VPWR sky130_fd_sc_hd__decap_3
X_07552_ net624 _03656_ VGND VGND VPWR VPWR _03657_ sky130_fd_sc_hd__nand2_1
X_06503_ picorv32_core.count_instr\[13\] picorv32_core.count_instr\[12\] picorv32_core.count_instr\[11\]
+ _02815_ VGND VGND VPWR VPWR _02820_ sky130_fd_sc_hd__and4_1
XTAP_TAPCELL_ROW_66_1263 VGND VPWR sky130_fd_sc_hd__tapvpwrvgnd_1
X_07483_ net794 _03609_ net533 VGND VGND VPWR VPWR _03610_ sky130_fd_sc_hd__mux2_1
X_06434_ net208 net2017 net425 VGND VGND VPWR VPWR _00102_ sky130_fd_sc_hd__mux2_1
X_09222_ _04413_ _04414_ _04417_ _04418_ net642 VGND VGND VPWR VPWR _04419_ sky130_fd_sc_hd__a221o_1
XFILLER_21_134 VGND VGND VPWR VPWR sky130_fd_sc_hd__fill_2
X_06365_ picorv32_core.reg_out\[25\] picorv32_core.alu_out_q\[25\] net953 VGND VGND
+ VPWR VPWR _02766_ sky130_fd_sc_hd__mux2_1
X_09153_ picorv32_core.cpuregs\[0\]\[0\] picorv32_core.cpuregs\[1\]\[0\] picorv32_core.cpuregs\[2\]\[0\]
+ picorv32_core.cpuregs\[3\]\[0\] net885 net854 VGND VGND VPWR VPWR _04352_ sky130_fd_sc_hd__mux4_1
XPHY_EDGE_ROW_86_Left_228 VGND VGND VPWR VPWR sky130_fd_sc_hd__decap_3
X_05316_ _01819_ _01822_ _01823_ _01817_ VGND VGND VPWR VPWR _01824_ sky130_fd_sc_hd__a31o_1
X_08104_ _02795_ _04171_ VGND VGND VPWR VPWR _04172_ sky130_fd_sc_hd__or2_2
X_09084_ net1570 net209 net339 VGND VGND VPWR VPWR _01252_ sky130_fd_sc_hd__mux2_1
X_06296_ _02708_ _02709_ VGND VGND VPWR VPWR _02711_ sky130_fd_sc_hd__nor2_1
Xhold820 picorv32_core.cpuregs\[1\]\[23\] VGND VGND VPWR VPWR net1929 sky130_fd_sc_hd__dlygate4sd3_1
X_08035_ net697 _04110_ VGND VGND VPWR VPWR _04111_ sky130_fd_sc_hd__or2_1
X_05247_ picorv32_core.count_instr\[35\] net935 net939 picorv32_core.count_instr\[3\]
+ VGND VGND VPWR VPWR _01760_ sky130_fd_sc_hd__a22o_1
XFILLER_103_401 VGND VGND VPWR VPWR sky130_fd_sc_hd__fill_2
Xhold842 picorv32_core.cpuregs\[9\]\[18\] VGND VGND VPWR VPWR net1951 sky130_fd_sc_hd__dlygate4sd3_1
Xhold864 picorv32_core.cpuregs\[4\]\[4\] VGND VGND VPWR VPWR net1973 sky130_fd_sc_hd__dlygate4sd3_1
Xhold831 picorv32_core.cpuregs\[8\]\[2\] VGND VGND VPWR VPWR net1940 sky130_fd_sc_hd__dlygate4sd3_1
Xhold853 picorv32_core.cpuregs\[4\]\[9\] VGND VGND VPWR VPWR net1962 sky130_fd_sc_hd__dlygate4sd3_1
X_05178_ net924 net970 VGND VGND VPWR VPWR _01701_ sky130_fd_sc_hd__nand2_2
Xhold897 picorv32_core.cpuregs\[16\]\[27\] VGND VGND VPWR VPWR net2006 sky130_fd_sc_hd__dlygate4sd3_1
Xhold886 picorv32_core.cpuregs\[8\]\[18\] VGND VGND VPWR VPWR net1995 sky130_fd_sc_hd__dlygate4sd3_1
Xhold875 picorv32_core.cpuregs\[25\]\[4\] VGND VGND VPWR VPWR net1984 sky130_fd_sc_hd__dlygate4sd3_1
XFILLER_131_765 VPWR VGND VPWR VGND sky130_ef_sc_hd__decap_12
XFILLER_130_253 VGND VGND VPWR VPWR sky130_fd_sc_hd__fill_1
XFILLER_107_78 VGND VGND VPWR VPWR sky130_fd_sc_hd__decap_4
XFILLER_76_307 VGND VGND VPWR VPWR sky130_fd_sc_hd__fill_1
X_09986_ net1851 net278 net312 VGND VGND VPWR VPWR _01463_ sky130_fd_sc_hd__mux2_1
XPHY_EDGE_ROW_95_Left_237 VGND VGND VPWR VPWR sky130_fd_sc_hd__decap_3
X_08937_ net259 net2238 net355 VGND VGND VPWR VPWR _01110_ sky130_fd_sc_hd__mux2_1
XFILLER_67_49 VGND VGND VPWR VPWR sky130_fd_sc_hd__decap_6
X_08868_ net272 net1986 net363 VGND VGND VPWR VPWR _01043_ sky130_fd_sc_hd__mux2_1
XFILLER_57_532 VGND VGND VPWR VPWR sky130_fd_sc_hd__decap_3
XTAP_TAPCELL_ROW_4_366 VGND VPWR sky130_fd_sc_hd__tapvpwrvgnd_1
XFILLER_123_55 VGND VGND VPWR VPWR sky130_fd_sc_hd__fill_1
X_07819_ picorv32_core.cpuregs\[28\]\[17\] picorv32_core.cpuregs\[29\]\[17\] picorv32_core.cpuregs\[30\]\[17\]
+ picorv32_core.cpuregs\[31\]\[17\] net747 net714 VGND VGND VPWR VPWR _03907_ sky130_fd_sc_hd__mux4_1
X_08799_ net288 net2095 net371 VGND VGND VPWR VPWR _00977_ sky130_fd_sc_hd__mux2_1
XFILLER_45_738 VGND VGND VPWR VPWR sky130_fd_sc_hd__fill_1
XFILLER_53_760 VGND VGND VPWR VPWR sky130_fd_sc_hd__fill_1
XFILLER_16_53 VPWR VGND VPWR VGND sky130_ef_sc_hd__decap_12
X_10830_ clknet_leaf_130_clk _00681_ VGND VGND VPWR VPWR picorv32_core.cpuregs\[17\]\[7\]
+ sky130_fd_sc_hd__dfxtp_1
XFILLER_44_248 VGND VGND VPWR VPWR sky130_fd_sc_hd__decap_4
XFILLER_44_259 VGND VGND VPWR VPWR sky130_fd_sc_hd__fill_1
X_10761_ clknet_leaf_136_clk _00612_ VGND VGND VPWR VPWR picorv32_core.cpuregs\[14\]\[2\]
+ sky130_fd_sc_hd__dfxtp_1
XTAP_TAPCELL_ROW_43_928 VGND VPWR sky130_fd_sc_hd__tapvpwrvgnd_1
X_10692_ clknet_leaf_136_clk _00543_ VGND VGND VPWR VPWR net126 sky130_fd_sc_hd__dfxtp_1
XTAP_TAPCELL_ROW_23_641 VGND VPWR sky130_fd_sc_hd__tapvpwrvgnd_1
XFILLER_40_421 VPWR VGND VPWR VGND sky130_ef_sc_hd__decap_12
XFILLER_139_821 VGND VGND VPWR VPWR sky130_fd_sc_hd__decap_8
XTAP_TAPCELL_ROW_97_1713 VGND VPWR sky130_fd_sc_hd__tapvpwrvgnd_1
XFILLER_8_149 VGND VGND VPWR VPWR sky130_fd_sc_hd__fill_1
XFILLER_32_85 VGND VGND VPWR VPWR sky130_fd_sc_hd__fill_1
X_11313_ clknet_leaf_94_clk _00014_ VGND VGND VPWR VPWR picorv32_core.cpu_state\[4\]
+ sky130_fd_sc_hd__dfxtp_1
XFILLER_106_250 VGND VGND VPWR VPWR sky130_fd_sc_hd__fill_2
X_11244_ clknet_leaf_96_clk _00019_ VGND VGND VPWR VPWR picorv32_core.mem_wordsize\[2\]
+ sky130_fd_sc_hd__dfxtp_1
X_11175_ clknet_leaf_71_clk _01026_ VGND VGND VPWR VPWR picorv32_core.cpuregs\[7\]\[29\]
+ sky130_fd_sc_hd__dfxtp_1
XFILLER_79_178 VGND VGND VPWR VPWR sky130_fd_sc_hd__fill_1
X_10126_ clknet_leaf_0_clk _00048_ VGND VGND VPWR VPWR picorv32_core.cpuregs\[22\]\[9\]
+ sky130_fd_sc_hd__dfxtp_1
XTAP_TAPCELL_ROW_124_2109 VGND VPWR sky130_fd_sc_hd__tapvpwrvgnd_1
X_10057_ net1283 net256 net306 VGND VGND VPWR VPWR _01532_ sky130_fd_sc_hd__mux2_1
XTAP_TAPCELL_ROW_50_1031 VGND VPWR sky130_fd_sc_hd__tapvpwrvgnd_1
XFILLER_48_554 VGND VGND VPWR VPWR sky130_fd_sc_hd__decap_3
XFILLER_48_565 VGND VGND VPWR VPWR sky130_fd_sc_hd__decap_6
XTAP_TAPCELL_ROW_106_1842 VGND VPWR sky130_fd_sc_hd__tapvpwrvgnd_1
XFILLER_50_218 VGND VGND VPWR VPWR sky130_fd_sc_hd__fill_1
X_10959_ clknet_leaf_138_clk _00810_ VGND VGND VPWR VPWR picorv32_core.cpuregs\[13\]\[5\]
+ sky130_fd_sc_hd__dfxtp_1
XFILLER_44_793 VGND VGND VPWR VPWR sky130_fd_sc_hd__decap_8
XFILLER_78_3 VGND VGND VPWR VPWR sky130_fd_sc_hd__fill_1
XTAP_TAPCELL_ROW_61_1193 VGND VPWR sky130_fd_sc_hd__tapvpwrvgnd_1
X_06150_ picorv32_core.decoded_imm_j\[15\] _00756_ net439 VGND VGND VPWR VPWR _00025_
+ sky130_fd_sc_hd__mux2_1
X_06081_ _02160_ _02161_ net571 VGND VGND VPWR VPWR _02539_ sky130_fd_sc_hd__and3_1
Xhold105 picorv32_core.cpuregs\[3\]\[15\] VGND VGND VPWR VPWR net1214 sky130_fd_sc_hd__dlygate4sd3_1
X_05101_ picorv32_core.instr_sw picorv32_core.instr_sh picorv32_core.instr_sb VGND
+ VGND VPWR VPWR _01633_ sky130_fd_sc_hd__or3_1
XFILLER_7_193 VPWR VGND VPWR VGND sky130_ef_sc_hd__decap_12
Xhold116 picorv32_core.cpuregs\[23\]\[0\] VGND VGND VPWR VPWR net1225 sky130_fd_sc_hd__dlygate4sd3_1
Xhold127 picorv32_core.cpuregs\[29\]\[29\] VGND VGND VPWR VPWR net1236 sky130_fd_sc_hd__dlygate4sd3_1
Xhold149 picorv32_core.cpuregs\[31\]\[24\] VGND VGND VPWR VPWR net1258 sky130_fd_sc_hd__dlygate4sd3_1
Xhold138 picorv32_core.cpuregs\[3\]\[6\] VGND VGND VPWR VPWR net1247 sky130_fd_sc_hd__dlygate4sd3_1
XFILLER_98_432 VGND VGND VPWR VPWR sky130_fd_sc_hd__fill_2
XFILLER_113_765 VPWR VGND VPWR VGND sky130_ef_sc_hd__decap_12
X_09840_ _03397_ _03398_ _03537_ VGND VGND VPWR VPWR _05009_ sky130_fd_sc_hd__a21o_1
Xfanout607 _01649_ VGND VGND VPWR VPWR net607 sky130_fd_sc_hd__clkbuf_2
Xfanout618 net619 VGND VGND VPWR VPWR net618 sky130_fd_sc_hd__clkbuf_4
Xfanout629 net630 VGND VGND VPWR VPWR net629 sky130_fd_sc_hd__clkbuf_4
X_09771_ picorv32_core.reg_pc\[26\] net538 _04943_ net483 VGND VGND VPWR VPWR _04944_
+ sky130_fd_sc_hd__a211o_1
XFILLER_112_253 VGND VGND VPWR VPWR sky130_fd_sc_hd__decap_4
X_06983_ _02935_ _03185_ _01703_ VGND VGND VPWR VPWR _03196_ sky130_fd_sc_hd__o21ai_1
XFILLER_58_329 VGND VGND VPWR VPWR sky130_fd_sc_hd__decap_4
XFILLER_100_448 VPWR VGND VPWR VGND sky130_ef_sc_hd__decap_12
X_05934_ _02402_ _02403_ VGND VGND VPWR VPWR _02404_ sky130_fd_sc_hd__nand2_1
X_08722_ net1431 net498 net381 VGND VGND VPWR VPWR _00870_ sky130_fd_sc_hd__mux2_1
XTAP_TAPCELL_ROW_1_314 VGND VPWR sky130_fd_sc_hd__tapvpwrvgnd_1
XTAP_TAPCELL_ROW_1_325 VGND VPWR sky130_fd_sc_hd__tapvpwrvgnd_1
XFILLER_27_727 VGND VGND VPWR VPWR sky130_fd_sc_hd__fill_1
X_08653_ net1301 net208 net393 VGND VGND VPWR VPWR _00804_ sky130_fd_sc_hd__mux2_1
XFILLER_66_384 VGND VGND VPWR VPWR sky130_fd_sc_hd__decap_8
X_05865_ net805 net961 net567 _02338_ _02340_ VGND VGND VPWR VPWR picorv32_core.alu_out\[8\]
+ sky130_fd_sc_hd__a311o_1
XFILLER_26_226 VGND VGND VPWR VPWR sky130_fd_sc_hd__fill_1
XFILLER_81_354 VGND VGND VPWR VPWR sky130_fd_sc_hd__fill_1
X_07604_ net628 _03703_ VGND VGND VPWR VPWR _03704_ sky130_fd_sc_hd__or2_1
X_08584_ net504 net1776 net395 VGND VGND VPWR VPWR _00707_ sky130_fd_sc_hd__mux2_1
X_05796_ net969 net968 net967 net669 VGND VGND VPWR VPWR _02277_ sky130_fd_sc_hd__o31a_1
X_07535_ net2187 _03644_ net463 VGND VGND VPWR VPWR _00355_ sky130_fd_sc_hd__mux2_1
XFILLER_81_387 VGND VGND VPWR VPWR sky130_fd_sc_hd__decap_4
X_07466_ net1939 _03598_ net460 VGND VGND VPWR VPWR _00332_ sky130_fd_sc_hd__mux2_1
X_06417_ net272 net1484 net422 VGND VGND VPWR VPWR _00085_ sky130_fd_sc_hd__mux2_1
XFILLER_50_774 VGND VGND VPWR VPWR sky130_fd_sc_hd__decap_8
XFILLER_10_627 VGND VGND VPWR VPWR sky130_fd_sc_hd__fill_1
X_09205_ picorv32_core.cpuregs\[4\]\[2\] picorv32_core.cpuregs\[5\]\[2\] picorv32_core.cpuregs\[6\]\[2\]
+ picorv32_core.cpuregs\[7\]\[2\] net884 net851 VGND VGND VPWR VPWR _04402_ sky130_fd_sc_hd__mux4_1
X_07397_ _03400_ _03536_ _03399_ VGND VGND VPWR VPWR _03537_ sky130_fd_sc_hd__o21a_1
XFILLER_50_796 VGND VGND VPWR VPWR sky130_fd_sc_hd__fill_1
XTAP_TAPCELL_ROW_20_600 VGND VPWR sky130_fd_sc_hd__tapvpwrvgnd_1
XFILLER_136_813 VPWR VGND VPWR VGND sky130_ef_sc_hd__decap_12
X_06348_ net2073 net245 net435 VGND VGND VPWR VPWR _00060_ sky130_fd_sc_hd__mux2_1
X_09136_ net1624 net262 net330 VGND VGND VPWR VPWR _01302_ sky130_fd_sc_hd__mux2_1
XTAP_TAPCELL_ROW_79_1454 VGND VPWR sky130_fd_sc_hd__tapvpwrvgnd_1
X_09067_ net1564 net275 net337 VGND VGND VPWR VPWR _01235_ sky130_fd_sc_hd__mux2_1
X_06279_ picorv32_core.reg_pc\[8\] _02693_ VGND VGND VPWR VPWR _02697_ sky130_fd_sc_hd__xor2_1
X_08018_ picorv32_core.cpuregs\[24\]\[28\] picorv32_core.cpuregs\[25\]\[28\] picorv32_core.cpuregs\[26\]\[28\]
+ picorv32_core.cpuregs\[27\]\[28\] net752 net719 VGND VGND VPWR VPWR _04095_ sky130_fd_sc_hd__mux4_1
Xhold672 picorv32_core.cpuregs\[29\]\[30\] VGND VGND VPWR VPWR net1781 sky130_fd_sc_hd__dlygate4sd3_1
Xhold661 picorv32_core.cpuregs\[6\]\[24\] VGND VGND VPWR VPWR net1770 sky130_fd_sc_hd__dlygate4sd3_1
XTAP_TAPCELL_ROW_92_1643 VGND VPWR sky130_fd_sc_hd__tapvpwrvgnd_1
XTAP_TAPCELL_ROW_92_1632 VGND VPWR sky130_fd_sc_hd__tapvpwrvgnd_1
XTAP_TAPCELL_ROW_9_436 VGND VPWR sky130_fd_sc_hd__tapvpwrvgnd_1
Xhold650 picorv32_core.cpuregs\[4\]\[1\] VGND VGND VPWR VPWR net1759 sky130_fd_sc_hd__dlygate4sd3_1
Xhold683 picorv32_core.cpuregs\[22\]\[27\] VGND VGND VPWR VPWR net1792 sky130_fd_sc_hd__dlygate4sd3_1
Xhold694 picorv32_core.cpuregs\[12\]\[30\] VGND VGND VPWR VPWR net1803 sky130_fd_sc_hd__dlygate4sd3_1
XFILLER_104_754 VGND VGND VPWR VPWR sky130_fd_sc_hd__fill_2
X_09969_ net1238 net213 net319 VGND VGND VPWR VPWR _01447_ sky130_fd_sc_hd__mux2_1
XFILLER_89_476 VGND VGND VPWR VPWR sky130_fd_sc_hd__decap_8
XFILLER_134_65 VPWR VGND VPWR VGND sky130_ef_sc_hd__decap_12
XFILLER_57_384 VGND VGND VPWR VPWR sky130_fd_sc_hd__decap_8
XTAP_TAPCELL_ROW_28_711 VGND VPWR sky130_fd_sc_hd__tapvpwrvgnd_1
X_11862_ picorv32_core.mem_la_wdata\[4\] VGND VGND VPWR VPWR net199 sky130_fd_sc_hd__clkbuf_1
X_10813_ clknet_leaf_30_clk _00664_ VGND VGND VPWR VPWR picorv32_core.cpuregs\[15\]\[22\]
+ sky130_fd_sc_hd__dfxtp_1
XFILLER_26_793 VGND VGND VPWR VPWR sky130_fd_sc_hd__decap_3
XFILLER_13_443 VGND VGND VPWR VPWR sky130_fd_sc_hd__decap_4
XFILLER_25_270 VGND VGND VPWR VPWR sky130_fd_sc_hd__fill_1
XFILLER_25_281 VGND VGND VPWR VPWR sky130_fd_sc_hd__decap_4
X_10744_ clknet_leaf_88_clk _00595_ VGND VGND VPWR VPWR picorv32_core.decoded_imm\[15\]
+ sky130_fd_sc_hd__dfxtp_2
XTAP_TAPCELL_ROW_101_1772 VGND VPWR sky130_fd_sc_hd__tapvpwrvgnd_1
X_10675_ clknet_leaf_112_clk _00529_ VGND VGND VPWR VPWR picorv32_core.decoded_imm_j\[2\]
+ sky130_fd_sc_hd__dfxtp_1
Xpicorv32_axi_1071 VGND VGND VPWR VPWR picorv32_axi_1071/HI pcpi_insn[31] sky130_fd_sc_hd__conb_1
Xpicorv32_axi_1082 VGND VGND VPWR VPWR picorv32_axi_1082/HI trace_data[9] sky130_fd_sc_hd__conb_1
Xpicorv32_axi_1060 VGND VGND VPWR VPWR picorv32_axi_1060/HI pcpi_insn[20] sky130_fd_sc_hd__conb_1
XFILLER_4_141 VPWR VGND VPWR VGND sky130_ef_sc_hd__decap_12
XFILLER_5_697 VPWR VGND VPWR VGND sky130_ef_sc_hd__decap_12
Xpicorv32_axi_1093 VGND VGND VPWR VPWR picorv32_axi_1093/HI trace_data[20] sky130_fd_sc_hd__conb_1
X_11227_ clknet_leaf_26_clk _01078_ VGND VGND VPWR VPWR picorv32_core.cpuregs\[5\]\[17\]
+ sky130_fd_sc_hd__dfxtp_1
X_11158_ clknet_leaf_6_clk _01009_ VGND VGND VPWR VPWR picorv32_core.cpuregs\[7\]\[12\]
+ sky130_fd_sc_hd__dfxtp_1
X_10109_ net1117 VGND VGND VPWR VPWR _00959_ sky130_fd_sc_hd__clkbuf_1
XFILLER_110_757 VPWR VGND VPWR VGND sky130_ef_sc_hd__decap_12
XFILLER_110_746 VGND VGND VPWR VPWR sky130_fd_sc_hd__decap_8
XFILLER_67_137 VGND VGND VPWR VPWR sky130_fd_sc_hd__fill_1
XFILLER_83_608 VGND VGND VPWR VPWR sky130_fd_sc_hd__fill_2
XFILLER_67_159 VGND VGND VPWR VPWR sky130_fd_sc_hd__fill_1
X_11089_ clknet_leaf_139_clk _00940_ VGND VGND VPWR VPWR picorv32_core.cpuregs\[0\]\[7\]
+ sky130_fd_sc_hd__dfxtp_1
XFILLER_48_362 VGND VGND VPWR VPWR sky130_fd_sc_hd__fill_2
XFILLER_75_192 VGND VGND VPWR VPWR sky130_fd_sc_hd__fill_2
XFILLER_24_719 VPWR VGND VPWR VGND sky130_ef_sc_hd__decap_12
X_05650_ _02130_ _02132_ VGND VGND VPWR VPWR _02134_ sky130_fd_sc_hd__nand2_1
X_05581_ picorv32_core.count_instr\[59\] net937 net941 picorv32_core.count_instr\[27\]
+ VGND VGND VPWR VPWR _02070_ sky130_fd_sc_hd__a22o_1
XFILLER_63_365 VGND VGND VPWR VPWR sky130_fd_sc_hd__decap_6
XTAP_TAPCELL_ROW_63_1222 VGND VPWR sky130_fd_sc_hd__tapvpwrvgnd_1
X_07320_ net152 picorv32_core.decoded_imm\[1\] VGND VGND VPWR VPWR _03460_ sky130_fd_sc_hd__or2_1
XFILLER_32_752 VGND VGND VPWR VPWR sky130_fd_sc_hd__decap_4
X_07251_ net916 net613 VGND VGND VPWR VPWR _03391_ sky130_fd_sc_hd__nor2_2
XFILLER_136_109 VPWR VGND VPWR VGND sky130_ef_sc_hd__decap_12
XFILLER_118_813 VPWR VGND VPWR VGND sky130_ef_sc_hd__decap_12
X_07182_ picorv32_core.count_cycle\[40\] _03344_ net974 VGND VGND VPWR VPWR _03346_
+ sky130_fd_sc_hd__a21oi_1
X_06202_ picorv32_core.cpuregs\[24\]\[3\] picorv32_core.cpuregs\[25\]\[3\] picorv32_core.cpuregs\[26\]\[3\]
+ picorv32_core.cpuregs\[27\]\[3\] net743 net710 VGND VGND VPWR VPWR _02633_ sky130_fd_sc_hd__mux4_1
X_06133_ net764 _02586_ VGND VGND VPWR VPWR _02587_ sky130_fd_sc_hd__xnor2_1
XFILLER_105_529 VGND VGND VPWR VPWR sky130_fd_sc_hd__decap_4
X_06064_ net773 net189 net573 VGND VGND VPWR VPWR _02524_ sky130_fd_sc_hd__a21oi_1
Xfanout404 net405 VGND VGND VPWR VPWR net404 sky130_fd_sc_hd__buf_4
XTAP_TAPCELL_ROW_74_1373 VGND VPWR sky130_fd_sc_hd__tapvpwrvgnd_1
X_09823_ picorv32_core.cpuregs\[20\]\[29\] picorv32_core.cpuregs\[21\]\[29\] picorv32_core.cpuregs\[22\]\[29\]
+ picorv32_core.cpuregs\[23\]\[29\] net905 net869 VGND VGND VPWR VPWR _04993_ sky130_fd_sc_hd__mux4_1
XFILLER_101_713 VGND VGND VPWR VPWR sky130_fd_sc_hd__decap_4
XTAP_TAPCELL_ROW_74_1384 VGND VPWR sky130_fd_sc_hd__tapvpwrvgnd_1
Xfanout426 net427 VGND VGND VPWR VPWR net426 sky130_fd_sc_hd__clkbuf_2
Xfanout448 _02687_ VGND VGND VPWR VPWR net448 sky130_fd_sc_hd__dlymetal6s2s_1
Xfanout415 _04172_ VGND VGND VPWR VPWR net415 sky130_fd_sc_hd__buf_4
Xfanout437 net438 VGND VGND VPWR VPWR net437 sky130_fd_sc_hd__clkbuf_4
XFILLER_140_381 VGND VGND VPWR VPWR sky130_fd_sc_hd__fill_1
Xfanout459 _03702_ VGND VGND VPWR VPWR net459 sky130_fd_sc_hd__buf_4
XFILLER_86_457 VGND VGND VPWR VPWR sky130_fd_sc_hd__fill_1
X_09754_ _01602_ net543 VGND VGND VPWR VPWR _04927_ sky130_fd_sc_hd__nand2_1
X_06966_ _03178_ _03179_ VGND VGND VPWR VPWR _03180_ sky130_fd_sc_hd__nand2_1
X_09685_ _04857_ _04860_ _04861_ net828 net650 VGND VGND VPWR VPWR _04862_ sky130_fd_sc_hd__a221o_1
XFILLER_82_630 VGND VGND VPWR VPWR sky130_fd_sc_hd__decap_4
X_08705_ net2011 net261 net384 VGND VGND VPWR VPWR _00854_ sky130_fd_sc_hd__mux2_1
X_06897_ net989 _03116_ VGND VGND VPWR VPWR _00245_ sky130_fd_sc_hd__and2_1
XFILLER_67_682 VGND VGND VPWR VPWR sky130_fd_sc_hd__fill_2
X_05917_ net506 _02385_ _02388_ VGND VGND VPWR VPWR picorv32_core.alu_out\[12\] sky130_fd_sc_hd__a21o_1
XFILLER_54_321 VPWR VGND VPWR VGND sky130_ef_sc_hd__decap_12
XPHY_EDGE_ROW_126_Right_126 VGND VGND VPWR VPWR sky130_fd_sc_hd__decap_3
X_08636_ net1288 net274 net390 VGND VGND VPWR VPWR _00787_ sky130_fd_sc_hd__mux2_1
Xclkbuf_leaf_93_clk clknet_4_9_0_clk VGND VGND VPWR VPWR clknet_leaf_93_clk sky130_fd_sc_hd__clkbuf_8
X_05848_ _02323_ _02324_ VGND VGND VPWR VPWR _02325_ sky130_fd_sc_hd__xnor2_1
XFILLER_15_708 VPWR VGND VPWR VGND sky130_ef_sc_hd__decap_12
XFILLER_54_365 VGND VGND VPWR VPWR sky130_fd_sc_hd__fill_2
XFILLER_42_505 VGND VGND VPWR VPWR sky130_fd_sc_hd__decap_6
X_08567_ net258 net1633 net400 VGND VGND VPWR VPWR _00692_ sky130_fd_sc_hd__mux2_1
XFILLER_23_741 VPWR VGND VPWR VGND sky130_ef_sc_hd__decap_12
X_05779_ _02130_ net573 VGND VGND VPWR VPWR _02262_ sky130_fd_sc_hd__nor2_1
X_07518_ picorv32_core.reg_out\[26\] picorv32_core.reg_next_pc\[26\] net559 VGND VGND
+ VPWR VPWR _03633_ sky130_fd_sc_hd__mux2_1
X_08498_ net1559 net255 net408 VGND VGND VPWR VPWR _00628_ sky130_fd_sc_hd__mux2_1
XFILLER_22_251 VGND VGND VPWR VPWR sky130_fd_sc_hd__fill_1
XFILLER_23_785 VGND VGND VPWR VPWR sky130_fd_sc_hd__decap_8
XTAP_TAPCELL_ROW_33_780 VGND VPWR sky130_fd_sc_hd__tapvpwrvgnd_1
X_07449_ picorv32_core.reg_out\[3\] picorv32_core.reg_next_pc\[3\] net555 VGND VGND
+ VPWR VPWR _03587_ sky130_fd_sc_hd__mux2_1
X_10460_ clknet_leaf_65_clk _00347_ VGND VGND VPWR VPWR net52 sky130_fd_sc_hd__dfxtp_1
XFILLER_10_457 VGND VGND VPWR VPWR sky130_fd_sc_hd__decap_3
X_09119_ net1684 net502 net328 VGND VGND VPWR VPWR _01285_ sky130_fd_sc_hd__mux2_1
XFILLER_124_805 VGND VGND VPWR VPWR sky130_fd_sc_hd__decap_6
X_10391_ clknet_leaf_82_clk _00310_ VGND VGND VPWR VPWR picorv32_core.count_cycle\[49\]
+ sky130_fd_sc_hd__dfxtp_1
XFILLER_123_326 VGND VGND VPWR VPWR sky130_fd_sc_hd__fill_1
Xhold480 picorv32_core.cpuregs\[14\]\[23\] VGND VGND VPWR VPWR net1589 sky130_fd_sc_hd__dlygate4sd3_1
XFILLER_8_3 VPWR VGND VPWR VGND sky130_ef_sc_hd__decap_12
XFILLER_1_111 VGND VGND VPWR VPWR sky130_fd_sc_hd__fill_1
X_11012_ clknet_leaf_63_clk _00863_ VGND VGND VPWR VPWR picorv32_core.cpuregs\[12\]\[26\]
+ sky130_fd_sc_hd__dfxtp_1
Xhold491 picorv32_core.cpuregs\[10\]\[3\] VGND VGND VPWR VPWR net1600 sky130_fd_sc_hd__dlygate4sd3_1
XFILLER_131_381 VGND VGND VPWR VPWR sky130_fd_sc_hd__fill_2
XFILLER_77_457 VGND VGND VPWR VPWR sky130_fd_sc_hd__fill_2
Xfanout960 net961 VGND VGND VPWR VPWR net960 sky130_fd_sc_hd__buf_2
Xfanout971 net165 VGND VGND VPWR VPWR net971 sky130_fd_sc_hd__buf_4
Xfanout993 net998 VGND VGND VPWR VPWR net993 sky130_fd_sc_hd__clkbuf_2
XFILLER_77_468 VPWR VGND VPWR VGND sky130_ef_sc_hd__decap_12
XFILLER_18_502 VGND VGND VPWR VPWR sky130_fd_sc_hd__fill_2
Xfanout982 net988 VGND VGND VPWR VPWR net982 sky130_fd_sc_hd__buf_2
XFILLER_100_790 VGND VGND VPWR VPWR sky130_fd_sc_hd__decap_6
Xclkbuf_leaf_84_clk clknet_4_14_0_clk VGND VGND VPWR VPWR clknet_leaf_84_clk sky130_fd_sc_hd__clkbuf_8
Xhold1191 picorv32_core.mem_rdata_q\[3\] VGND VGND VPWR VPWR net2300 sky130_fd_sc_hd__dlygate4sd3_1
Xhold1180 _01416_ VGND VGND VPWR VPWR net2289 sky130_fd_sc_hd__dlygate4sd3_1
XTAP_TAPCELL_ROW_103_1801 VGND VPWR sky130_fd_sc_hd__tapvpwrvgnd_1
X_11845_ net48 VGND VGND VPWR VPWR net80 sky130_fd_sc_hd__clkbuf_1
XFILLER_72_195 VGND VGND VPWR VPWR sky130_fd_sc_hd__fill_1
XFILLER_54_94 VGND VGND VPWR VPWR sky130_fd_sc_hd__decap_3
XFILLER_9_211 VGND VGND VPWR VPWR sky130_fd_sc_hd__decap_4
X_10727_ clknet_leaf_108_clk _00578_ VGND VGND VPWR VPWR axi_adapter.mem_valid sky130_fd_sc_hd__dfxtp_1
X_10658_ clknet_leaf_64_clk _00512_ VGND VGND VPWR VPWR picorv32_core.cpuregs\[20\]\[26\]
+ sky130_fd_sc_hd__dfxtp_1
XTAP_TAPCELL_ROW_132_2219 VGND VPWR sky130_fd_sc_hd__tapvpwrvgnd_1
Xclkload14 clknet_4_15_0_clk VGND VGND VPWR VPWR clkload14/Y sky130_fd_sc_hd__inv_6
Xclkload25 clknet_leaf_8_clk VGND VGND VPWR VPWR clkload25/Y sky130_fd_sc_hd__inv_6
XTAP_TAPCELL_ROW_11_463 VGND VPWR sky130_fd_sc_hd__tapvpwrvgnd_1
Xclkload58 clknet_leaf_36_clk VGND VGND VPWR VPWR clkload58/Y sky130_fd_sc_hd__inv_6
Xclkload69 clknet_leaf_54_clk VGND VGND VPWR VPWR clkload69/Y sky130_fd_sc_hd__inv_12
Xclkload47 clknet_leaf_24_clk VGND VGND VPWR VPWR clkload47/Y sky130_fd_sc_hd__clkinv_8
X_10589_ clknet_leaf_96_clk _00443_ VGND VGND VPWR VPWR picorv32_core.instr_lhu sky130_fd_sc_hd__dfxtp_1
Xclkload36 clknet_leaf_139_clk VGND VGND VPWR VPWR clkload36/Y sky130_fd_sc_hd__clkinv_4
XFILLER_5_483 VGND VGND VPWR VPWR sky130_fd_sc_hd__fill_1
XTAP_TAPCELL_ROW_114_1963 VGND VPWR sky130_fd_sc_hd__tapvpwrvgnd_1
XTAP_TAPCELL_ROW_114_1952 VGND VPWR sky130_fd_sc_hd__tapvpwrvgnd_1
X_06820_ net980 _03045_ VGND VGND VPWR VPWR _00239_ sky130_fd_sc_hd__and2_1
XFILLER_83_427 VGND VGND VPWR VPWR sky130_fd_sc_hd__fill_2
X_06751_ _02914_ _02915_ _02916_ _02917_ VGND VGND VPWR VPWR _02982_ sky130_fd_sc_hd__a31o_1
Xclkbuf_leaf_75_clk clknet_4_15_0_clk VGND VGND VPWR VPWR clknet_leaf_75_clk sky130_fd_sc_hd__clkbuf_8
X_06682_ picorv32_core.reg_pc\[18\] net554 _02930_ net517 VGND VGND VPWR VPWR _00216_
+ sky130_fd_sc_hd__a22o_1
X_05702_ net793 net178 VGND VGND VPWR VPWR _02186_ sky130_fd_sc_hd__nand2_1
X_09470_ net804 net787 net546 VGND VGND VPWR VPWR _04656_ sky130_fd_sc_hd__mux2_1
XFILLER_64_630 VGND VGND VPWR VPWR sky130_fd_sc_hd__decap_6
XFILLER_91_482 VGND VGND VPWR VPWR sky130_fd_sc_hd__decap_6
X_08421_ picorv32_core.mem_rdata_q\[26\] net614 VGND VGND VPWR VPWR _04291_ sky130_fd_sc_hd__and2_1
XTAP_TAPCELL_ROW_19_574 VGND VPWR sky130_fd_sc_hd__tapvpwrvgnd_1
X_05633_ net946 picorv32_core.count_cycle\[63\] net603 _02117_ VGND VGND VPWR VPWR
+ _02118_ sky130_fd_sc_hd__a211o_1
XTAP_TAPCELL_ROW_19_585 VGND VPWR sky130_fd_sc_hd__tapvpwrvgnd_1
X_05564_ picorv32_core.reg_pc\[26\] picorv32_core.decoded_imm\[26\] VGND VGND VPWR
+ VPWR _02054_ sky130_fd_sc_hd__nand2_1
X_08352_ net1182 net455 _04250_ VGND VGND VPWR VPWR _00555_ sky130_fd_sc_hd__o21a_1
X_08283_ net1678 net246 net412 VGND VGND VPWR VPWR _00507_ sky130_fd_sc_hd__mux2_1
X_05495_ net578 _01989_ _01990_ net782 net917 VGND VGND VPWR VPWR _01991_ sky130_fd_sc_hd__a32o_1
X_07303_ net803 picorv32_core.decoded_imm\[9\] VGND VGND VPWR VPWR _03443_ sky130_fd_sc_hd__nor2_1
X_07234_ picorv32_core.count_cycle\[58\] picorv32_core.count_cycle\[59\] _03375_ VGND
+ VGND VPWR VPWR _03379_ sky130_fd_sc_hd__and3_1
Xclkload8 clknet_4_9_0_clk VGND VGND VPWR VPWR clkload8/X sky130_fd_sc_hd__clkbuf_8
XFILLER_118_610 VGND VGND VPWR VPWR sky130_fd_sc_hd__fill_1
XFILLER_117_142 VGND VGND VPWR VPWR sky130_fd_sc_hd__decap_3
XTAP_TAPCELL_ROW_76_1413 VGND VPWR sky130_fd_sc_hd__tapvpwrvgnd_1
XTAP_TAPCELL_ROW_76_1402 VGND VPWR sky130_fd_sc_hd__tapvpwrvgnd_1
X_07165_ _03334_ _03335_ VGND VGND VPWR VPWR _00294_ sky130_fd_sc_hd__nor2_1
X_06116_ _02566_ _02571_ VGND VGND VPWR VPWR _02572_ sky130_fd_sc_hd__xnor2_1
X_07096_ picorv32_core.count_cycle\[7\] _03289_ picorv32_core.count_cycle\[8\] VGND
+ VGND VPWR VPWR _03292_ sky130_fd_sc_hd__a21o_1
XFILLER_105_337 VGND VGND VPWR VPWR sky130_fd_sc_hd__fill_1
X_06047_ net670 _02507_ VGND VGND VPWR VPWR _02508_ sky130_fd_sc_hd__and2_1
XFILLER_59_17 VGND VGND VPWR VPWR sky130_fd_sc_hd__decap_3
Xfanout223 net224 VGND VGND VPWR VPWR net223 sky130_fd_sc_hd__dlymetal6s2s_1
Xfanout212 _02791_ VGND VGND VPWR VPWR net212 sky130_fd_sc_hd__clkbuf_2
XFILLER_120_318 VGND VGND VPWR VPWR sky130_fd_sc_hd__decap_4
Xfanout245 _02752_ VGND VGND VPWR VPWR net245 sky130_fd_sc_hd__clkbuf_2
Xfanout234 net235 VGND VGND VPWR VPWR net234 sky130_fd_sc_hd__clkbuf_2
Xfanout256 _02739_ VGND VGND VPWR VPWR net256 sky130_fd_sc_hd__buf_1
X_09806_ picorv32_core.cpuregs\[4\]\[28\] picorv32_core.cpuregs\[5\]\[28\] picorv32_core.cpuregs\[6\]\[28\]
+ picorv32_core.cpuregs\[7\]\[28\] net896 net862 VGND VGND VPWR VPWR _04977_ sky130_fd_sc_hd__mux4_1
X_07998_ picorv32_core.cpuregs\[12\]\[27\] picorv32_core.cpuregs\[13\]\[27\] picorv32_core.cpuregs\[14\]\[27\]
+ picorv32_core.cpuregs\[15\]\[27\] net756 net723 VGND VGND VPWR VPWR _04076_ sky130_fd_sc_hd__mux4_1
XFILLER_115_78 VGND VGND VPWR VPWR sky130_fd_sc_hd__decap_4
Xfanout267 _02731_ VGND VGND VPWR VPWR net267 sky130_fd_sc_hd__dlymetal6s2s_1
Xfanout289 _02715_ VGND VGND VPWR VPWR net289 sky130_fd_sc_hd__clkbuf_2
Xfanout278 net279 VGND VGND VPWR VPWR net278 sky130_fd_sc_hd__clkbuf_2
X_09737_ picorv32_core.cpuregs\[20\]\[25\] picorv32_core.cpuregs\[21\]\[25\] picorv32_core.cpuregs\[22\]\[25\]
+ picorv32_core.cpuregs\[23\]\[25\] net904 net870 VGND VGND VPWR VPWR _04911_ sky130_fd_sc_hd__mux4_1
X_06949_ net934 _02933_ VGND VGND VPWR VPWR _03164_ sky130_fd_sc_hd__nor2_1
XFILLER_28_811 VGND VGND VPWR VPWR sky130_fd_sc_hd__fill_1
Xclkbuf_leaf_66_clk clknet_4_13_0_clk VGND VGND VPWR VPWR clknet_leaf_66_clk sky130_fd_sc_hd__clkbuf_8
XTAP_TAPCELL_ROW_38_850 VGND VPWR sky130_fd_sc_hd__tapvpwrvgnd_1
XFILLER_131_55 VGND VGND VPWR VPWR sky130_fd_sc_hd__fill_1
X_09668_ net769 net547 VGND VGND VPWR VPWR _04845_ sky130_fd_sc_hd__or2_1
XTAP_TAPCELL_ROW_87_1564 VGND VPWR sky130_fd_sc_hd__tapvpwrvgnd_1
XTAP_TAPCELL_ROW_38_861 VGND VPWR sky130_fd_sc_hd__tapvpwrvgnd_1
XFILLER_43_836 VGND VGND VPWR VPWR sky130_fd_sc_hd__fill_1
XFILLER_91_37 VGND VGND VPWR VPWR sky130_fd_sc_hd__fill_1
X_09599_ net285 _04764_ _04779_ _04757_ VGND VGND VPWR VPWR _01337_ sky130_fd_sc_hd__a31o_1
XFILLER_82_493 VPWR VGND VPWR VGND sky130_ef_sc_hd__decap_12
XFILLER_15_549 VGND VGND VPWR VPWR sky130_fd_sc_hd__fill_2
X_08619_ net983 net37 net102 net2348 VGND VGND VPWR VPWR _04333_ sky130_fd_sc_hd__a31o_1
X_11630_ clknet_leaf_12_clk _01461_ VGND VGND VPWR VPWR picorv32_core.cpuregs\[28\]\[11\]
+ sky130_fd_sc_hd__dfxtp_1
X_11561_ clknet_leaf_1_clk _01392_ VGND VGND VPWR VPWR picorv32_core.cpuregs\[2\]\[8\]
+ sky130_fd_sc_hd__dfxtp_1
XFILLER_10_243 VGND VGND VPWR VPWR sky130_fd_sc_hd__fill_1
X_10512_ clknet_leaf_124_clk picorv32_core.alu_out\[0\] VGND VGND VPWR VPWR picorv32_core.alu_out_q\[0\]
+ sky130_fd_sc_hd__dfxtp_1
X_11492_ clknet_leaf_125_clk _01328_ VGND VGND VPWR VPWR net172 sky130_fd_sc_hd__dfxtp_1
XFILLER_11_777 VGND VGND VPWR VPWR sky130_fd_sc_hd__decap_6
X_10443_ clknet_leaf_117_clk _00330_ VGND VGND VPWR VPWR net65 sky130_fd_sc_hd__dfxtp_1
XFILLER_40_85 VGND VGND VPWR VPWR sky130_fd_sc_hd__fill_1
X_10374_ clknet_leaf_104_clk _00293_ VGND VGND VPWR VPWR picorv32_core.count_cycle\[32\]
+ sky130_fd_sc_hd__dfxtp_1
XTAP_TAPCELL_ROW_129_2181 VGND VPWR sky130_fd_sc_hd__tapvpwrvgnd_1
XTAP_TAPCELL_ROW_129_2170 VGND VPWR sky130_fd_sc_hd__tapvpwrvgnd_1
Xfanout790 net148 VGND VGND VPWR VPWR net790 sky130_fd_sc_hd__buf_1
Xclkbuf_leaf_57_clk clknet_4_12_0_clk VGND VGND VPWR VPWR clknet_leaf_57_clk sky130_fd_sc_hd__clkbuf_8
XFILLER_1_57 VPWR VGND VPWR VGND sky130_ef_sc_hd__decap_12
XFILLER_80_419 VGND VGND VPWR VPWR sky130_fd_sc_hd__fill_1
XFILLER_34_825 VGND VGND VPWR VPWR sky130_fd_sc_hd__fill_2
XFILLER_73_482 VGND VGND VPWR VPWR sky130_fd_sc_hd__fill_1
XFILLER_61_644 VGND VGND VPWR VPWR sky130_fd_sc_hd__fill_1
XTAP_TAPCELL_ROW_16_533 VGND VPWR sky130_fd_sc_hd__tapvpwrvgnd_1
X_11828_ net59 VGND VGND VPWR VPWR net91 sky130_fd_sc_hd__clkbuf_1
XTAP_TAPCELL_ROW_16_544 VGND VPWR sky130_fd_sc_hd__tapvpwrvgnd_1
Xclkload103 clknet_leaf_109_clk VGND VGND VPWR VPWR clkload103/Y sky130_fd_sc_hd__inv_8
X_05280_ picorv32_core.reg_pc\[6\] picorv32_core.decoded_imm\[6\] VGND VGND VPWR VPWR
+ _01790_ sky130_fd_sc_hd__and2_1
Xclkload125 clknet_leaf_67_clk VGND VGND VPWR VPWR clkload125/Y sky130_fd_sc_hd__clkinvlp_4
Xclkload136 clknet_leaf_70_clk VGND VGND VPWR VPWR clkload136/X sky130_fd_sc_hd__clkbuf_8
Xclkload114 clknet_leaf_57_clk VGND VGND VPWR VPWR clkload114/Y sky130_fd_sc_hd__inv_12
XTAP_TAPCELL_ROW_58_1143 VGND VPWR sky130_fd_sc_hd__tapvpwrvgnd_1
XFILLER_6_781 VPWR VGND VPWR VGND sky130_ef_sc_hd__decap_12
X_08970_ net1675 net259 net350 VGND VGND VPWR VPWR _01142_ sky130_fd_sc_hd__mux2_1
X_07921_ net695 _04000_ net621 VGND VGND VPWR VPWR _04004_ sky130_fd_sc_hd__o21a_1
XTAP_TAPCELL_ROW_71_1332 VGND VPWR sky130_fd_sc_hd__tapvpwrvgnd_1
XFILLER_96_563 VGND VGND VPWR VPWR sky130_fd_sc_hd__decap_8
XFILLER_96_552 VGND VGND VPWR VPWR sky130_fd_sc_hd__decap_3
X_07852_ picorv32_core.decoded_imm\[18\] net591 net596 VGND VGND VPWR VPWR _03939_
+ sky130_fd_sc_hd__a21o_1
X_06803_ _02921_ _03012_ VGND VGND VPWR VPWR _03030_ sky130_fd_sc_hd__nand2_1
Xinput1 mem_axi_arready VGND VGND VPWR VPWR net1 sky130_fd_sc_hd__clkbuf_1
Xclkbuf_leaf_48_clk clknet_4_7_0_clk VGND VGND VPWR VPWR clknet_leaf_48_clk sky130_fd_sc_hd__clkbuf_8
X_07783_ picorv32_core.cpuregs\[8\]\[15\] picorv32_core.cpuregs\[9\]\[15\] picorv32_core.cpuregs\[10\]\[15\]
+ picorv32_core.cpuregs\[11\]\[15\] net740 net707 VGND VGND VPWR VPWR _03873_ sky130_fd_sc_hd__mux4_1
X_09522_ picorv32_core.cpuregs\[28\]\[15\] picorv32_core.cpuregs\[29\]\[15\] picorv32_core.cpuregs\[30\]\[15\]
+ picorv32_core.cpuregs\[31\]\[15\] net882 net849 VGND VGND VPWR VPWR _04706_ sky130_fd_sc_hd__mux4_1
XFILLER_71_408 VPWR VGND VPWR VGND sky130_ef_sc_hd__decap_12
X_06734_ _02964_ _02965_ VGND VGND VPWR VPWR _02966_ sky130_fd_sc_hd__nand2_1
X_06665_ _02704_ picorv32_core.reg_next_pc\[10\] _02910_ VGND VGND VPWR VPWR _02922_
+ sky130_fd_sc_hd__mux2_2
X_09453_ picorv32_core.cpuregs\[28\]\[12\] picorv32_core.cpuregs\[29\]\[12\] picorv32_core.cpuregs\[30\]\[12\]
+ picorv32_core.cpuregs\[31\]\[12\] net880 net847 VGND VGND VPWR VPWR _04640_ sky130_fd_sc_hd__mux4_1
X_05616_ picorv32_core.reg_pc\[30\] picorv32_core.decoded_imm\[30\] VGND VGND VPWR
+ VPWR _02102_ sky130_fd_sc_hd__nand2_1
X_09384_ picorv32_core.cpuregs\[20\]\[9\] picorv32_core.cpuregs\[21\]\[9\] picorv32_core.cpuregs\[22\]\[9\]
+ picorv32_core.cpuregs\[23\]\[9\] net873 net840 VGND VGND VPWR VPWR _04574_ sky130_fd_sc_hd__mux4_1
X_08404_ _01667_ _03579_ _03584_ _04279_ VGND VGND VPWR VPWR _04280_ sky130_fd_sc_hd__a31o_1
X_06596_ picorv32_core.count_instr\[47\] picorv32_core.count_instr\[46\] picorv32_core.count_instr\[45\]
+ _02874_ VGND VGND VPWR VPWR _02879_ sky130_fd_sc_hd__and4_1
X_08335_ net928 net968 net959 net927 VGND VGND VPWR VPWR _04239_ sky130_fd_sc_hd__a22o_1
X_05547_ picorv32_core.count_cycle\[24\] net600 VGND VGND VPWR VPWR _02039_ sky130_fd_sc_hd__or2_1
XTAP_TAPCELL_ROW_82_1494 VGND VPWR sky130_fd_sc_hd__tapvpwrvgnd_1
XFILLER_138_749 VGND VGND VPWR VPWR sky130_fd_sc_hd__decap_6
X_05478_ picorv32_core.count_cycle\[19\] net601 VGND VGND VPWR VPWR _01975_ sky130_fd_sc_hd__or2_1
X_08266_ net1337 net466 net411 VGND VGND VPWR VPWR _00490_ sky130_fd_sc_hd__mux2_1
X_07217_ picorv32_core.count_cycle\[52\] _03365_ picorv32_core.count_cycle\[53\] VGND
+ VGND VPWR VPWR _03368_ sky130_fd_sc_hd__a21o_1
X_08197_ picorv32_core.mem_rdata_q\[27\] picorv32_core.mem_rdata_q\[28\] _04201_ VGND
+ VGND VPWR VPWR _04202_ sky130_fd_sc_hd__nor3_1
X_07148_ net2259 _03323_ net994 VGND VGND VPWR VPWR _03325_ sky130_fd_sc_hd__o21ai_1
XFILLER_3_217 VGND VGND VPWR VPWR sky130_fd_sc_hd__decap_6
XFILLER_106_657 VGND VGND VPWR VPWR sky130_fd_sc_hd__decap_3
XFILLER_10_77 VGND VGND VPWR VPWR sky130_fd_sc_hd__decap_6
X_07079_ net1689 net2292 _03281_ VGND VGND VPWR VPWR _00262_ sky130_fd_sc_hd__a21oi_1
XFILLER_126_77 VGND VGND VPWR VPWR sky130_fd_sc_hd__decap_6
X_10090_ net1140 VGND VGND VPWR VPWR _00940_ sky130_fd_sc_hd__clkbuf_1
XFILLER_19_42 VPWR VGND VPWR VGND sky130_ef_sc_hd__decap_12
Xclkbuf_leaf_39_clk clknet_4_5_0_clk VGND VGND VPWR VPWR clknet_leaf_39_clk sky130_fd_sc_hd__clkbuf_8
XFILLER_62_419 VGND VGND VPWR VPWR sky130_fd_sc_hd__fill_1
X_10992_ clknet_leaf_141_clk _00843_ VGND VGND VPWR VPWR picorv32_core.cpuregs\[12\]\[6\]
+ sky130_fd_sc_hd__dfxtp_1
XFILLER_15_335 VGND VGND VPWR VPWR sky130_fd_sc_hd__fill_1
XPHY_EDGE_ROW_106_Left_248 VGND VGND VPWR VPWR sky130_fd_sc_hd__decap_3
XFILLER_70_463 VGND VGND VPWR VPWR sky130_fd_sc_hd__decap_6
X_11613_ clknet_leaf_45_clk _01444_ VGND VGND VPWR VPWR picorv32_core.cpuregs\[23\]\[26\]
+ sky130_fd_sc_hd__dfxtp_1
XFILLER_129_749 VPWR VGND VPWR VGND sky130_ef_sc_hd__decap_12
X_11544_ clknet_leaf_70_clk _01375_ VGND VGND VPWR VPWR picorv32_core.cpuregs\[30\]\[25\]
+ sky130_fd_sc_hd__dfxtp_1
XFILLER_7_501 VGND VGND VPWR VPWR sky130_fd_sc_hd__decap_3
X_11475_ clknet_leaf_62_clk _01311_ VGND VGND VPWR VPWR picorv32_core.cpuregs\[24\]\[26\]
+ sky130_fd_sc_hd__dfxtp_1
XFILLER_109_440 VGND VGND VPWR VPWR sky130_fd_sc_hd__decap_8
X_10426_ clknet_leaf_85_clk _01557_ VGND VGND VPWR VPWR picorv32_core.reg_out\[19\]
+ sky130_fd_sc_hd__dfxtp_1
XFILLER_124_454 VGND VGND VPWR VPWR sky130_fd_sc_hd__fill_2
XPHY_EDGE_ROW_115_Left_257 VGND VGND VPWR VPWR sky130_fd_sc_hd__decap_3
XTAP_TAPCELL_ROW_111_1911 VGND VPWR sky130_fd_sc_hd__tapvpwrvgnd_1
X_10357_ clknet_leaf_82_clk _00276_ VGND VGND VPWR VPWR picorv32_core.count_cycle\[15\]
+ sky130_fd_sc_hd__dfxtp_1
X_10288_ clknet_leaf_125_clk _00207_ VGND VGND VPWR VPWR picorv32_core.reg_pc\[9\]
+ sky130_fd_sc_hd__dfxtp_1
XFILLER_2_261 VGND VGND VPWR VPWR sky130_fd_sc_hd__fill_1
XTAP_TAPCELL_ROW_53_1073 VGND VPWR sky130_fd_sc_hd__tapvpwrvgnd_1
XFILLER_78_574 VPWR VGND VPWR VGND sky130_ef_sc_hd__decap_12
XFILLER_93_555 VGND VGND VPWR VPWR sky130_fd_sc_hd__decap_4
XTAP_TAPCELL_ROW_140_2329 VGND VPWR sky130_fd_sc_hd__tapvpwrvgnd_1
XFILLER_81_717 VGND VGND VPWR VPWR sky130_fd_sc_hd__decap_4
XPHY_EDGE_ROW_124_Left_266 VGND VGND VPWR VPWR sky130_fd_sc_hd__decap_3
XTAP_TAPCELL_ROW_109_1884 VGND VPWR sky130_fd_sc_hd__tapvpwrvgnd_1
XFILLER_18_173 VGND VGND VPWR VPWR sky130_fd_sc_hd__fill_2
X_06450_ net278 net2116 net418 VGND VGND VPWR VPWR _00116_ sky130_fd_sc_hd__mux2_1
X_05401_ net926 _01797_ net585 VGND VGND VPWR VPWR _01903_ sky130_fd_sc_hd__a21o_1
XFILLER_33_165 VGND VGND VPWR VPWR sky130_fd_sc_hd__decap_3
X_06381_ picorv32_core.reg_out\[28\] picorv32_core.alu_out_q\[28\] net953 VGND VGND
+ VPWR VPWR _02779_ sky130_fd_sc_hd__mux2_1
XFILLER_119_215 VGND VGND VPWR VPWR sky130_fd_sc_hd__fill_1
X_08120_ net270 net1391 net415 VGND VGND VPWR VPWR _00413_ sky130_fd_sc_hd__mux2_1
X_05332_ _01834_ _01835_ _01830_ _01833_ VGND VGND VPWR VPWR _01839_ sky130_fd_sc_hd__o211ai_1
X_08051_ net954 net511 _04125_ _04126_ VGND VGND VPWR VPWR _00389_ sky130_fd_sc_hd__o22a_1
X_05263_ picorv32_core.count_cycle\[4\] net599 net576 _01774_ VGND VGND VPWR VPWR
+ _01775_ sky130_fd_sc_hd__o211a_1
XFILLER_128_793 VPWR VGND VPWR VGND sky130_ef_sc_hd__decap_12
X_07002_ net932 _02937_ VGND VGND VPWR VPWR _03213_ sky130_fd_sc_hd__or2_1
XPHY_EDGE_ROW_133_Left_275 VGND VGND VPWR VPWR sky130_fd_sc_hd__decap_3
XFILLER_127_281 VGND VGND VPWR VPWR sky130_fd_sc_hd__decap_3
X_05194_ axi_adapter.ack_wvalid _01713_ VGND VGND VPWR VPWR net140 sky130_fd_sc_hd__nor2_1
XFILLER_0_209 VPWR VGND VPWR VGND sky130_ef_sc_hd__decap_12
XFILLER_103_638 VGND VGND VPWR VPWR sky130_fd_sc_hd__decap_8
XFILLER_103_627 VGND VGND VPWR VPWR sky130_fd_sc_hd__fill_2
X_08953_ net1454 net503 net349 VGND VGND VPWR VPWR _01125_ sky130_fd_sc_hd__mux2_1
X_07904_ _03978_ _03986_ _03987_ net621 net689 VGND VGND VPWR VPWR _03988_ sky130_fd_sc_hd__a221o_1
X_08884_ net211 net2229 net364 VGND VGND VPWR VPWR _01059_ sky130_fd_sc_hd__mux2_1
XFILLER_96_382 VGND VGND VPWR VPWR sky130_fd_sc_hd__fill_2
XFILLER_56_29 VGND VGND VPWR VPWR sky130_fd_sc_hd__fill_2
X_07835_ picorv32_core.cpuregs\[20\]\[18\] picorv32_core.cpuregs\[21\]\[18\] picorv32_core.cpuregs\[22\]\[18\]
+ picorv32_core.cpuregs\[23\]\[18\] net758 net725 VGND VGND VPWR VPWR _03922_ sky130_fd_sc_hd__mux4_1
XFILLER_84_533 VGND VGND VPWR VPWR sky130_fd_sc_hd__decap_3
XFILLER_56_235 VGND VGND VPWR VPWR sky130_fd_sc_hd__fill_1
XFILLER_72_717 VGND VGND VPWR VPWR sky130_fd_sc_hd__decap_4
X_07766_ picorv32_core.cpuregs\[28\]\[14\] picorv32_core.cpuregs\[29\]\[14\] picorv32_core.cpuregs\[30\]\[14\]
+ picorv32_core.cpuregs\[31\]\[14\] net738 net705 VGND VGND VPWR VPWR _03857_ sky130_fd_sc_hd__mux4_1
XTAP_TAPCELL_ROW_84_1523 VGND VPWR sky130_fd_sc_hd__tapvpwrvgnd_1
X_09505_ net826 _04689_ _04688_ net478 VGND VGND VPWR VPWR _04690_ sky130_fd_sc_hd__o211a_1
X_06717_ picorv32_core.decoded_imm_j\[1\] _02911_ _02949_ VGND VGND VPWR VPWR _02951_
+ sky130_fd_sc_hd__nand3_1
XFILLER_37_493 VGND VGND VPWR VPWR sky130_fd_sc_hd__fill_1
X_07697_ picorv32_core.cpuregs\[0\]\[10\] picorv32_core.cpuregs\[1\]\[10\] picorv32_core.cpuregs\[2\]\[10\]
+ picorv32_core.cpuregs\[3\]\[10\] net736 net703 VGND VGND VPWR VPWR _03792_ sky130_fd_sc_hd__mux4_1
X_09436_ picorv32_core.cpuregs\[28\]\[11\] picorv32_core.cpuregs\[29\]\[11\] picorv32_core.cpuregs\[30\]\[11\]
+ picorv32_core.cpuregs\[31\]\[11\] net878 net845 VGND VGND VPWR VPWR _04624_ sky130_fd_sc_hd__mux4_1
X_06648_ net924 net975 VGND VGND VPWR VPWR _02913_ sky130_fd_sc_hd__nor2_1
XFILLER_40_625 VGND VGND VPWR VPWR sky130_fd_sc_hd__decap_4
XFILLER_40_636 VGND VGND VPWR VPWR sky130_fd_sc_hd__fill_1
X_06579_ _02868_ net986 _02867_ VGND VGND VPWR VPWR _00175_ sky130_fd_sc_hd__and3b_1
X_09367_ picorv32_core.cpuregs\[28\]\[8\] picorv32_core.cpuregs\[29\]\[8\] picorv32_core.cpuregs\[30\]\[8\]
+ picorv32_core.cpuregs\[31\]\[8\] net881 net848 VGND VGND VPWR VPWR _04558_ sky130_fd_sc_hd__mux4_1
X_08318_ net2297 net526 _04232_ _04234_ VGND VGND VPWR VPWR _00537_ sky130_fd_sc_hd__a31o_1
X_09298_ picorv32_core.cpuregs\[28\]\[5\] picorv32_core.cpuregs\[29\]\[5\] picorv32_core.cpuregs\[30\]\[5\]
+ picorv32_core.cpuregs\[31\]\[5\] net875 net842 VGND VGND VPWR VPWR _04492_ sky130_fd_sc_hd__mux4_1
XANTENNA_50 net354 VGND VGND VPWR VPWR sky130_fd_sc_hd__diode_2
XFILLER_138_546 VGND VGND VPWR VPWR sky130_fd_sc_hd__fill_1
XANTENNA_72 _00006_ VGND VGND VPWR VPWR sky130_fd_sc_hd__diode_2
X_08249_ picorv32_core.mem_rdata_q\[28\] net24 net520 VGND VGND VPWR VPWR _00769_
+ sky130_fd_sc_hd__mux2_1
XANTENNA_83 net181 VGND VGND VPWR VPWR sky130_fd_sc_hd__diode_2
XANTENNA_61 net613 VGND VGND VPWR VPWR sky130_fd_sc_hd__diode_2
XANTENNA_94 net962 VGND VGND VPWR VPWR sky130_fd_sc_hd__diode_2
XFILLER_134_730 VPWR VGND VPWR VGND sky130_ef_sc_hd__decap_12
XFILLER_108_3 VPWR VGND VPWR VGND sky130_ef_sc_hd__decap_12
X_11260_ clknet_leaf_16_clk _01108_ VGND VGND VPWR VPWR picorv32_core.cpuregs\[4\]\[15\]
+ sky130_fd_sc_hd__dfxtp_1
XFILLER_4_526 VGND VGND VPWR VPWR sky130_fd_sc_hd__decap_6
X_10211_ clknet_leaf_42_clk _00130_ VGND VGND VPWR VPWR picorv32_core.cpuregs\[9\]\[27\]
+ sky130_fd_sc_hd__dfxtp_1
XTAP_TAPCELL_ROW_95_1685 VGND VPWR sky130_fd_sc_hd__tapvpwrvgnd_1
X_11191_ clknet_leaf_15_clk _01042_ VGND VGND VPWR VPWR picorv32_core.cpuregs\[6\]\[13\]
+ sky130_fd_sc_hd__dfxtp_1
X_10142_ clknet_leaf_66_clk _00064_ VGND VGND VPWR VPWR picorv32_core.cpuregs\[22\]\[25\]
+ sky130_fd_sc_hd__dfxtp_1
XFILLER_0_721 VGND VGND VPWR VPWR sky130_fd_sc_hd__decap_3
Xoutput190 net190 VGND VGND VPWR VPWR pcpi_rs2[25] sky130_fd_sc_hd__buf_2
X_10073_ picorv32_core.decoded_imm_j\[4\] _00765_ net438 VGND VGND VPWR VPWR _00474_
+ sky130_fd_sc_hd__mux2_1
XFILLER_75_522 VGND VGND VPWR VPWR sky130_fd_sc_hd__fill_1
XFILLER_0_776 VGND VGND VPWR VPWR sky130_fd_sc_hd__decap_4
XFILLER_87_393 VPWR VGND VPWR VGND sky130_ef_sc_hd__decap_12
XFILLER_48_769 VGND VGND VPWR VPWR sky130_fd_sc_hd__fill_1
XFILLER_75_566 VGND VGND VPWR VPWR sky130_fd_sc_hd__fill_2
XFILLER_35_408 VGND VGND VPWR VPWR sky130_fd_sc_hd__decap_4
X_10975_ clknet_leaf_49_clk _00826_ VGND VGND VPWR VPWR picorv32_core.cpuregs\[13\]\[21\]
+ sky130_fd_sc_hd__dfxtp_1
XFILLER_43_430 VGND VGND VPWR VPWR sky130_fd_sc_hd__decap_3
XFILLER_16_699 VGND VGND VPWR VPWR sky130_fd_sc_hd__fill_1
XTAP_TAPCELL_ROW_26_683 VGND VPWR sky130_fd_sc_hd__tapvpwrvgnd_1
X_11527_ clknet_leaf_129_clk _01358_ VGND VGND VPWR VPWR picorv32_core.cpuregs\[30\]\[8\]
+ sky130_fd_sc_hd__dfxtp_1
XTAP_TAPCELL_ROW_137_2291 VGND VPWR sky130_fd_sc_hd__tapvpwrvgnd_1
XFILLER_125_741 VPWR VGND VPWR VGND sky130_ef_sc_hd__decap_12
Xhold309 picorv32_core.cpuregs\[26\]\[29\] VGND VGND VPWR VPWR net1418 sky130_fd_sc_hd__dlygate4sd3_1
X_11458_ clknet_leaf_140_clk _01294_ VGND VGND VPWR VPWR picorv32_core.cpuregs\[24\]\[9\]
+ sky130_fd_sc_hd__dfxtp_1
XFILLER_125_785 VPWR VGND VPWR VGND sky130_ef_sc_hd__decap_12
XTAP_TAPCELL_ROW_55_1102 VGND VPWR sky130_fd_sc_hd__tapvpwrvgnd_1
X_11389_ clknet_leaf_111_clk _01225_ VGND VGND VPWR VPWR picorv32_core.cpuregs\[31\]\[4\]
+ sky130_fd_sc_hd__dfxtp_1
X_10409_ clknet_leaf_105_clk _01569_ VGND VGND VPWR VPWR picorv32_core.reg_out\[2\]
+ sky130_fd_sc_hd__dfxtp_1
XFILLER_97_124 VGND VGND VPWR VPWR sky130_fd_sc_hd__decap_3
XFILLER_97_113 VGND VGND VPWR VPWR sky130_fd_sc_hd__fill_2
XFILLER_140_755 VGND VGND VPWR VPWR sky130_fd_sc_hd__fill_1
X_05950_ net507 _02417_ _02418_ _02411_ VGND VGND VPWR VPWR picorv32_core.alu_out\[15\]
+ sky130_fd_sc_hd__a31o_1
XFILLER_23_3 VPWR VGND VPWR VGND sky130_ef_sc_hd__decap_12
Xhold1009 picorv32_core.cpuregs\[4\]\[7\] VGND VGND VPWR VPWR net2118 sky130_fd_sc_hd__dlygate4sd3_1
X_05881_ net801 _02353_ VGND VGND VPWR VPWR _02355_ sky130_fd_sc_hd__or2_1
XFILLER_81_514 VGND VGND VPWR VPWR sky130_fd_sc_hd__fill_2
XFILLER_54_706 VGND VGND VPWR VPWR sky130_fd_sc_hd__decap_8
X_07620_ picorv32_core.cpuregs\[4\]\[6\] picorv32_core.cpuregs\[5\]\[6\] picorv32_core.cpuregs\[6\]\[6\]
+ picorv32_core.cpuregs\[7\]\[6\] net732 net699 VGND VGND VPWR VPWR _03719_ sky130_fd_sc_hd__mux4_1
XFILLER_26_419 VGND VGND VPWR VPWR sky130_fd_sc_hd__fill_1
XFILLER_93_385 VGND VGND VPWR VPWR sky130_fd_sc_hd__decap_4
XFILLER_81_547 VGND VGND VPWR VPWR sky130_fd_sc_hd__decap_3
X_07551_ _03654_ _03655_ net632 VGND VGND VPWR VPWR _03656_ sky130_fd_sc_hd__mux2_1
XFILLER_47_780 VGND VGND VPWR VPWR sky130_fd_sc_hd__decap_4
X_06502_ _02819_ net992 _02818_ VGND VGND VPWR VPWR _00147_ sky130_fd_sc_hd__and3b_1
XFILLER_46_290 VGND VGND VPWR VPWR sky130_fd_sc_hd__fill_1
X_07482_ picorv32_core.reg_out\[14\] picorv32_core.reg_next_pc\[14\] net558 VGND VGND
+ VPWR VPWR _03609_ sky130_fd_sc_hd__mux2_1
XTAP_TAPCELL_ROW_66_1264 VGND VPWR sky130_fd_sc_hd__tapvpwrvgnd_1
X_06433_ net212 net1841 net425 VGND VGND VPWR VPWR _00101_ sky130_fd_sc_hd__mux2_1
X_09221_ net835 _04415_ net830 VGND VGND VPWR VPWR _04418_ sky130_fd_sc_hd__a21oi_1
X_06364_ net1439 net233 net435 VGND VGND VPWR VPWR _00063_ sky130_fd_sc_hd__mux2_1
X_09152_ net2086 net522 _04193_ picorv32_core.is_sb_sh_sw VGND VGND VPWR VPWR _01318_
+ sky130_fd_sc_hd__a22o_1
X_05315_ net925 _01719_ net585 VGND VGND VPWR VPWR _01823_ sky130_fd_sc_hd__a21o_1
X_08103_ net949 net948 net947 VGND VGND VPWR VPWR _04171_ sky130_fd_sc_hd__nand3b_2
XFILLER_135_505 VGND VGND VPWR VPWR sky130_fd_sc_hd__decap_4
X_09083_ net1519 net210 net339 VGND VGND VPWR VPWR _01251_ sky130_fd_sc_hd__mux2_1
X_06295_ picorv32_core.reg_pc\[11\] picorv32_core.reg_pc\[10\] _02701_ VGND VGND VPWR
+ VPWR _02710_ sky130_fd_sc_hd__and3_1
XFILLER_135_549 VGND VGND VPWR VPWR sky130_fd_sc_hd__decap_3
X_08034_ picorv32_core.cpuregs\[16\]\[29\] picorv32_core.cpuregs\[17\]\[29\] picorv32_core.cpuregs\[18\]\[29\]
+ picorv32_core.cpuregs\[19\]\[29\] net761 net728 VGND VGND VPWR VPWR _04110_ sky130_fd_sc_hd__mux4_1
Xhold821 picorv32_core.cpuregs\[4\]\[12\] VGND VGND VPWR VPWR net1930 sky130_fd_sc_hd__dlygate4sd3_1
X_05246_ net14 _01717_ _01722_ net29 _01758_ VGND VGND VPWR VPWR _01759_ sky130_fd_sc_hd__a221o_1
Xhold810 picorv32_core.cpuregs\[13\]\[1\] VGND VGND VPWR VPWR net1919 sky130_fd_sc_hd__dlygate4sd3_1
Xhold832 picorv32_core.cpuregs\[16\]\[26\] VGND VGND VPWR VPWR net1941 sky130_fd_sc_hd__dlygate4sd3_1
Xhold854 picorv32_core.cpuregs\[6\]\[12\] VGND VGND VPWR VPWR net1963 sky130_fd_sc_hd__dlygate4sd3_1
Xhold843 picorv32_core.cpuregs\[1\]\[7\] VGND VGND VPWR VPWR net1952 sky130_fd_sc_hd__dlygate4sd3_1
X_05177_ picorv32_core.cpu_state\[1\] net970 VGND VGND VPWR VPWR _01700_ sky130_fd_sc_hd__and2_2
XFILLER_131_722 VGND VGND VPWR VPWR sky130_fd_sc_hd__decap_6
Xhold876 picorv32_core.cpuregs\[9\]\[30\] VGND VGND VPWR VPWR net1985 sky130_fd_sc_hd__dlygate4sd3_1
Xhold865 picorv32_core.cpuregs\[2\]\[22\] VGND VGND VPWR VPWR net1974 sky130_fd_sc_hd__dlygate4sd3_1
Xhold898 picorv32_core.cpuregs\[7\]\[22\] VGND VGND VPWR VPWR net2007 sky130_fd_sc_hd__dlygate4sd3_1
Xhold887 picorv32_core.cpuregs\[22\]\[1\] VGND VGND VPWR VPWR net1996 sky130_fd_sc_hd__dlygate4sd3_1
XFILLER_131_777 VGND VGND VPWR VPWR sky130_fd_sc_hd__decap_6
XFILLER_130_221 VGND VGND VPWR VPWR sky130_fd_sc_hd__decap_4
XFILLER_103_446 VGND VGND VPWR VPWR sky130_fd_sc_hd__fill_2
XFILLER_88_157 VGND VGND VPWR VPWR sky130_fd_sc_hd__fill_1
X_09985_ net1667 net289 net312 VGND VGND VPWR VPWR _01462_ sky130_fd_sc_hd__mux2_1
X_08936_ net266 net2206 net355 VGND VGND VPWR VPWR _01109_ sky130_fd_sc_hd__mux2_1
X_08867_ net278 net1977 net362 VGND VGND VPWR VPWR _01042_ sky130_fd_sc_hd__mux2_1
XTAP_TAPCELL_ROW_4_367 VGND VPWR sky130_fd_sc_hd__tapvpwrvgnd_1
XTAP_TAPCELL_ROW_4_356 VGND VPWR sky130_fd_sc_hd__tapvpwrvgnd_1
X_07818_ net696 _03905_ VGND VGND VPWR VPWR _03906_ sky130_fd_sc_hd__or2_1
XFILLER_83_27 VGND VGND VPWR VPWR sky130_fd_sc_hd__fill_1
X_08798_ net292 net2039 net370 VGND VGND VPWR VPWR _00976_ sky130_fd_sc_hd__mux2_1
XFILLER_60_709 VGND VGND VPWR VPWR sky130_fd_sc_hd__fill_2
X_07749_ picorv32_core.cpuregs\[8\]\[13\] picorv32_core.cpuregs\[9\]\[13\] picorv32_core.cpuregs\[10\]\[13\]
+ picorv32_core.cpuregs\[11\]\[13\] net740 net707 VGND VGND VPWR VPWR _03841_ sky130_fd_sc_hd__mux4_1
XFILLER_25_441 VGND VGND VPWR VPWR sky130_fd_sc_hd__decap_6
XFILLER_53_783 VGND VGND VPWR VPWR sky130_fd_sc_hd__fill_1
X_10760_ clknet_leaf_114_clk _00611_ VGND VGND VPWR VPWR picorv32_core.cpuregs\[14\]\[1\]
+ sky130_fd_sc_hd__dfxtp_1
XFILLER_13_614 VGND VGND VPWR VPWR sky130_fd_sc_hd__fill_2
XFILLER_16_65 VGND VGND VPWR VPWR sky130_fd_sc_hd__decap_8
XTAP_TAPCELL_ROW_43_929 VGND VPWR sky130_fd_sc_hd__tapvpwrvgnd_1
X_09419_ picorv32_core.reg_pc\[10\] net539 _04607_ net482 VGND VGND VPWR VPWR _04608_
+ sky130_fd_sc_hd__a211o_1
X_10691_ clknet_leaf_136_clk _00542_ VGND VGND VPWR VPWR net115 sky130_fd_sc_hd__dfxtp_1
XTAP_TAPCELL_ROW_23_642 VGND VPWR sky130_fd_sc_hd__tapvpwrvgnd_1
XFILLER_40_477 VGND VGND VPWR VPWR sky130_fd_sc_hd__decap_8
XTAP_TAPCELL_ROW_97_1714 VGND VPWR sky130_fd_sc_hd__tapvpwrvgnd_1
XFILLER_8_139 VGND VGND VPWR VPWR sky130_fd_sc_hd__fill_1
XFILLER_40_499 VGND VGND VPWR VPWR sky130_fd_sc_hd__decap_4
X_11312_ clknet_leaf_95_clk _00013_ VGND VGND VPWR VPWR picorv32_core.cpu_state\[3\]
+ sky130_fd_sc_hd__dfxtp_2
XFILLER_107_752 VGND VGND VPWR VPWR sky130_fd_sc_hd__fill_1
X_11243_ clknet_leaf_96_clk _00018_ VGND VGND VPWR VPWR picorv32_core.mem_wordsize\[1\]
+ sky130_fd_sc_hd__dfxtp_1
XFILLER_79_113 VGND VGND VPWR VPWR sky130_fd_sc_hd__fill_1
X_11174_ clknet_leaf_37_clk _01025_ VGND VGND VPWR VPWR picorv32_core.cpuregs\[7\]\[28\]
+ sky130_fd_sc_hd__dfxtp_1
XFILLER_95_617 VGND VGND VPWR VPWR sky130_fd_sc_hd__decap_4
X_10125_ clknet_leaf_12_clk _00047_ VGND VGND VPWR VPWR picorv32_core.cpuregs\[22\]\[8\]
+ sky130_fd_sc_hd__dfxtp_1
XFILLER_94_149 VGND VGND VPWR VPWR sky130_fd_sc_hd__fill_1
X_10056_ net1514 net261 net306 VGND VGND VPWR VPWR _01531_ sky130_fd_sc_hd__mux2_1
XTAP_TAPCELL_ROW_50_1032 VGND VPWR sky130_fd_sc_hd__tapvpwrvgnd_1
XFILLER_48_533 VGND VGND VPWR VPWR sky130_fd_sc_hd__decap_4
XTAP_TAPCELL_ROW_106_1843 VGND VPWR sky130_fd_sc_hd__tapvpwrvgnd_1
X_10958_ clknet_leaf_115_clk _00809_ VGND VGND VPWR VPWR picorv32_core.cpuregs\[13\]\[4\]
+ sky130_fd_sc_hd__dfxtp_1
XTAP_TAPCELL_ROW_139_2320 VGND VPWR sky130_fd_sc_hd__tapvpwrvgnd_1
XFILLER_71_591 VGND VGND VPWR VPWR sky130_fd_sc_hd__fill_2
X_10889_ clknet_leaf_108_clk _00740_ VGND VGND VPWR VPWR axi_adapter.ack_wvalid sky130_fd_sc_hd__dfxtp_1
XTAP_TAPCELL_ROW_61_1183 VGND VPWR sky130_fd_sc_hd__tapvpwrvgnd_1
XFILLER_31_499 VGND VGND VPWR VPWR sky130_fd_sc_hd__decap_4
XTAP_TAPCELL_ROW_61_1194 VGND VPWR sky130_fd_sc_hd__tapvpwrvgnd_1
Xhold117 picorv32_core.cpuregs\[7\]\[28\] VGND VGND VPWR VPWR net1226 sky130_fd_sc_hd__dlygate4sd3_1
X_06080_ net769 net191 net569 VGND VGND VPWR VPWR _02538_ sky130_fd_sc_hd__and3_1
Xhold106 picorv32_core.cpuregs\[27\]\[16\] VGND VGND VPWR VPWR net1215 sky130_fd_sc_hd__dlygate4sd3_1
XFILLER_7_161 VGND VGND VPWR VPWR sky130_fd_sc_hd__decap_6
X_05100_ picorv32_core.mem_do_wdata _01631_ VGND VGND VPWR VPWR _01632_ sky130_fd_sc_hd__nor2_1
XPHY_EDGE_ROW_9_Right_9 VGND VGND VPWR VPWR sky130_fd_sc_hd__decap_3
Xhold139 picorv32_core.cpuregs\[28\]\[4\] VGND VGND VPWR VPWR net1248 sky130_fd_sc_hd__dlygate4sd3_1
Xhold128 picorv32_core.cpuregs\[19\]\[9\] VGND VGND VPWR VPWR net1237 sky130_fd_sc_hd__dlygate4sd3_1
Xfanout608 net609 VGND VGND VPWR VPWR net608 sky130_fd_sc_hd__buf_2
Xfanout619 _01621_ VGND VGND VPWR VPWR net619 sky130_fd_sc_hd__clkbuf_4
X_09770_ net834 _04939_ _04942_ net481 VGND VGND VPWR VPWR _04943_ sky130_fd_sc_hd__o211a_1
XFILLER_113_777 VGND VGND VPWR VPWR sky130_fd_sc_hd__decap_6
XPHY_EDGE_ROW_107_Right_107 VGND VGND VPWR VPWR sky130_fd_sc_hd__decap_3
X_06982_ net678 net589 _03193_ _03194_ VGND VGND VPWR VPWR _03195_ sky130_fd_sc_hd__and4_1
X_05933_ net793 _02401_ VGND VGND VPWR VPWR _02403_ sky130_fd_sc_hd__or2_1
X_08721_ net1320 net503 net381 VGND VGND VPWR VPWR _00869_ sky130_fd_sc_hd__mux2_1
XFILLER_39_533 VGND VGND VPWR VPWR sky130_fd_sc_hd__fill_1
X_08652_ net1378 net212 net393 VGND VGND VPWR VPWR _00803_ sky130_fd_sc_hd__mux2_1
XTAP_TAPCELL_ROW_1_315 VGND VPWR sky130_fd_sc_hd__tapvpwrvgnd_1
XFILLER_54_536 VPWR VGND VPWR VGND sky130_ef_sc_hd__decap_12
X_05864_ net805 net960 net606 _02339_ VGND VGND VPWR VPWR _02340_ sky130_fd_sc_hd__o22a_1
X_07603_ picorv32_core.cpuregs\[4\]\[5\] picorv32_core.cpuregs\[5\]\[5\] picorv32_core.cpuregs\[6\]\[5\]
+ picorv32_core.cpuregs\[7\]\[5\] net734 net701 VGND VGND VPWR VPWR _03703_ sky130_fd_sc_hd__mux4_1
XTAP_TAPCELL_ROW_1_326 VGND VPWR sky130_fd_sc_hd__tapvpwrvgnd_1
X_08583_ _04225_ _04327_ VGND VGND VPWR VPWR _04330_ sky130_fd_sc_hd__or2_4
X_05795_ net606 _02135_ _02137_ net572 _02275_ VGND VGND VPWR VPWR _02276_ sky130_fd_sc_hd__a221o_1
X_07534_ net971 _03643_ net534 VGND VGND VPWR VPWR _03644_ sky130_fd_sc_hd__mux2_1
XFILLER_53_19 VGND VGND VPWR VPWR sky130_fd_sc_hd__decap_3
XFILLER_35_783 VGND VGND VPWR VPWR sky130_fd_sc_hd__fill_1
X_07465_ net171 _03597_ net532 VGND VGND VPWR VPWR _03598_ sky130_fd_sc_hd__mux2_1
X_06416_ net276 net1693 net423 VGND VGND VPWR VPWR _00084_ sky130_fd_sc_hd__mux2_1
X_09204_ net152 _04401_ net282 VGND VGND VPWR VPWR _01320_ sky130_fd_sc_hd__mux2_1
X_07396_ net766 picorv32_core.decoded_imm\[28\] _03535_ VGND VGND VPWR VPWR _03536_
+ sky130_fd_sc_hd__a21o_1
XTAP_TAPCELL_ROW_20_601 VGND VPWR sky130_fd_sc_hd__tapvpwrvgnd_1
XFILLER_136_825 VGND VGND VPWR VPWR sky130_fd_sc_hd__decap_8
X_06347_ _02748_ _02751_ net565 VGND VGND VPWR VPWR _02752_ sky130_fd_sc_hd__mux2_2
X_09135_ net1234 net267 net330 VGND VGND VPWR VPWR _01301_ sky130_fd_sc_hd__mux2_1
XTAP_TAPCELL_ROW_79_1444 VGND VPWR sky130_fd_sc_hd__tapvpwrvgnd_1
XTAP_TAPCELL_ROW_79_1455 VGND VPWR sky130_fd_sc_hd__tapvpwrvgnd_1
X_09066_ net1533 net277 net336 VGND VGND VPWR VPWR _01234_ sky130_fd_sc_hd__mux2_1
X_06278_ picorv32_core.reg_out\[8\] picorv32_core.alu_out_q\[8\] net950 VGND VGND
+ VPWR VPWR _02696_ sky130_fd_sc_hd__mux2_1
X_08017_ picorv32_core.cpuregs\[28\]\[28\] picorv32_core.cpuregs\[29\]\[28\] picorv32_core.cpuregs\[30\]\[28\]
+ picorv32_core.cpuregs\[31\]\[28\] net754 net721 VGND VGND VPWR VPWR _04094_ sky130_fd_sc_hd__mux4_1
XFILLER_123_519 VGND VGND VPWR VPWR sky130_fd_sc_hd__decap_4
XFILLER_2_805 VGND VGND VPWR VPWR sky130_fd_sc_hd__decap_6
X_05229_ picorv32_core.reg_pc\[2\] picorv32_core.decoded_imm\[2\] VGND VGND VPWR VPWR
+ _01743_ sky130_fd_sc_hd__nand2_1
XTAP_TAPCELL_ROW_92_1644 VGND VPWR sky130_fd_sc_hd__tapvpwrvgnd_1
XTAP_TAPCELL_ROW_92_1633 VGND VPWR sky130_fd_sc_hd__tapvpwrvgnd_1
Xhold662 picorv32_core.cpuregs\[28\]\[17\] VGND VGND VPWR VPWR net1771 sky130_fd_sc_hd__dlygate4sd3_1
Xhold640 picorv32_core.cpuregs\[16\]\[12\] VGND VGND VPWR VPWR net1749 sky130_fd_sc_hd__dlygate4sd3_1
Xhold651 picorv32_core.cpuregs\[30\]\[5\] VGND VGND VPWR VPWR net1760 sky130_fd_sc_hd__dlygate4sd3_1
XTAP_TAPCELL_ROW_9_437 VGND VPWR sky130_fd_sc_hd__tapvpwrvgnd_1
Xhold684 picorv32_core.cpuregs\[18\]\[30\] VGND VGND VPWR VPWR net1793 sky130_fd_sc_hd__dlygate4sd3_1
XFILLER_131_541 VGND VGND VPWR VPWR sky130_fd_sc_hd__fill_2
Xhold695 picorv32_core.cpuregs\[29\]\[26\] VGND VGND VPWR VPWR net1804 sky130_fd_sc_hd__dlygate4sd3_1
Xhold673 picorv32_core.cpuregs\[8\]\[29\] VGND VGND VPWR VPWR net1782 sky130_fd_sc_hd__dlygate4sd3_1
X_09968_ net1216 net218 net318 VGND VGND VPWR VPWR _01446_ sky130_fd_sc_hd__mux2_1
XFILLER_77_617 VGND VGND VPWR VPWR sky130_fd_sc_hd__fill_1
XFILLER_134_77 VGND VGND VPWR VPWR sky130_fd_sc_hd__decap_6
X_08919_ _04225_ _04340_ VGND VGND VPWR VPWR _04344_ sky130_fd_sc_hd__or2_1
XFILLER_94_48 VGND VGND VPWR VPWR sky130_fd_sc_hd__fill_2
XFILLER_18_717 VPWR VGND VPWR VGND sky130_ef_sc_hd__decap_12
X_09899_ picorv32_core.latched_rd\[4\] picorv32_core.latched_rd\[3\] picorv32_core.latched_rd\[2\]
+ _02666_ VGND VGND VPWR VPWR _05033_ sky130_fd_sc_hd__or4_4
XFILLER_17_205 VGND VGND VPWR VPWR sky130_fd_sc_hd__fill_1
XTAP_TAPCELL_ROW_28_712 VGND VPWR sky130_fd_sc_hd__tapvpwrvgnd_1
XFILLER_72_355 VGND VGND VPWR VPWR sky130_fd_sc_hd__fill_2
X_11861_ net966 VGND VGND VPWR VPWR net198 sky130_fd_sc_hd__clkbuf_1
X_10812_ clknet_leaf_50_clk _00663_ VGND VGND VPWR VPWR picorv32_core.cpuregs\[15\]\[21\]
+ sky130_fd_sc_hd__dfxtp_1
XFILLER_27_97 VGND VGND VPWR VPWR sky130_fd_sc_hd__decap_4
X_10743_ clknet_leaf_88_clk _00594_ VGND VGND VPWR VPWR picorv32_core.decoded_imm\[16\]
+ sky130_fd_sc_hd__dfxtp_2
XFILLER_53_580 VGND VGND VPWR VPWR sky130_fd_sc_hd__decap_3
XFILLER_13_411 VGND VGND VPWR VPWR sky130_fd_sc_hd__fill_2
XTAP_TAPCELL_ROW_101_1773 VGND VPWR sky130_fd_sc_hd__tapvpwrvgnd_1
X_10674_ clknet_leaf_111_clk _00528_ VGND VGND VPWR VPWR picorv32_core.decoded_imm_j\[1\]
+ sky130_fd_sc_hd__dfxtp_2
XTAP_TAPCELL_ROW_134_2250 VGND VPWR sky130_fd_sc_hd__tapvpwrvgnd_1
Xpicorv32_axi_1061 VGND VGND VPWR VPWR picorv32_axi_1061/HI pcpi_insn[21] sky130_fd_sc_hd__conb_1
Xpicorv32_axi_1050 VGND VGND VPWR VPWR picorv32_axi_1050/HI pcpi_insn[10] sky130_fd_sc_hd__conb_1
Xpicorv32_axi_1072 VGND VGND VPWR VPWR picorv32_axi_1072/HI pcpi_valid sky130_fd_sc_hd__conb_1
Xpicorv32_axi_1083 VGND VGND VPWR VPWR picorv32_axi_1083/HI trace_data[10] sky130_fd_sc_hd__conb_1
Xpicorv32_axi_1094 VGND VGND VPWR VPWR picorv32_axi_1094/HI trace_data[21] sky130_fd_sc_hd__conb_1
XFILLER_4_153 VPWR VGND VPWR VGND sky130_ef_sc_hd__decap_12
X_11226_ clknet_leaf_22_clk _01077_ VGND VGND VPWR VPWR picorv32_core.cpuregs\[5\]\[16\]
+ sky130_fd_sc_hd__dfxtp_1
XFILLER_4_197 VPWR VGND VPWR VGND sky130_ef_sc_hd__decap_12
XFILLER_95_403 VGND VGND VPWR VPWR sky130_fd_sc_hd__decap_6
X_11157_ clknet_leaf_4_clk _01008_ VGND VGND VPWR VPWR picorv32_core.cpuregs\[7\]\[11\]
+ sky130_fd_sc_hd__dfxtp_1
X_10108_ net1120 VGND VGND VPWR VPWR _00958_ sky130_fd_sc_hd__clkbuf_1
XFILLER_110_769 VPWR VGND VPWR VGND sky130_ef_sc_hd__decap_12
X_11088_ clknet_leaf_141_clk _00939_ VGND VGND VPWR VPWR picorv32_core.cpuregs\[0\]\[6\]
+ sky130_fd_sc_hd__dfxtp_1
X_10039_ net1510 net502 net304 VGND VGND VPWR VPWR _01514_ sky130_fd_sc_hd__mux2_1
XFILLER_90_141 VGND VGND VPWR VPWR sky130_fd_sc_hd__decap_3
XFILLER_63_333 VGND VGND VPWR VPWR sky130_fd_sc_hd__decap_3
X_05580_ net23 net583 net574 VGND VGND VPWR VPWR _02069_ sky130_fd_sc_hd__a21o_1
XFILLER_17_783 VGND VGND VPWR VPWR sky130_fd_sc_hd__fill_1
XTAP_TAPCELL_ROW_63_1223 VGND VPWR sky130_fd_sc_hd__tapvpwrvgnd_1
XTAP_TAPCELL_ROW_63_1212 VGND VPWR sky130_fd_sc_hd__tapvpwrvgnd_1
XFILLER_32_775 VPWR VGND VPWR VGND sky130_ef_sc_hd__decap_12
X_07250_ picorv32_core.cpu_state\[2\] net915 VGND VGND VPWR VPWR _03390_ sky130_fd_sc_hd__nor2_1
XFILLER_118_825 VPWR VGND VPWR VGND sky130_ef_sc_hd__decap_12
X_07181_ _03344_ _03345_ VGND VGND VPWR VPWR _00300_ sky130_fd_sc_hd__nor2_1
X_06201_ _02627_ _02628_ _02631_ net688 net683 VGND VGND VPWR VPWR _02632_ sky130_fd_sc_hd__a221o_1
XFILLER_117_335 VGND VGND VPWR VPWR sky130_fd_sc_hd__fill_1
X_06132_ net196 _02585_ VGND VGND VPWR VPWR _02586_ sky130_fd_sc_hd__xnor2_1
X_06063_ _02511_ _02520_ _02521_ VGND VGND VPWR VPWR _02523_ sky130_fd_sc_hd__or3_1
Xfanout405 _04326_ VGND VGND VPWR VPWR net405 sky130_fd_sc_hd__buf_4
XTAP_TAPCELL_ROW_74_1374 VGND VPWR sky130_fd_sc_hd__tapvpwrvgnd_1
XFILLER_101_725 VGND VGND VPWR VPWR sky130_fd_sc_hd__decap_3
X_09822_ net767 net543 _04927_ net471 VGND VGND VPWR VPWR _04992_ sky130_fd_sc_hd__o211a_1
Xfanout416 net417 VGND VGND VPWR VPWR net416 sky130_fd_sc_hd__buf_4
XTAP_TAPCELL_ROW_74_1385 VGND VPWR sky130_fd_sc_hd__tapvpwrvgnd_1
XFILLER_59_617 VGND VGND VPWR VPWR sky130_fd_sc_hd__decap_4
Xfanout438 net441 VGND VGND VPWR VPWR net438 sky130_fd_sc_hd__clkbuf_4
Xfanout427 _02698_ VGND VGND VPWR VPWR net427 sky130_fd_sc_hd__clkbuf_2
XFILLER_101_758 VGND VGND VPWR VPWR sky130_fd_sc_hd__fill_1
XFILLER_101_736 VGND VGND VPWR VPWR sky130_fd_sc_hd__decap_8
X_09753_ net771 net542 _04867_ net470 VGND VGND VPWR VPWR _04926_ sky130_fd_sc_hd__o211a_1
XFILLER_100_213 VGND VGND VPWR VPWR sky130_fd_sc_hd__decap_4
XFILLER_58_138 VGND VGND VPWR VPWR sky130_fd_sc_hd__fill_2
Xfanout449 net450 VGND VGND VPWR VPWR net449 sky130_fd_sc_hd__clkbuf_2
X_06965_ net934 _02934_ VGND VGND VPWR VPWR _03179_ sky130_fd_sc_hd__or2_1
X_08704_ net1568 net264 net384 VGND VGND VPWR VPWR _00853_ sky130_fd_sc_hd__mux2_1
XFILLER_74_609 VGND VGND VPWR VPWR sky130_fd_sc_hd__fill_1
XFILLER_55_801 VGND VGND VPWR VPWR sky130_fd_sc_hd__fill_2
XFILLER_39_352 VGND VGND VPWR VPWR sky130_fd_sc_hd__fill_2
X_09684_ _04852_ _04853_ net657 VGND VGND VPWR VPWR _04861_ sky130_fd_sc_hd__mux2_1
X_06896_ net589 _03114_ _03115_ VGND VGND VPWR VPWR _03116_ sky130_fd_sc_hd__a21o_1
X_05916_ _02191_ _02386_ _02387_ VGND VGND VPWR VPWR _02388_ sky130_fd_sc_hd__a21o_1
XFILLER_94_491 VGND VGND VPWR VPWR sky130_fd_sc_hd__decap_8
XFILLER_82_653 VGND VGND VPWR VPWR sky130_fd_sc_hd__fill_1
X_08635_ net1604 net276 net391 VGND VGND VPWR VPWR _00786_ sky130_fd_sc_hd__mux2_1
XFILLER_54_333 VGND VGND VPWR VPWR sky130_fd_sc_hd__fill_2
X_05847_ _02312_ _02316_ _02311_ VGND VGND VPWR VPWR _02324_ sky130_fd_sc_hd__a21o_1
XFILLER_81_141 VGND VGND VPWR VPWR sky130_fd_sc_hd__fill_1
X_08566_ net259 net1710 net400 VGND VGND VPWR VPWR _00691_ sky130_fd_sc_hd__mux2_1
X_07517_ net1740 _03632_ net463 VGND VGND VPWR VPWR _00349_ sky130_fd_sc_hd__mux2_1
X_05778_ _02131_ _02260_ VGND VGND VPWR VPWR _02261_ sky130_fd_sc_hd__xor2_1
X_08497_ net1453 net260 net408 VGND VGND VPWR VPWR _00627_ sky130_fd_sc_hd__mux2_1
XFILLER_23_753 VPWR VGND VPWR VGND sky130_ef_sc_hd__decap_12
X_07448_ net1700 _03586_ net460 VGND VGND VPWR VPWR _00326_ sky130_fd_sc_hd__mux2_1
XTAP_TAPCELL_ROW_33_781 VGND VPWR sky130_fd_sc_hd__tapvpwrvgnd_1
X_07379_ _03411_ _03412_ VGND VGND VPWR VPWR _03519_ sky130_fd_sc_hd__or2_1
XFILLER_13_55 VGND VGND VPWR VPWR sky130_fd_sc_hd__fill_1
XFILLER_129_55 VGND VGND VPWR VPWR sky130_fd_sc_hd__fill_1
X_09118_ _04171_ _04225_ VGND VGND VPWR VPWR _04351_ sky130_fd_sc_hd__nor2_2
XFILLER_129_99 VGND VGND VPWR VPWR sky130_fd_sc_hd__fill_1
X_10390_ clknet_leaf_82_clk _00309_ VGND VGND VPWR VPWR picorv32_core.count_cycle\[48\]
+ sky130_fd_sc_hd__dfxtp_1
X_09049_ net216 net2089 net343 VGND VGND VPWR VPWR _01218_ sky130_fd_sc_hd__mux2_1
XFILLER_2_602 VGND VGND VPWR VPWR sky130_fd_sc_hd__decap_6
XFILLER_104_530 VGND VGND VPWR VPWR sky130_fd_sc_hd__fill_2
Xhold470 picorv32_core.cpuregs\[14\]\[2\] VGND VGND VPWR VPWR net1579 sky130_fd_sc_hd__dlygate4sd3_1
Xhold481 picorv32_core.cpuregs\[2\]\[3\] VGND VGND VPWR VPWR net1590 sky130_fd_sc_hd__dlygate4sd3_1
XFILLER_2_635 VGND VGND VPWR VPWR sky130_fd_sc_hd__fill_2
X_11011_ clknet_leaf_70_clk _00862_ VGND VGND VPWR VPWR picorv32_core.cpuregs\[12\]\[25\]
+ sky130_fd_sc_hd__dfxtp_1
Xhold492 picorv32_core.cpuregs\[28\]\[15\] VGND VGND VPWR VPWR net1601 sky130_fd_sc_hd__dlygate4sd3_1
XFILLER_1_167 VGND VGND VPWR VPWR sky130_fd_sc_hd__fill_1
XFILLER_131_393 VGND VGND VPWR VPWR sky130_fd_sc_hd__decap_4
XFILLER_77_447 VGND VGND VPWR VPWR sky130_fd_sc_hd__fill_1
Xfanout950 picorv32_core.latched_stalu VGND VGND VPWR VPWR net950 sky130_fd_sc_hd__clkbuf_4
Xfanout961 net203 VGND VGND VPWR VPWR net961 sky130_fd_sc_hd__buf_2
Xfanout994 net998 VGND VGND VPWR VPWR net994 sky130_fd_sc_hd__buf_2
Xfanout972 net974 VGND VGND VPWR VPWR net972 sky130_fd_sc_hd__clkbuf_4
Xfanout983 net988 VGND VGND VPWR VPWR net983 sky130_fd_sc_hd__clkbuf_2
XFILLER_58_672 VGND VGND VPWR VPWR sky130_fd_sc_hd__fill_2
Xhold1170 net136 VGND VGND VPWR VPWR net2279 sky130_fd_sc_hd__dlygate4sd3_1
XFILLER_38_85 VGND VGND VPWR VPWR sky130_fd_sc_hd__fill_2
Xhold1192 picorv32_core.mem_rdata_q\[19\] VGND VGND VPWR VPWR net2301 sky130_fd_sc_hd__dlygate4sd3_1
Xhold1181 picorv32_core.count_cycle\[33\] VGND VGND VPWR VPWR net2290 sky130_fd_sc_hd__dlygate4sd3_1
XTAP_TAPCELL_ROW_103_1802 VGND VPWR sky130_fd_sc_hd__tapvpwrvgnd_1
X_11844_ net47 VGND VGND VPWR VPWR net79 sky130_fd_sc_hd__clkbuf_1
XFILLER_45_399 VGND VGND VPWR VPWR sky130_fd_sc_hd__fill_1
XFILLER_9_234 VGND VGND VPWR VPWR sky130_fd_sc_hd__decap_4
XFILLER_9_201 VGND VGND VPWR VPWR sky130_fd_sc_hd__fill_1
XFILLER_13_285 VGND VGND VPWR VPWR sky130_fd_sc_hd__fill_1
X_10726_ clknet_leaf_108_clk _00577_ VGND VGND VPWR VPWR net139 sky130_fd_sc_hd__dfxtp_1
X_10657_ clknet_leaf_71_clk _00511_ VGND VGND VPWR VPWR picorv32_core.cpuregs\[20\]\[25\]
+ sky130_fd_sc_hd__dfxtp_1
Xclkload26 clknet_leaf_9_clk VGND VGND VPWR VPWR clkload26/Y sky130_fd_sc_hd__clkinv_2
XTAP_TAPCELL_ROW_11_464 VGND VPWR sky130_fd_sc_hd__tapvpwrvgnd_1
Xclkload15 clknet_leaf_1_clk VGND VGND VPWR VPWR clkload15/X sky130_fd_sc_hd__clkbuf_4
Xclkload59 clknet_leaf_37_clk VGND VGND VPWR VPWR clkload59/Y sky130_fd_sc_hd__bufinv_16
Xclkload48 clknet_leaf_25_clk VGND VGND VPWR VPWR clkload48/Y sky130_fd_sc_hd__clkinvlp_4
X_10588_ clknet_leaf_96_clk _00442_ VGND VGND VPWR VPWR picorv32_core.instr_lbu sky130_fd_sc_hd__dfxtp_1
Xclkload37 clknet_leaf_140_clk VGND VGND VPWR VPWR clkload37/X sky130_fd_sc_hd__clkbuf_4
XFILLER_141_113 VPWR VGND VPWR VGND sky130_ef_sc_hd__decap_12
XTAP_TAPCELL_ROW_114_1964 VGND VPWR sky130_fd_sc_hd__tapvpwrvgnd_1
XTAP_TAPCELL_ROW_114_1953 VGND VPWR sky130_fd_sc_hd__tapvpwrvgnd_1
X_11209_ clknet_leaf_60_clk _01060_ VGND VGND VPWR VPWR picorv32_core.cpuregs\[6\]\[31\]
+ sky130_fd_sc_hd__dfxtp_1
XFILLER_110_566 VGND VGND VPWR VPWR sky130_fd_sc_hd__fill_2
XFILLER_110_555 VGND VGND VPWR VPWR sky130_fd_sc_hd__fill_2
XFILLER_110_577 VGND VGND VPWR VPWR sky130_fd_sc_hd__decap_8
XFILLER_37_812 VPWR VGND VPWR VGND sky130_ef_sc_hd__decap_12
X_06750_ _02977_ _02979_ net673 VGND VGND VPWR VPWR _02981_ sky130_fd_sc_hd__o21ai_1
X_06681_ _02737_ picorv32_core.reg_next_pc\[18\] net562 VGND VGND VPWR VPWR _02930_
+ sky130_fd_sc_hd__mux2_1
X_05701_ net793 net178 VGND VGND VPWR VPWR _02185_ sky130_fd_sc_hd__or2_1
X_05632_ picorv32_core.count_instr\[63\] net937 net941 picorv32_core.count_instr\[31\]
+ VGND VGND VPWR VPWR _02117_ sky130_fd_sc_hd__a22o_1
X_08420_ picorv32_core.decoded_imm\[27\] net528 net442 _04290_ VGND VGND VPWR VPWR
+ _00583_ sky130_fd_sc_hd__o22a_1
XTAP_TAPCELL_ROW_19_575 VGND VPWR sky130_fd_sc_hd__tapvpwrvgnd_1
XTAP_TAPCELL_ROW_19_586 VGND VPWR sky130_fd_sc_hd__tapvpwrvgnd_1
X_05563_ picorv32_core.reg_pc\[26\] picorv32_core.decoded_imm\[26\] VGND VGND VPWR
+ VPWR _02053_ sky130_fd_sc_hd__or2_1
X_08351_ _01595_ net178 net451 _04249_ VGND VGND VPWR VPWR _04250_ sky130_fd_sc_hd__a211o_2
X_08282_ net2125 net249 net412 VGND VGND VPWR VPWR _00506_ sky130_fd_sc_hd__mux2_1
X_05494_ picorv32_core.count_cycle\[20\] net601 VGND VGND VPWR VPWR _01990_ sky130_fd_sc_hd__or2_1
X_07302_ net805 picorv32_core.decoded_imm\[8\] VGND VGND VPWR VPWR _03442_ sky130_fd_sc_hd__nand2_1
X_07233_ picorv32_core.count_cycle\[58\] _03375_ picorv32_core.count_cycle\[59\] VGND
+ VGND VPWR VPWR _03378_ sky130_fd_sc_hd__a21o_1
XTAP_TAPCELL_ROW_30_740 VGND VPWR sky130_fd_sc_hd__tapvpwrvgnd_1
Xclkload9 clknet_4_10_0_clk VGND VGND VPWR VPWR clkload9/Y sky130_fd_sc_hd__inv_6
XTAP_TAPCELL_ROW_76_1414 VGND VPWR sky130_fd_sc_hd__tapvpwrvgnd_1
XTAP_TAPCELL_ROW_76_1403 VGND VPWR sky130_fd_sc_hd__tapvpwrvgnd_1
X_07164_ net2290 _03333_ net984 VGND VGND VPWR VPWR _03335_ sky130_fd_sc_hd__o21ai_1
X_06115_ _02569_ _02570_ VGND VGND VPWR VPWR _02571_ sky130_fd_sc_hd__nor2_1
XFILLER_105_305 VGND VGND VPWR VPWR sky130_fd_sc_hd__decap_4
X_07095_ picorv32_core.count_cycle\[7\] _03289_ _03291_ VGND VGND VPWR VPWR _00268_
+ sky130_fd_sc_hd__o21a_1
XFILLER_121_809 VPWR VGND VPWR VGND sky130_ef_sc_hd__decap_12
X_06046_ net955 net186 net187 _02469_ VGND VGND VPWR VPWR _02507_ sky130_fd_sc_hd__or4_1
XFILLER_132_157 VGND VGND VPWR VPWR sky130_fd_sc_hd__decap_3
Xfanout213 net216 VGND VGND VPWR VPWR net213 sky130_fd_sc_hd__clkbuf_2
XFILLER_59_403 VGND VGND VPWR VPWR sky130_fd_sc_hd__decap_8
Xfanout224 _02778_ VGND VGND VPWR VPWR net224 sky130_fd_sc_hd__clkbuf_2
Xfanout235 _02765_ VGND VGND VPWR VPWR net235 sky130_fd_sc_hd__clkbuf_2
Xfanout246 _02752_ VGND VGND VPWR VPWR net246 sky130_fd_sc_hd__clkbuf_2
XFILLER_101_522 VGND VGND VPWR VPWR sky130_fd_sc_hd__decap_4
XFILLER_101_511 VGND VGND VPWR VPWR sky130_fd_sc_hd__fill_2
X_09805_ picorv32_core.cpuregs\[12\]\[28\] picorv32_core.cpuregs\[13\]\[28\] picorv32_core.cpuregs\[14\]\[28\]
+ picorv32_core.cpuregs\[15\]\[28\] net896 net862 VGND VGND VPWR VPWR _04976_ sky130_fd_sc_hd__mux4_1
X_07997_ net191 net511 _04074_ _04075_ VGND VGND VPWR VPWR _00386_ sky130_fd_sc_hd__o22a_1
Xfanout257 _02739_ VGND VGND VPWR VPWR net257 sky130_fd_sc_hd__clkbuf_2
XFILLER_75_28 VPWR VGND VPWR VGND sky130_ef_sc_hd__decap_12
Xfanout268 net269 VGND VGND VPWR VPWR net268 sky130_fd_sc_hd__clkbuf_2
Xfanout279 _02720_ VGND VGND VPWR VPWR net279 sky130_fd_sc_hd__buf_1
XFILLER_101_577 VPWR VGND VPWR VGND sky130_ef_sc_hd__decap_12
X_09736_ net612 _04906_ _04909_ net488 VGND VGND VPWR VPWR _04910_ sky130_fd_sc_hd__a211o_1
X_06948_ net934 _02933_ VGND VGND VPWR VPWR _03163_ sky130_fd_sc_hd__and2_1
XFILLER_74_417 VGND VGND VPWR VPWR sky130_fd_sc_hd__decap_3
X_09667_ _03418_ _03516_ _03415_ _03416_ VGND VGND VPWR VPWR _04844_ sky130_fd_sc_hd__o211ai_1
XFILLER_55_631 VGND VGND VPWR VPWR sky130_fd_sc_hd__fill_1
XPHY_EDGE_ROW_19_Left_161 VGND VGND VPWR VPWR sky130_fd_sc_hd__decap_3
XTAP_TAPCELL_ROW_87_1565 VGND VPWR sky130_fd_sc_hd__tapvpwrvgnd_1
X_06879_ _03094_ _03098_ VGND VGND VPWR VPWR _03100_ sky130_fd_sc_hd__or2_1
XFILLER_54_141 VGND VGND VPWR VPWR sky130_fd_sc_hd__decap_3
X_08618_ _04331_ _04332_ VGND VGND VPWR VPWR _00739_ sky130_fd_sc_hd__and2_1
XTAP_TAPCELL_ROW_38_851 VGND VPWR sky130_fd_sc_hd__tapvpwrvgnd_1
XTAP_TAPCELL_ROW_38_862 VGND VPWR sky130_fd_sc_hd__tapvpwrvgnd_1
XFILLER_42_303 VGND VGND VPWR VPWR sky130_fd_sc_hd__decap_4
X_09598_ picorv32_core.reg_pc\[18\] net537 _04778_ net484 VGND VGND VPWR VPWR _04779_
+ sky130_fd_sc_hd__a211o_1
X_08549_ net504 net1497 net399 VGND VGND VPWR VPWR _00674_ sky130_fd_sc_hd__mux2_1
XFILLER_23_583 VGND VGND VPWR VPWR sky130_fd_sc_hd__decap_3
XFILLER_24_65 VGND VGND VPWR VPWR sky130_fd_sc_hd__decap_3
X_11560_ clknet_leaf_140_clk _01391_ VGND VGND VPWR VPWR picorv32_core.cpuregs\[2\]\[7\]
+ sky130_fd_sc_hd__dfxtp_1
XFILLER_138_3 VPWR VGND VPWR VGND sky130_ef_sc_hd__decap_12
XTAP_TAPCELL_ROW_118_2020 VGND VPWR sky130_fd_sc_hd__tapvpwrvgnd_1
X_10511_ clknet_leaf_96_clk net1268 VGND VGND VPWR VPWR picorv32_core.latched_is_lb
+ sky130_fd_sc_hd__dfxtp_1
X_11491_ clknet_leaf_124_clk _01327_ VGND VGND VPWR VPWR net171 sky130_fd_sc_hd__dfxtp_1
XFILLER_136_441 VGND VGND VPWR VPWR sky130_fd_sc_hd__decap_8
XFILLER_10_288 VGND VGND VPWR VPWR sky130_fd_sc_hd__fill_2
X_10442_ clknet_leaf_117_clk _00329_ VGND VGND VPWR VPWR net64 sky130_fd_sc_hd__dfxtp_1
XPHY_EDGE_ROW_28_Left_170 VGND VGND VPWR VPWR sky130_fd_sc_hd__decap_3
X_10373_ clknet_leaf_83_clk _00292_ VGND VGND VPWR VPWR picorv32_core.count_cycle\[31\]
+ sky130_fd_sc_hd__dfxtp_1
XFILLER_123_113 VGND VGND VPWR VPWR sky130_fd_sc_hd__fill_2
XFILLER_2_421 VPWR VGND VPWR VGND sky130_ef_sc_hd__decap_12
XFILLER_104_393 VGND VGND VPWR VPWR sky130_fd_sc_hd__fill_1
XTAP_TAPCELL_ROW_129_2182 VGND VPWR sky130_fd_sc_hd__tapvpwrvgnd_1
XTAP_TAPCELL_ROW_129_2171 VGND VPWR sky130_fd_sc_hd__tapvpwrvgnd_1
Xfanout780 net154 VGND VGND VPWR VPWR net780 sky130_fd_sc_hd__clkbuf_4
Xfanout791 net792 VGND VGND VPWR VPWR net791 sky130_fd_sc_hd__buf_2
XFILLER_77_277 VGND VGND VPWR VPWR sky130_fd_sc_hd__decap_3
XFILLER_65_406 VGND VGND VPWR VPWR sky130_fd_sc_hd__fill_1
XFILLER_19_801 VGND VGND VPWR VPWR sky130_fd_sc_hd__fill_1
XFILLER_65_50 VGND VGND VPWR VPWR sky130_fd_sc_hd__decap_6
XFILLER_1_69 VPWR VGND VPWR VGND sky130_ef_sc_hd__decap_12
XFILLER_18_333 VGND VGND VPWR VPWR sky130_fd_sc_hd__decap_3
XFILLER_46_664 VPWR VGND VPWR VGND sky130_ef_sc_hd__decap_12
XTAP_TAPCELL_ROW_16_534 VGND VPWR sky130_fd_sc_hd__tapvpwrvgnd_1
X_11827_ axi_adapter.mem_instr VGND VGND VPWR VPWR net69 sky130_fd_sc_hd__clkbuf_1
X_10709_ clknet_leaf_27_clk _00560_ VGND VGND VPWR VPWR net114 sky130_fd_sc_hd__dfxtp_1
XFILLER_41_391 VGND VGND VPWR VPWR sky130_fd_sc_hd__fill_1
Xclkload104 clknet_leaf_110_clk VGND VGND VPWR VPWR clkload104/Y sky130_fd_sc_hd__clkinvlp_4
X_11689_ clknet_leaf_141_clk _01520_ VGND VGND VPWR VPWR picorv32_core.cpuregs\[27\]\[6\]
+ sky130_fd_sc_hd__dfxtp_1
XFILLER_139_290 VGND VGND VPWR VPWR sky130_fd_sc_hd__fill_2
Xclkload137 clknet_leaf_72_clk VGND VGND VPWR VPWR clkload137/Y sky130_fd_sc_hd__clkinv_8
Xclkload126 clknet_leaf_68_clk VGND VGND VPWR VPWR clkload126/Y sky130_fd_sc_hd__inv_6
Xclkload115 clknet_leaf_58_clk VGND VGND VPWR VPWR clkload115/Y sky130_fd_sc_hd__inv_8
XFILLER_115_603 VGND VGND VPWR VPWR sky130_fd_sc_hd__fill_2
XTAP_TAPCELL_ROW_58_1144 VGND VPWR sky130_fd_sc_hd__tapvpwrvgnd_1
XFILLER_6_793 VPWR VGND VPWR VGND sky130_ef_sc_hd__decap_12
X_07920_ picorv32_core.cpuregs\[8\]\[22\] picorv32_core.cpuregs\[9\]\[22\] picorv32_core.cpuregs\[10\]\[22\]
+ picorv32_core.cpuregs\[11\]\[22\] net752 net719 VGND VGND VPWR VPWR _04003_ sky130_fd_sc_hd__mux4_1
XFILLER_111_831 VGND VGND VPWR VPWR sky130_fd_sc_hd__fill_2
XTAP_TAPCELL_ROW_71_1333 VGND VPWR sky130_fd_sc_hd__tapvpwrvgnd_1
XFILLER_69_745 VGND VGND VPWR VPWR sky130_fd_sc_hd__fill_2
X_07851_ _03935_ _03937_ net458 _03934_ VGND VGND VPWR VPWR _03938_ sky130_fd_sc_hd__o211a_1
XFILLER_84_737 VPWR VGND VPWR VGND sky130_ef_sc_hd__decap_12
XFILLER_69_789 VGND VGND VPWR VPWR sky130_fd_sc_hd__fill_2
X_07782_ picorv32_core.cpuregs\[12\]\[15\] picorv32_core.cpuregs\[13\]\[15\] picorv32_core.cpuregs\[14\]\[15\]
+ picorv32_core.cpuregs\[15\]\[15\] net740 net707 VGND VGND VPWR VPWR _03872_ sky130_fd_sc_hd__mux4_1
X_06802_ _03028_ VGND VGND VPWR VPWR _03029_ sky130_fd_sc_hd__inv_2
Xinput2 mem_axi_awready VGND VGND VPWR VPWR net2 sky130_fd_sc_hd__clkbuf_1
X_09521_ picorv32_core.cpuregs\[16\]\[15\] picorv32_core.cpuregs\[17\]\[15\] picorv32_core.cpuregs\[18\]\[15\]
+ picorv32_core.cpuregs\[19\]\[15\] net893 net859 VGND VGND VPWR VPWR _04705_ sky130_fd_sc_hd__mux4_1
X_06733_ picorv32_core.decoded_imm_j\[4\] _02916_ VGND VGND VPWR VPWR _02965_ sky130_fd_sc_hd__nand2_1
XFILLER_101_15 VPWR VGND VPWR VGND sky130_ef_sc_hd__decap_12
X_06664_ picorv32_core.reg_pc\[9\] net552 _02921_ net515 VGND VGND VPWR VPWR _00207_
+ sky130_fd_sc_hd__a22o_1
X_09452_ picorv32_core.cpuregs\[16\]\[12\] picorv32_core.cpuregs\[17\]\[12\] picorv32_core.cpuregs\[18\]\[12\]
+ picorv32_core.cpuregs\[19\]\[12\] net878 net845 VGND VGND VPWR VPWR _04639_ sky130_fd_sc_hd__mux4_1
XTAP_TAPCELL_ROW_35_810 VGND VPWR sky130_fd_sc_hd__tapvpwrvgnd_1
X_05615_ net910 net302 _02096_ _02101_ VGND VGND VPWR VPWR _01568_ sky130_fd_sc_hd__a31o_1
X_06595_ _02878_ net992 _02877_ VGND VGND VPWR VPWR _00181_ sky130_fd_sc_hd__and3b_1
XFILLER_52_656 VGND VGND VPWR VPWR sky130_fd_sc_hd__fill_1
X_09383_ net610 _04568_ _04572_ net486 VGND VGND VPWR VPWR _04573_ sky130_fd_sc_hd__a211o_1
X_08403_ net519 _03583_ _01628_ _01624_ VGND VGND VPWR VPWR _04279_ sky130_fd_sc_hd__and4bb_1
X_05546_ picorv32_core.instr_rdcycleh picorv32_core.count_cycle\[56\] net603 _02037_
+ VGND VGND VPWR VPWR _02038_ sky130_fd_sc_hd__a211o_1
X_08334_ net1163 net456 _04238_ VGND VGND VPWR VPWR _00549_ sky130_fd_sc_hd__o21a_1
XTAP_TAPCELL_ROW_82_1495 VGND VPWR sky130_fd_sc_hd__tapvpwrvgnd_1
X_05477_ net946 picorv32_core.count_cycle\[51\] net604 _01973_ VGND VGND VPWR VPWR
+ _01974_ sky130_fd_sc_hd__a211o_1
X_08265_ net1210 net494 net411 VGND VGND VPWR VPWR _00489_ sky130_fd_sc_hd__mux2_1
X_07216_ picorv32_core.count_cycle\[52\] _03365_ _03367_ VGND VGND VPWR VPWR _00313_
+ sky130_fd_sc_hd__o21a_1
X_08196_ picorv32_core.mem_rdata_q\[25\] picorv32_core.mem_rdata_q\[26\] VGND VGND
+ VPWR VPWR _04201_ sky130_fd_sc_hd__or2_1
XFILLER_106_603 VGND VGND VPWR VPWR sky130_fd_sc_hd__fill_1
X_07147_ picorv32_core.count_cycle\[25\] picorv32_core.count_cycle\[26\] picorv32_core.count_cycle\[27\]
+ _03319_ VGND VGND VPWR VPWR _03324_ sky130_fd_sc_hd__and4_1
XFILLER_105_113 VGND VGND VPWR VPWR sky130_fd_sc_hd__decap_3
X_07078_ picorv32_core.count_cycle\[0\] net2292 net982 VGND VGND VPWR VPWR _03281_
+ sky130_fd_sc_hd__o21ai_1
X_06029_ _02489_ _02490_ _02491_ VGND VGND VPWR VPWR _02492_ sky130_fd_sc_hd__o21ba_1
XFILLER_59_255 VGND VGND VPWR VPWR sky130_fd_sc_hd__decap_4
XFILLER_19_54 VGND VGND VPWR VPWR sky130_fd_sc_hd__fill_2
XFILLER_47_417 VGND VGND VPWR VPWR sky130_fd_sc_hd__decap_8
X_09719_ picorv32_core.cpuregs\[28\]\[24\] picorv32_core.cpuregs\[29\]\[24\] picorv32_core.cpuregs\[30\]\[24\]
+ picorv32_core.cpuregs\[31\]\[24\] net895 net861 VGND VGND VPWR VPWR _04894_ sky130_fd_sc_hd__mux4_1
X_10991_ clknet_leaf_139_clk _00842_ VGND VGND VPWR VPWR picorv32_core.cpuregs\[12\]\[5\]
+ sky130_fd_sc_hd__dfxtp_1
XFILLER_42_122 VGND VGND VPWR VPWR sky130_fd_sc_hd__fill_2
X_11612_ clknet_leaf_66_clk _01443_ VGND VGND VPWR VPWR picorv32_core.cpuregs\[23\]\[25\]
+ sky130_fd_sc_hd__dfxtp_1
XFILLER_23_391 VGND VGND VPWR VPWR sky130_fd_sc_hd__fill_1
X_11543_ clknet_leaf_33_clk _01374_ VGND VGND VPWR VPWR picorv32_core.cpuregs\[30\]\[24\]
+ sky130_fd_sc_hd__dfxtp_1
X_11474_ clknet_leaf_70_clk _01310_ VGND VGND VPWR VPWR picorv32_core.cpuregs\[24\]\[25\]
+ sky130_fd_sc_hd__dfxtp_1
XFILLER_137_783 VGND VGND VPWR VPWR sky130_fd_sc_hd__fill_1
X_10425_ clknet_leaf_84_clk _01556_ VGND VGND VPWR VPWR picorv32_core.reg_out\[18\]
+ sky130_fd_sc_hd__dfxtp_1
XTAP_TAPCELL_ROW_111_1912 VGND VPWR sky130_fd_sc_hd__tapvpwrvgnd_1
XFILLER_97_306 VGND VGND VPWR VPWR sky130_fd_sc_hd__fill_2
X_10356_ clknet_leaf_82_clk _00275_ VGND VGND VPWR VPWR picorv32_core.count_cycle\[14\]
+ sky130_fd_sc_hd__dfxtp_1
XFILLER_3_741 VPWR VGND VPWR VGND sky130_ef_sc_hd__decap_12
X_10287_ clknet_leaf_125_clk _00206_ VGND VGND VPWR VPWR picorv32_core.reg_pc\[8\]
+ sky130_fd_sc_hd__dfxtp_2
XFILLER_3_785 VPWR VGND VPWR VGND sky130_ef_sc_hd__decap_12
XFILLER_2_251 VGND VGND VPWR VPWR sky130_fd_sc_hd__fill_1
XTAP_TAPCELL_ROW_53_1074 VGND VPWR sky130_fd_sc_hd__tapvpwrvgnd_1
XFILLER_78_586 VGND VGND VPWR VPWR sky130_fd_sc_hd__fill_2
XFILLER_65_214 VGND VGND VPWR VPWR sky130_fd_sc_hd__fill_1
XFILLER_81_729 VGND VGND VPWR VPWR sky130_fd_sc_hd__fill_2
XFILLER_65_269 VGND VGND VPWR VPWR sky130_fd_sc_hd__fill_2
XTAP_TAPCELL_ROW_109_1885 VGND VPWR sky130_fd_sc_hd__tapvpwrvgnd_1
X_05400_ net9 _01818_ VGND VGND VPWR VPWR _01902_ sky130_fd_sc_hd__or2_1
X_06380_ net1792 net222 net435 VGND VGND VPWR VPWR _00066_ sky130_fd_sc_hd__mux2_1
X_05331_ _01830_ _01833_ _01837_ VGND VGND VPWR VPWR _01838_ sky130_fd_sc_hd__a21bo_1
X_08050_ picorv32_core.decoded_imm\[29\] net591 net596 VGND VGND VPWR VPWR _04126_
+ sky130_fd_sc_hd__a21o_1
XTAP_TAPCELL_ROW_40_890 VGND VPWR sky130_fd_sc_hd__tapvpwrvgnd_1
X_05262_ picorv32_core.count_instr\[4\] net939 net602 _01773_ VGND VGND VPWR VPWR
+ _01774_ sky130_fd_sc_hd__a211o_1
X_07001_ net932 _02937_ VGND VGND VPWR VPWR _03212_ sky130_fd_sc_hd__nand2_1
X_05193_ _01713_ VGND VGND VPWR VPWR net102 sky130_fd_sc_hd__inv_2
X_08952_ net947 net948 net949 _04325_ VGND VGND VPWR VPWR _04345_ sky130_fd_sc_hd__nor4_2
X_08883_ net215 net2064 net364 VGND VGND VPWR VPWR _01058_ sky130_fd_sc_hd__mux2_1
X_07903_ _03981_ _03982_ net636 VGND VGND VPWR VPWR _03987_ sky130_fd_sc_hd__mux2_1
X_07834_ net181 net512 _03920_ _03921_ VGND VGND VPWR VPWR _00377_ sky130_fd_sc_hd__o22a_1
XFILLER_56_19 VGND VGND VPWR VPWR sky130_fd_sc_hd__fill_1
X_07765_ picorv32_core.cpuregs\[16\]\[14\] picorv32_core.cpuregs\[17\]\[14\] picorv32_core.cpuregs\[18\]\[14\]
+ picorv32_core.cpuregs\[19\]\[14\] net738 net705 VGND VGND VPWR VPWR _03856_ sky130_fd_sc_hd__mux4_1
XFILLER_25_601 VGND VGND VPWR VPWR sky130_fd_sc_hd__fill_1
XTAP_TAPCELL_ROW_84_1524 VGND VPWR sky130_fd_sc_hd__tapvpwrvgnd_1
X_09504_ _04679_ _04680_ _04685_ _04686_ net654 net832 VGND VGND VPWR VPWR _04689_
+ sky130_fd_sc_hd__mux4_1
X_07696_ picorv32_core.cpuregs\[4\]\[10\] picorv32_core.cpuregs\[5\]\[10\] picorv32_core.cpuregs\[6\]\[10\]
+ picorv32_core.cpuregs\[7\]\[10\] net731 net698 VGND VGND VPWR VPWR _03791_ sky130_fd_sc_hd__mux4_1
X_06716_ picorv32_core.decoded_imm_j\[1\] _02911_ _02949_ VGND VGND VPWR VPWR _02950_
+ sky130_fd_sc_hd__a21o_1
XFILLER_72_29 VPWR VGND VPWR VGND sky130_ef_sc_hd__decap_12
XFILLER_52_453 VGND VGND VPWR VPWR sky130_fd_sc_hd__fill_1
X_06647_ net665 picorv32_core.reg_pc\[1\] net981 _02912_ VGND VGND VPWR VPWR _00199_
+ sky130_fd_sc_hd__a31o_1
X_09435_ picorv32_core.cpuregs\[16\]\[11\] picorv32_core.cpuregs\[17\]\[11\] picorv32_core.cpuregs\[18\]\[11\]
+ picorv32_core.cpuregs\[19\]\[11\] net878 net845 VGND VGND VPWR VPWR _04623_ sky130_fd_sc_hd__mux4_1
X_06578_ picorv32_core.count_instr\[40\] picorv32_core.count_instr\[39\] _02864_ VGND
+ VGND VPWR VPWR _02868_ sky130_fd_sc_hd__and3_1
X_09366_ picorv32_core.cpuregs\[16\]\[8\] picorv32_core.cpuregs\[17\]\[8\] picorv32_core.cpuregs\[18\]\[8\]
+ picorv32_core.cpuregs\[19\]\[8\] net881 net848 VGND VGND VPWR VPWR _04557_ sky130_fd_sc_hd__mux4_1
X_05529_ net19 net583 net574 VGND VGND VPWR VPWR _02022_ sky130_fd_sc_hd__a21o_1
XANTENNA_40 picorv32_core.mem_rdata_q\[21\] VGND VGND VPWR VPWR sky130_fd_sc_hd__diode_2
X_08317_ picorv32_core.is_sll_srl_sra net522 VGND VGND VPWR VPWR _04234_ sky130_fd_sc_hd__and2_1
X_09297_ picorv32_core.cpuregs\[8\]\[5\] picorv32_core.cpuregs\[9\]\[5\] picorv32_core.cpuregs\[10\]\[5\]
+ picorv32_core.cpuregs\[11\]\[5\] net875 net842 VGND VGND VPWR VPWR _04491_ sky130_fd_sc_hd__mux4_1
XANTENNA_62 net626 VGND VGND VPWR VPWR sky130_fd_sc_hd__diode_2
XANTENNA_73 _02667_ VGND VGND VPWR VPWR sky130_fd_sc_hd__diode_2
XANTENNA_51 net364 VGND VGND VPWR VPWR sky130_fd_sc_hd__diode_2
XANTENNA_84 net342 VGND VGND VPWR VPWR sky130_fd_sc_hd__diode_2
X_08248_ net2316 _00768_ net438 VGND VGND VPWR VPWR _00477_ sky130_fd_sc_hd__mux2_1
XFILLER_119_783 VGND VGND VPWR VPWR sky130_fd_sc_hd__fill_1
XANTENNA_95 _04267_ VGND VGND VPWR VPWR sky130_fd_sc_hd__diode_2
XFILLER_21_55 VGND VGND VPWR VPWR sky130_fd_sc_hd__fill_1
XFILLER_137_55 VGND VGND VPWR VPWR sky130_fd_sc_hd__fill_1
XFILLER_134_742 VPWR VGND VPWR VGND sky130_ef_sc_hd__decap_12
X_10210_ clknet_leaf_63_clk _00129_ VGND VGND VPWR VPWR picorv32_core.cpuregs\[9\]\[26\]
+ sky130_fd_sc_hd__dfxtp_1
XFILLER_118_271 VGND VGND VPWR VPWR sky130_fd_sc_hd__fill_2
XFILLER_106_411 VGND VGND VPWR VPWR sky130_fd_sc_hd__fill_2
X_08179_ net930 _01594_ net929 VGND VGND VPWR VPWR _04194_ sky130_fd_sc_hd__nor3_1
XFILLER_4_549 VGND VGND VPWR VPWR sky130_fd_sc_hd__fill_2
XFILLER_97_15 VPWR VGND VPWR VGND sky130_ef_sc_hd__decap_12
XTAP_TAPCELL_ROW_95_1686 VGND VPWR sky130_fd_sc_hd__tapvpwrvgnd_1
XFILLER_79_306 VGND VGND VPWR VPWR sky130_fd_sc_hd__fill_1
X_11190_ clknet_leaf_6_clk _01041_ VGND VGND VPWR VPWR picorv32_core.cpuregs\[6\]\[12\]
+ sky130_fd_sc_hd__dfxtp_1
XFILLER_121_414 VGND VGND VPWR VPWR sky130_fd_sc_hd__fill_1
X_10141_ clknet_leaf_33_clk _00063_ VGND VGND VPWR VPWR picorv32_core.cpuregs\[22\]\[24\]
+ sky130_fd_sc_hd__dfxtp_1
XFILLER_106_477 VPWR VGND VPWR VGND sky130_ef_sc_hd__decap_12
Xoutput191 net191 VGND VGND VPWR VPWR pcpi_rs2[26] sky130_fd_sc_hd__buf_2
Xoutput180 net180 VGND VGND VPWR VPWR pcpi_rs2[16] sky130_fd_sc_hd__buf_2
X_10072_ net675 _02600_ _04191_ _05043_ VGND VGND VPWR VPWR _01546_ sky130_fd_sc_hd__a22o_1
XFILLER_0_755 VGND VGND VPWR VPWR sky130_fd_sc_hd__fill_1
XFILLER_75_501 VGND VGND VPWR VPWR sky130_fd_sc_hd__decap_3
XFILLER_47_203 VGND VGND VPWR VPWR sky130_fd_sc_hd__decap_4
XTAP_TAPCELL_ROW_126_2130 VGND VPWR sky130_fd_sc_hd__tapvpwrvgnd_1
XFILLER_87_383 VGND VGND VPWR VPWR sky130_fd_sc_hd__fill_2
XFILLER_75_545 VPWR VGND VPWR VGND sky130_ef_sc_hd__decap_12
XFILLER_63_729 VGND VGND VPWR VPWR sky130_fd_sc_hd__decap_4
XFILLER_46_52 VGND VGND VPWR VPWR sky130_fd_sc_hd__fill_1
X_10974_ clknet_leaf_21_clk _00825_ VGND VGND VPWR VPWR picorv32_core.cpuregs\[13\]\[20\]
+ sky130_fd_sc_hd__dfxtp_1
XFILLER_46_74 VGND VGND VPWR VPWR sky130_fd_sc_hd__fill_1
XFILLER_15_111 VGND VGND VPWR VPWR sky130_fd_sc_hd__fill_1
XFILLER_43_453 VGND VGND VPWR VPWR sky130_fd_sc_hd__fill_2
XFILLER_70_272 VGND VGND VPWR VPWR sky130_fd_sc_hd__decap_4
XTAP_TAPCELL_ROW_26_684 VGND VPWR sky130_fd_sc_hd__tapvpwrvgnd_1
XFILLER_129_514 VGND VGND VPWR VPWR sky130_fd_sc_hd__fill_1
XFILLER_8_811 VGND VGND VPWR VPWR sky130_fd_sc_hd__fill_1
X_11526_ clknet_leaf_130_clk _01357_ VGND VGND VPWR VPWR picorv32_core.cpuregs\[30\]\[7\]
+ sky130_fd_sc_hd__dfxtp_1
XTAP_TAPCELL_ROW_137_2292 VGND VPWR sky130_fd_sc_hd__tapvpwrvgnd_1
XFILLER_7_57 VPWR VGND VPWR VGND sky130_ef_sc_hd__decap_12
X_11457_ clknet_leaf_129_clk _01293_ VGND VGND VPWR VPWR picorv32_core.cpuregs\[24\]\[8\]
+ sky130_fd_sc_hd__dfxtp_1
XFILLER_140_701 VPWR VGND VPWR VGND sky130_ef_sc_hd__decap_12
XFILLER_125_753 VPWR VGND VPWR VGND sky130_ef_sc_hd__decap_12
XTAP_TAPCELL_ROW_55_1103 VGND VPWR sky130_fd_sc_hd__tapvpwrvgnd_1
X_11388_ clknet_leaf_116_clk _01224_ VGND VGND VPWR VPWR picorv32_core.cpuregs\[31\]\[3\]
+ sky130_fd_sc_hd__dfxtp_1
X_10408_ clknet_leaf_104_clk _01558_ VGND VGND VPWR VPWR picorv32_core.reg_out\[1\]
+ sky130_fd_sc_hd__dfxtp_1
XFILLER_125_797 VPWR VGND VPWR VGND sky130_ef_sc_hd__decap_12
X_10339_ clknet_leaf_75_clk _00258_ VGND VGND VPWR VPWR picorv32_core.reg_next_pc\[29\]
+ sky130_fd_sc_hd__dfxtp_1
XFILLER_98_637 VGND VGND VPWR VPWR sky130_fd_sc_hd__decap_6
XFILLER_97_169 VGND VGND VPWR VPWR sky130_fd_sc_hd__fill_2
X_05880_ net801 _02353_ VGND VGND VPWR VPWR _02354_ sky130_fd_sc_hd__nand2_1
X_07550_ picorv32_core.cpuregs\[0\]\[0\] picorv32_core.cpuregs\[1\]\[0\] picorv32_core.cpuregs\[2\]\[0\]
+ picorv32_core.cpuregs\[3\]\[0\] net743 net710 VGND VGND VPWR VPWR _03655_ sky130_fd_sc_hd__mux4_1
XFILLER_47_792 VGND VGND VPWR VPWR sky130_fd_sc_hd__decap_8
X_06501_ picorv32_core.count_instr\[12\] picorv32_core.count_instr\[11\] _02815_ VGND
+ VGND VPWR VPWR _02819_ sky130_fd_sc_hd__and3_1
X_07481_ net1819 _03608_ net462 VGND VGND VPWR VPWR _00337_ sky130_fd_sc_hd__mux2_1
XTAP_TAPCELL_ROW_66_1265 VGND VPWR sky130_fd_sc_hd__tapvpwrvgnd_1
X_09220_ net653 _04416_ VGND VGND VPWR VPWR _04417_ sky130_fd_sc_hd__nand2_1
XTAP_TAPCELL_ROW_45_960 VGND VPWR sky130_fd_sc_hd__tapvpwrvgnd_1
X_06432_ net213 net1491 net425 VGND VGND VPWR VPWR _00100_ sky130_fd_sc_hd__mux2_1
X_06363_ _02761_ _02764_ net564 VGND VGND VPWR VPWR _02765_ sky130_fd_sc_hd__mux2_2
X_09151_ net2186 net522 _04181_ picorv32_core.is_sb_sh_sw VGND VGND VPWR VPWR _01317_
+ sky130_fd_sc_hd__a22o_1
XFILLER_21_169 VGND VGND VPWR VPWR sky130_fd_sc_hd__fill_1
X_09082_ net1224 net214 net339 VGND VGND VPWR VPWR _01250_ sky130_fd_sc_hd__mux2_1
X_05314_ picorv32_core.latched_is_lh _01820_ VGND VGND VPWR VPWR _01822_ sky130_fd_sc_hd__or2_2
X_08102_ picorv32_core.latched_is_lb net987 _04170_ _01639_ net1267 VGND VGND VPWR
+ VPWR _00397_ sky130_fd_sc_hd__a32o_1
X_08033_ picorv32_core.cpuregs\[20\]\[29\] picorv32_core.cpuregs\[21\]\[29\] picorv32_core.cpuregs\[22\]\[29\]
+ picorv32_core.cpuregs\[23\]\[29\] net761 net728 VGND VGND VPWR VPWR _04109_ sky130_fd_sc_hd__mux4_1
X_06294_ picorv32_core.reg_pc\[11\] picorv32_core.reg_pc\[10\] _02701_ VGND VGND VPWR
+ VPWR _02709_ sky130_fd_sc_hd__and3_1
X_05245_ net820 net6 _01718_ _01757_ VGND VGND VPWR VPWR _01758_ sky130_fd_sc_hd__o211a_1
Xhold800 net62 VGND VGND VPWR VPWR net1909 sky130_fd_sc_hd__dlygate4sd3_1
Xhold811 picorv32_core.cpuregs\[25\]\[2\] VGND VGND VPWR VPWR net1920 sky130_fd_sc_hd__dlygate4sd3_1
Xhold822 picorv32_core.cpuregs\[16\]\[25\] VGND VGND VPWR VPWR net1931 sky130_fd_sc_hd__dlygate4sd3_1
Xhold844 picorv32_core.cpuregs\[29\]\[25\] VGND VGND VPWR VPWR net1953 sky130_fd_sc_hd__dlygate4sd3_1
Xhold833 picorv32_core.cpuregs\[6\]\[19\] VGND VGND VPWR VPWR net1942 sky130_fd_sc_hd__dlygate4sd3_1
Xhold855 net65 VGND VGND VPWR VPWR net1964 sky130_fd_sc_hd__dlygate4sd3_1
X_05176_ net931 net921 _01671_ _01699_ _01697_ VGND VGND VPWR VPWR _00013_ sky130_fd_sc_hd__a41o_1
Xhold888 picorv32_core.cpuregs\[15\]\[25\] VGND VGND VPWR VPWR net1997 sky130_fd_sc_hd__dlygate4sd3_1
XFILLER_115_274 VGND VGND VPWR VPWR sky130_fd_sc_hd__decap_6
XFILLER_89_615 VGND VGND VPWR VPWR sky130_fd_sc_hd__fill_1
Xhold877 picorv32_core.cpuregs\[6\]\[14\] VGND VGND VPWR VPWR net1986 sky130_fd_sc_hd__dlygate4sd3_1
Xhold866 picorv32_core.cpuregs\[10\]\[5\] VGND VGND VPWR VPWR net1975 sky130_fd_sc_hd__dlygate4sd3_1
Xhold899 picorv32_core.cpuregs\[6\]\[1\] VGND VGND VPWR VPWR net2008 sky130_fd_sc_hd__dlygate4sd3_1
X_09984_ net1814 net293 net312 VGND VGND VPWR VPWR _01461_ sky130_fd_sc_hd__mux2_1
XFILLER_97_681 VGND VGND VPWR VPWR sky130_fd_sc_hd__fill_1
X_08935_ net270 net1492 net355 VGND VGND VPWR VPWR _01108_ sky130_fd_sc_hd__mux2_1
XFILLER_57_512 VPWR VGND VPWR VGND sky130_ef_sc_hd__decap_12
X_08866_ net286 net1963 net362 VGND VGND VPWR VPWR _01041_ sky130_fd_sc_hd__mux2_1
XTAP_TAPCELL_ROW_4_357 VGND VPWR sky130_fd_sc_hd__tapvpwrvgnd_1
XFILLER_29_225 VGND VGND VPWR VPWR sky130_fd_sc_hd__fill_1
XFILLER_123_57 VGND VGND VPWR VPWR sky130_fd_sc_hd__decap_6
X_07817_ picorv32_core.cpuregs\[16\]\[17\] picorv32_core.cpuregs\[17\]\[17\] picorv32_core.cpuregs\[18\]\[17\]
+ picorv32_core.cpuregs\[19\]\[17\] net747 net714 VGND VGND VPWR VPWR _03905_ sky130_fd_sc_hd__mux4_1
XTAP_TAPCELL_ROW_4_368 VGND VPWR sky130_fd_sc_hd__tapvpwrvgnd_1
X_08797_ net296 net2085 net370 VGND VGND VPWR VPWR _00975_ sky130_fd_sc_hd__mux2_1
XFILLER_45_707 VGND VGND VPWR VPWR sky130_fd_sc_hd__decap_8
XFILLER_84_386 VGND VGND VPWR VPWR sky130_fd_sc_hd__decap_6
X_07748_ picorv32_core.cpuregs\[12\]\[13\] picorv32_core.cpuregs\[13\]\[13\] picorv32_core.cpuregs\[14\]\[13\]
+ picorv32_core.cpuregs\[15\]\[13\] net739 net706 VGND VGND VPWR VPWR _03840_ sky130_fd_sc_hd__mux4_1
XTAP_TAPCELL_ROW_121_2060 VGND VPWR sky130_fd_sc_hd__tapvpwrvgnd_1
XFILLER_52_250 VGND VGND VPWR VPWR sky130_fd_sc_hd__fill_2
X_07679_ picorv32_core.cpuregs\[12\]\[9\] picorv32_core.cpuregs\[13\]\[9\] picorv32_core.cpuregs\[14\]\[9\]
+ picorv32_core.cpuregs\[15\]\[9\] net731 net698 VGND VGND VPWR VPWR _03775_ sky130_fd_sc_hd__mux4_1
X_10690_ clknet_leaf_137_clk _00541_ VGND VGND VPWR VPWR net104 sky130_fd_sc_hd__dfxtp_1
XTAP_TAPCELL_ROW_23_632 VGND VPWR sky130_fd_sc_hd__tapvpwrvgnd_1
X_09418_ net831 _04603_ _04606_ net478 VGND VGND VPWR VPWR _04607_ sky130_fd_sc_hd__o211a_1
XTAP_TAPCELL_ROW_23_643 VGND VPWR sky130_fd_sc_hd__tapvpwrvgnd_1
X_09349_ _04530_ _04531_ net835 VGND VGND VPWR VPWR _04541_ sky130_fd_sc_hd__mux2_1
XFILLER_138_344 VGND VGND VPWR VPWR sky130_fd_sc_hd__fill_2
XFILLER_138_322 VGND VGND VPWR VPWR sky130_fd_sc_hd__fill_1
XTAP_TAPCELL_ROW_97_1715 VGND VPWR sky130_fd_sc_hd__tapvpwrvgnd_1
XFILLER_126_506 VGND VGND VPWR VPWR sky130_fd_sc_hd__fill_1
XFILLER_120_3 VPWR VGND VPWR VGND sky130_ef_sc_hd__decap_12
X_11311_ clknet_leaf_94_clk _00012_ VGND VGND VPWR VPWR picorv32_core.cpu_state\[2\]
+ sky130_fd_sc_hd__dfxtp_2
XFILLER_4_302 VGND VGND VPWR VPWR sky130_fd_sc_hd__decap_3
X_11242_ clknet_leaf_96_clk _00017_ VGND VGND VPWR VPWR picorv32_core.mem_wordsize\[0\]
+ sky130_fd_sc_hd__dfxtp_1
XFILLER_134_583 VGND VGND VPWR VPWR sky130_fd_sc_hd__decap_4
X_11173_ clknet_leaf_38_clk _01024_ VGND VGND VPWR VPWR picorv32_core.cpuregs\[7\]\[27\]
+ sky130_fd_sc_hd__dfxtp_1
XFILLER_121_222 VGND VGND VPWR VPWR sky130_fd_sc_hd__fill_2
XFILLER_0_530 VGND VGND VPWR VPWR sky130_fd_sc_hd__fill_2
X_10124_ clknet_leaf_130_clk _00046_ VGND VGND VPWR VPWR picorv32_core.cpuregs\[22\]\[7\]
+ sky130_fd_sc_hd__dfxtp_1
XFILLER_95_629 VGND VGND VPWR VPWR sky130_fd_sc_hd__fill_2
XFILLER_94_139 VGND VGND VPWR VPWR sky130_fd_sc_hd__fill_1
X_10055_ net1215 net266 net306 VGND VGND VPWR VPWR _01530_ sky130_fd_sc_hd__mux2_1
XTAP_TAPCELL_ROW_50_1033 VGND VPWR sky130_fd_sc_hd__tapvpwrvgnd_1
XFILLER_48_589 VGND VGND VPWR VPWR sky130_fd_sc_hd__decap_6
XTAP_TAPCELL_ROW_106_1844 VGND VPWR sky130_fd_sc_hd__tapvpwrvgnd_1
X_10957_ clknet_leaf_117_clk _00808_ VGND VGND VPWR VPWR picorv32_core.cpuregs\[13\]\[3\]
+ sky130_fd_sc_hd__dfxtp_1
XFILLER_44_773 VGND VGND VPWR VPWR sky130_fd_sc_hd__fill_1
XTAP_TAPCELL_ROW_139_2321 VGND VPWR sky130_fd_sc_hd__tapvpwrvgnd_1
X_10888_ clknet_leaf_108_clk _00739_ VGND VGND VPWR VPWR axi_adapter.ack_arvalid sky130_fd_sc_hd__dfxtp_1
XTAP_TAPCELL_ROW_61_1184 VGND VPWR sky130_fd_sc_hd__tapvpwrvgnd_1
XTAP_TAPCELL_ROW_61_1195 VGND VPWR sky130_fd_sc_hd__tapvpwrvgnd_1
Xhold107 picorv32_core.cpuregs\[23\]\[28\] VGND VGND VPWR VPWR net1216 sky130_fd_sc_hd__dlygate4sd3_1
X_11509_ clknet_leaf_60_clk _01345_ VGND VGND VPWR VPWR net159 sky130_fd_sc_hd__dfxtp_1
Xhold129 picorv32_core.cpuregs\[23\]\[29\] VGND VGND VPWR VPWR net1238 sky130_fd_sc_hd__dlygate4sd3_1
Xhold118 picorv32_core.cpuregs\[7\]\[13\] VGND VGND VPWR VPWR net1227 sky130_fd_sc_hd__dlygate4sd3_1
XTAP_TAPCELL_ROW_117_1995 VGND VPWR sky130_fd_sc_hd__tapvpwrvgnd_1
Xfanout609 _01649_ VGND VGND VPWR VPWR net609 sky130_fd_sc_hd__buf_2
X_06981_ _03177_ _03180_ _03192_ VGND VGND VPWR VPWR _03194_ sky130_fd_sc_hd__nand3_1
XFILLER_86_629 VGND VGND VPWR VPWR sky130_fd_sc_hd__fill_2
XFILLER_79_670 VGND VGND VPWR VPWR sky130_fd_sc_hd__fill_2
XFILLER_58_309 VGND VGND VPWR VPWR sky130_fd_sc_hd__decap_3
X_05932_ net793 _02401_ VGND VGND VPWR VPWR _02402_ sky130_fd_sc_hd__nand2_1
X_08720_ _02797_ _04325_ VGND VGND VPWR VPWR _04337_ sky130_fd_sc_hd__nor2_1
X_08651_ net1464 net216 net393 VGND VGND VPWR VPWR _00802_ sky130_fd_sc_hd__mux2_1
X_05863_ net805 net960 net573 VGND VGND VPWR VPWR _02339_ sky130_fd_sc_hd__a21oi_1
XTAP_TAPCELL_ROW_1_316 VGND VPWR sky130_fd_sc_hd__tapvpwrvgnd_1
XFILLER_94_695 VGND VGND VPWR VPWR sky130_fd_sc_hd__decap_4
X_07602_ _01683_ _02611_ VGND VGND VPWR VPWR _03702_ sky130_fd_sc_hd__nor2_4
XFILLER_54_548 VGND VGND VPWR VPWR sky130_fd_sc_hd__fill_2
X_08582_ axi_adapter.xfer_done _04329_ axi_adapter.mem_valid net983 VGND VGND VPWR
+ VPWR _00706_ sky130_fd_sc_hd__and4b_1
X_05794_ net815 net966 net567 VGND VGND VPWR VPWR _02275_ sky130_fd_sc_hd__and3_1
X_07533_ picorv32_core.reg_out\[31\] picorv32_core.reg_next_pc\[31\] net559 VGND VGND
+ VPWR VPWR _03643_ sky130_fd_sc_hd__mux2_1
XFILLER_62_592 VGND VGND VPWR VPWR sky130_fd_sc_hd__fill_1
X_07464_ picorv32_core.reg_out\[8\] picorv32_core.reg_next_pc\[8\] net556 VGND VGND
+ VPWR VPWR _03597_ sky130_fd_sc_hd__mux2_1
X_06415_ net287 net2146 net423 VGND VGND VPWR VPWR _00083_ sky130_fd_sc_hd__mux2_1
X_09203_ _04398_ _04399_ _04400_ net485 _04397_ VGND VGND VPWR VPWR _04401_ sky130_fd_sc_hd__a221o_1
X_07395_ _03404_ _03531_ _03402_ _03403_ VGND VGND VPWR VPWR _03535_ sky130_fd_sc_hd__a211oi_1
X_09134_ net1342 net270 net329 VGND VGND VPWR VPWR _01300_ sky130_fd_sc_hd__mux2_1
XTAP_TAPCELL_ROW_20_602 VGND VPWR sky130_fd_sc_hd__tapvpwrvgnd_1
X_06346_ _02749_ _02750_ VGND VGND VPWR VPWR _02751_ sky130_fd_sc_hd__nor2_1
XTAP_TAPCELL_ROW_79_1456 VGND VPWR sky130_fd_sc_hd__tapvpwrvgnd_1
XTAP_TAPCELL_ROW_79_1445 VGND VPWR sky130_fd_sc_hd__tapvpwrvgnd_1
X_09065_ net1481 net289 net336 VGND VGND VPWR VPWR _01233_ sky130_fd_sc_hd__mux2_1
X_06277_ net1937 net430 net433 VGND VGND VPWR VPWR _00046_ sky130_fd_sc_hd__mux2_1
X_08016_ picorv32_core.cpuregs\[16\]\[28\] picorv32_core.cpuregs\[17\]\[28\] picorv32_core.cpuregs\[18\]\[28\]
+ picorv32_core.cpuregs\[19\]\[28\] net754 net721 VGND VGND VPWR VPWR _04093_ sky130_fd_sc_hd__mux4_1
Xhold630 picorv32_core.cpuregs\[3\]\[21\] VGND VGND VPWR VPWR net1739 sky130_fd_sc_hd__dlygate4sd3_1
X_05228_ picorv32_core.reg_pc\[2\] picorv32_core.decoded_imm\[2\] VGND VGND VPWR VPWR
+ _01742_ sky130_fd_sc_hd__and2_1
Xhold652 picorv32_core.cpuregs\[20\]\[27\] VGND VGND VPWR VPWR net1761 sky130_fd_sc_hd__dlygate4sd3_1
XTAP_TAPCELL_ROW_92_1645 VGND VPWR sky130_fd_sc_hd__tapvpwrvgnd_1
XTAP_TAPCELL_ROW_92_1634 VGND VPWR sky130_fd_sc_hd__tapvpwrvgnd_1
XTAP_TAPCELL_ROW_9_438 VGND VPWR sky130_fd_sc_hd__tapvpwrvgnd_1
Xhold663 picorv32_core.cpuregs\[9\]\[0\] VGND VGND VPWR VPWR net1772 sky130_fd_sc_hd__dlygate4sd3_1
Xhold641 picorv32_core.cpuregs\[29\]\[11\] VGND VGND VPWR VPWR net1750 sky130_fd_sc_hd__dlygate4sd3_1
Xhold685 picorv32_core.cpuregs\[2\]\[25\] VGND VGND VPWR VPWR net1794 sky130_fd_sc_hd__dlygate4sd3_1
Xhold674 picorv32_core.cpuregs\[30\]\[26\] VGND VGND VPWR VPWR net1783 sky130_fd_sc_hd__dlygate4sd3_1
XFILLER_103_233 VGND VGND VPWR VPWR sky130_fd_sc_hd__decap_4
XFILLER_89_445 VGND VGND VPWR VPWR sky130_fd_sc_hd__decap_3
X_05159_ picorv32_core.instr_lhu picorv32_core.instr_lh _01639_ VGND VGND VPWR VPWR
+ _01685_ sky130_fd_sc_hd__o21a_1
Xhold696 picorv32_core.cpuregs\[9\]\[8\] VGND VGND VPWR VPWR net1805 sky130_fd_sc_hd__dlygate4sd3_1
X_09967_ net1309 net222 net318 VGND VGND VPWR VPWR _01445_ sky130_fd_sc_hd__mux2_1
XFILLER_58_810 VGND VGND VPWR VPWR sky130_fd_sc_hd__fill_2
XFILLER_49_309 VGND VGND VPWR VPWR sky130_fd_sc_hd__fill_1
X_08918_ net207 net2208 net361 VGND VGND VPWR VPWR _01092_ sky130_fd_sc_hd__mux2_1
X_09898_ net2312 _05030_ _05032_ _04235_ VGND VGND VPWR VPWR _01383_ sky130_fd_sc_hd__o22a_1
X_08849_ net1226 net219 net368 VGND VGND VPWR VPWR _01025_ sky130_fd_sc_hd__mux2_1
XFILLER_73_835 VGND VGND VPWR VPWR sky130_fd_sc_hd__fill_2
XFILLER_18_729 VPWR VGND VPWR VGND sky130_ef_sc_hd__decap_12
XTAP_TAPCELL_ROW_28_713 VGND VPWR sky130_fd_sc_hd__tapvpwrvgnd_1
X_11860_ net967 VGND VGND VPWR VPWR net195 sky130_fd_sc_hd__clkbuf_1
XFILLER_45_559 VGND VGND VPWR VPWR sky130_fd_sc_hd__fill_1
X_10811_ clknet_leaf_21_clk _00662_ VGND VGND VPWR VPWR picorv32_core.cpuregs\[15\]\[20\]
+ sky130_fd_sc_hd__dfxtp_1
X_10742_ clknet_leaf_87_clk _00593_ VGND VGND VPWR VPWR picorv32_core.decoded_imm\[17\]
+ sky130_fd_sc_hd__dfxtp_2
XFILLER_40_253 VGND VGND VPWR VPWR sky130_fd_sc_hd__fill_1
XTAP_TAPCELL_ROW_101_1774 VGND VPWR sky130_fd_sc_hd__tapvpwrvgnd_1
XTAP_TAPCELL_ROW_101_1763 VGND VPWR sky130_fd_sc_hd__tapvpwrvgnd_1
X_10673_ clknet_leaf_94_clk _00527_ VGND VGND VPWR VPWR picorv32_core.decoded_imm_j\[11\]
+ sky130_fd_sc_hd__dfxtp_2
XFILLER_138_141 VGND VGND VPWR VPWR sky130_fd_sc_hd__decap_4
XTAP_TAPCELL_ROW_134_2251 VGND VPWR sky130_fd_sc_hd__tapvpwrvgnd_1
Xpicorv32_axi_1040 VGND VGND VPWR VPWR picorv32_axi_1040/HI pcpi_insn[0] sky130_fd_sc_hd__conb_1
Xpicorv32_axi_1062 VGND VGND VPWR VPWR picorv32_axi_1062/HI pcpi_insn[22] sky130_fd_sc_hd__conb_1
Xpicorv32_axi_1073 VGND VGND VPWR VPWR picorv32_axi_1073/HI trace_data[0] sky130_fd_sc_hd__conb_1
XFILLER_4_121 VPWR VGND VPWR VGND sky130_ef_sc_hd__decap_12
Xpicorv32_axi_1051 VGND VGND VPWR VPWR picorv32_axi_1051/HI pcpi_insn[11] sky130_fd_sc_hd__conb_1
Xpicorv32_axi_1084 VGND VGND VPWR VPWR picorv32_axi_1084/HI trace_data[11] sky130_fd_sc_hd__conb_1
XFILLER_107_561 VGND VGND VPWR VPWR sky130_fd_sc_hd__decap_4
X_11225_ clknet_leaf_15_clk _01076_ VGND VGND VPWR VPWR picorv32_core.cpuregs\[5\]\[15\]
+ sky130_fd_sc_hd__dfxtp_1
Xpicorv32_axi_1095 VGND VGND VPWR VPWR picorv32_axi_1095/HI trace_data[22] sky130_fd_sc_hd__conb_1
XFILLER_4_165 VPWR VGND VPWR VGND sky130_ef_sc_hd__decap_12
XFILLER_122_531 VGND VGND VPWR VPWR sky130_fd_sc_hd__fill_1
X_11156_ clknet_leaf_3_clk _01007_ VGND VGND VPWR VPWR picorv32_core.cpuregs\[7\]\[10\]
+ sky130_fd_sc_hd__dfxtp_1
X_10107_ net1134 VGND VGND VPWR VPWR _00957_ sky130_fd_sc_hd__clkbuf_1
XFILLER_68_83 VGND VGND VPWR VPWR sky130_fd_sc_hd__fill_1
X_11087_ clknet_leaf_137_clk _00938_ VGND VGND VPWR VPWR picorv32_core.cpuregs\[0\]\[5\]
+ sky130_fd_sc_hd__dfxtp_1
XFILLER_0_371 VGND VGND VPWR VPWR sky130_fd_sc_hd__decap_3
XFILLER_0_393 VGND VGND VPWR VPWR sky130_fd_sc_hd__fill_2
X_10038_ _04171_ _04325_ VGND VGND VPWR VPWR _05042_ sky130_fd_sc_hd__nor2_2
XFILLER_90_131 VGND VGND VPWR VPWR sky130_fd_sc_hd__fill_1
XFILLER_63_345 VGND VGND VPWR VPWR sky130_fd_sc_hd__fill_1
XFILLER_48_397 VPWR VGND VPWR VGND sky130_ef_sc_hd__decap_12
XFILLER_63_389 VGND VGND VPWR VPWR sky130_fd_sc_hd__decap_3
XTAP_TAPCELL_ROW_63_1224 VGND VPWR sky130_fd_sc_hd__tapvpwrvgnd_1
XTAP_TAPCELL_ROW_63_1213 VGND VPWR sky130_fd_sc_hd__tapvpwrvgnd_1
XFILLER_83_3 VGND VGND VPWR VPWR sky130_fd_sc_hd__decap_3
X_06200_ _02629_ _02630_ net632 VGND VGND VPWR VPWR _02631_ sky130_fd_sc_hd__mux2_1
XFILLER_32_787 VPWR VGND VPWR VGND sky130_ef_sc_hd__decap_12
XPHY_EDGE_ROW_140_Right_140 VGND VGND VPWR VPWR sky130_fd_sc_hd__decap_3
X_07180_ net2255 _03343_ net986 VGND VGND VPWR VPWR _03345_ sky130_fd_sc_hd__o21ai_1
XFILLER_129_185 VGND VGND VPWR VPWR sky130_fd_sc_hd__fill_1
X_06131_ net671 net954 _02576_ VGND VGND VPWR VPWR _02585_ sky130_fd_sc_hd__a21oi_1
X_06062_ _02511_ _02521_ _02520_ VGND VGND VPWR VPWR _02522_ sky130_fd_sc_hd__o21ai_2
Xfanout417 _04172_ VGND VGND VPWR VPWR net417 sky130_fd_sc_hd__buf_4
XFILLER_98_253 VGND VGND VPWR VPWR sky130_fd_sc_hd__decap_6
X_09821_ net772 net545 _04970_ VGND VGND VPWR VPWR _04991_ sky130_fd_sc_hd__o21ba_1
Xfanout439 net440 VGND VGND VPWR VPWR net439 sky130_fd_sc_hd__clkbuf_4
XTAP_TAPCELL_ROW_74_1375 VGND VPWR sky130_fd_sc_hd__tapvpwrvgnd_1
XFILLER_58_106 VGND VGND VPWR VPWR sky130_fd_sc_hd__decap_3
Xfanout406 net407 VGND VGND VPWR VPWR net406 sky130_fd_sc_hd__clkbuf_8
Xfanout428 _02698_ VGND VGND VPWR VPWR net428 sky130_fd_sc_hd__clkbuf_2
XFILLER_113_597 VGND VGND VPWR VPWR sky130_fd_sc_hd__decap_4
X_09752_ _03408_ _03529_ _03407_ VGND VGND VPWR VPWR _04925_ sky130_fd_sc_hd__o21ai_1
XFILLER_104_15 VPWR VGND VPWR VGND sky130_ef_sc_hd__decap_12
X_06964_ _03165_ _03170_ _03163_ VGND VGND VPWR VPWR _03178_ sky130_fd_sc_hd__a21o_1
X_08703_ net1892 net268 net382 VGND VGND VPWR VPWR _00852_ sky130_fd_sc_hd__mux2_1
X_09683_ net838 _04858_ net645 VGND VGND VPWR VPWR _04860_ sky130_fd_sc_hd__o21a_1
X_06895_ net667 picorv32_core.reg_next_pc\[16\] _02928_ net490 VGND VGND VPWR VPWR
+ _03115_ sky130_fd_sc_hd__a22o_1
X_05915_ net797 net957 net568 VGND VGND VPWR VPWR _02387_ sky130_fd_sc_hd__and3_1
XFILLER_39_364 VGND VGND VPWR VPWR sky130_fd_sc_hd__decap_6
XFILLER_39_386 VGND VGND VPWR VPWR sky130_fd_sc_hd__fill_1
XFILLER_82_643 VGND VGND VPWR VPWR sky130_fd_sc_hd__fill_1
X_08634_ net1585 net286 net390 VGND VGND VPWR VPWR _00785_ sky130_fd_sc_hd__mux2_1
X_05846_ _02321_ _02322_ VGND VGND VPWR VPWR _02323_ sky130_fd_sc_hd__nand2b_1
X_08565_ net267 net1672 net400 VGND VGND VPWR VPWR _00690_ sky130_fd_sc_hd__mux2_1
XFILLER_54_356 VGND VGND VPWR VPWR sky130_fd_sc_hd__fill_1
X_05777_ net819 _02258_ VGND VGND VPWR VPWR _02260_ sky130_fd_sc_hd__xnor2_1
X_07516_ net772 _03631_ net535 VGND VGND VPWR VPWR _03632_ sky130_fd_sc_hd__mux2_1
X_08496_ net1456 net264 net408 VGND VGND VPWR VPWR _00626_ sky130_fd_sc_hd__mux2_1
XFILLER_23_765 VPWR VGND VPWR VGND sky130_ef_sc_hd__decap_12
X_07447_ net818 _03581_ net532 VGND VGND VPWR VPWR _03586_ sky130_fd_sc_hd__mux2_1
XFILLER_22_253 VGND VGND VPWR VPWR sky130_fd_sc_hd__decap_3
XTAP_TAPCELL_ROW_33_782 VGND VPWR sky130_fd_sc_hd__tapvpwrvgnd_1
X_07378_ _03413_ _03517_ VGND VGND VPWR VPWR _03518_ sky130_fd_sc_hd__nand2_1
XFILLER_135_111 VGND VGND VPWR VPWR sky130_fd_sc_hd__fill_1
X_09117_ net207 net1619 net335 VGND VGND VPWR VPWR _01284_ sky130_fd_sc_hd__mux2_1
X_06329_ picorv32_core.reg_out\[18\] picorv32_core.alu_out_q\[18\] net952 VGND VGND
+ VPWR VPWR _02737_ sky130_fd_sc_hd__mux2_1
XFILLER_6_419 VGND VGND VPWR VPWR sky130_fd_sc_hd__fill_1
X_09048_ net218 net2009 net343 VGND VGND VPWR VPWR _01217_ sky130_fd_sc_hd__mux2_1
XFILLER_89_49 VGND VGND VPWR VPWR sky130_fd_sc_hd__decap_6
Xhold460 picorv32_core.cpuregs\[10\]\[28\] VGND VGND VPWR VPWR net1569 sky130_fd_sc_hd__dlygate4sd3_1
XFILLER_1_113 VPWR VGND VPWR VGND sky130_ef_sc_hd__decap_12
Xhold471 picorv32_core.cpuregs\[12\]\[8\] VGND VGND VPWR VPWR net1580 sky130_fd_sc_hd__dlygate4sd3_1
Xhold493 picorv32_core.cpuregs\[2\]\[26\] VGND VGND VPWR VPWR net1602 sky130_fd_sc_hd__dlygate4sd3_1
X_11010_ clknet_leaf_33_clk _00861_ VGND VGND VPWR VPWR picorv32_core.cpuregs\[12\]\[24\]
+ sky130_fd_sc_hd__dfxtp_1
Xhold482 picorv32_core.cpuregs\[14\]\[20\] VGND VGND VPWR VPWR net1591 sky130_fd_sc_hd__dlygate4sd3_1
XFILLER_131_361 VGND VGND VPWR VPWR sky130_fd_sc_hd__fill_1
XFILLER_104_586 VGND VGND VPWR VPWR sky130_fd_sc_hd__fill_2
XFILLER_77_437 VGND VGND VPWR VPWR sky130_fd_sc_hd__decap_6
Xfanout940 picorv32_core.instr_rdinstr VGND VGND VPWR VPWR net940 sky130_fd_sc_hd__clkbuf_2
Xfanout951 picorv32_core.latched_stalu VGND VGND VPWR VPWR net951 sky130_fd_sc_hd__clkbuf_2
XFILLER_49_117 VGND VGND VPWR VPWR sky130_fd_sc_hd__fill_1
Xfanout995 net998 VGND VGND VPWR VPWR net995 sky130_fd_sc_hd__clkbuf_1
Xfanout984 net987 VGND VGND VPWR VPWR net984 sky130_fd_sc_hd__buf_2
Xfanout973 net974 VGND VGND VPWR VPWR net973 sky130_fd_sc_hd__clkbuf_2
Xfanout962 picorv32_core.mem_la_wdata\[7\] VGND VGND VPWR VPWR net962 sky130_fd_sc_hd__buf_4
XFILLER_92_418 VGND VGND VPWR VPWR sky130_fd_sc_hd__fill_2
Xhold1160 picorv32_core.count_instr\[13\] VGND VGND VPWR VPWR net2269 sky130_fd_sc_hd__dlygate4sd3_1
XFILLER_46_813 VGND VGND VPWR VPWR sky130_fd_sc_hd__fill_1
Xhold1193 picorv32_core.count_instr\[57\] VGND VGND VPWR VPWR net2302 sky130_fd_sc_hd__dlygate4sd3_1
Xhold1171 picorv32_core.count_cycle\[30\] VGND VGND VPWR VPWR net2280 sky130_fd_sc_hd__dlygate4sd3_1
Xhold1182 picorv32_core.is_alu_reg_imm VGND VGND VPWR VPWR net2291 sky130_fd_sc_hd__dlygate4sd3_1
X_11843_ net46 VGND VGND VPWR VPWR net78 sky130_fd_sc_hd__clkbuf_1
XTAP_TAPCELL_ROW_103_1803 VGND VPWR sky130_fd_sc_hd__tapvpwrvgnd_1
XFILLER_72_197 VGND VGND VPWR VPWR sky130_fd_sc_hd__fill_1
XFILLER_60_359 VGND VGND VPWR VPWR sky130_fd_sc_hd__decap_4
X_10725_ clknet_leaf_108_clk _00576_ VGND VGND VPWR VPWR net138 sky130_fd_sc_hd__dfxtp_1
X_10656_ clknet_leaf_33_clk _00510_ VGND VGND VPWR VPWR picorv32_core.cpuregs\[20\]\[24\]
+ sky130_fd_sc_hd__dfxtp_1
XTAP_TAPCELL_ROW_11_465 VGND VPWR sky130_fd_sc_hd__tapvpwrvgnd_1
Xclkload16 clknet_leaf_3_clk VGND VGND VPWR VPWR clkload16/Y sky130_fd_sc_hd__inv_6
XFILLER_126_133 VGND VGND VPWR VPWR sky130_fd_sc_hd__decap_6
Xclkload49 clknet_leaf_26_clk VGND VGND VPWR VPWR clkload49/Y sky130_fd_sc_hd__bufinv_16
Xclkload27 clknet_leaf_10_clk VGND VGND VPWR VPWR clkload27/Y sky130_fd_sc_hd__inv_6
Xclkload38 clknet_leaf_13_clk VGND VGND VPWR VPWR clkload38/X sky130_fd_sc_hd__clkbuf_8
X_10587_ clknet_leaf_96_clk _00441_ VGND VGND VPWR VPWR picorv32_core.instr_lw sky130_fd_sc_hd__dfxtp_1
XFILLER_141_125 VPWR VGND VPWR VGND sky130_ef_sc_hd__decap_12
XTAP_TAPCELL_ROW_114_1965 VGND VPWR sky130_fd_sc_hd__tapvpwrvgnd_1
XTAP_TAPCELL_ROW_114_1954 VGND VPWR sky130_fd_sc_hd__tapvpwrvgnd_1
XFILLER_141_169 VPWR VGND VPWR VGND sky130_ef_sc_hd__decap_12
X_11208_ clknet_leaf_65_clk _01059_ VGND VGND VPWR VPWR picorv32_core.cpuregs\[6\]\[30\]
+ sky130_fd_sc_hd__dfxtp_1
XFILLER_95_223 VGND VGND VPWR VPWR sky130_fd_sc_hd__fill_1
X_11139_ clknet_leaf_69_clk _00990_ VGND VGND VPWR VPWR picorv32_core.cpuregs\[8\]\[25\]
+ sky130_fd_sc_hd__dfxtp_1
XFILLER_110_589 VGND VGND VPWR VPWR sky130_fd_sc_hd__fill_2
XFILLER_49_673 VGND VGND VPWR VPWR sky130_fd_sc_hd__fill_1
XFILLER_37_824 VGND VGND VPWR VPWR sky130_fd_sc_hd__decap_8
X_06680_ picorv32_core.reg_pc\[17\] net554 _02929_ net517 VGND VGND VPWR VPWR _00215_
+ sky130_fd_sc_hd__a22o_1
XFILLER_76_481 VGND VGND VPWR VPWR sky130_fd_sc_hd__fill_1
X_05700_ _02182_ _02183_ VGND VGND VPWR VPWR _02184_ sky130_fd_sc_hd__and2_1
XFILLER_48_194 VGND VGND VPWR VPWR sky130_fd_sc_hd__fill_2
X_05631_ net28 net583 net574 VGND VGND VPWR VPWR _02116_ sky130_fd_sc_hd__a21o_1
XFILLER_63_153 VGND VGND VPWR VPWR sky130_fd_sc_hd__fill_1
X_08350_ net928 net963 net178 net927 VGND VGND VPWR VPWR _04249_ sky130_fd_sc_hd__a22o_1
XFILLER_51_337 VGND VGND VPWR VPWR sky130_fd_sc_hd__fill_1
XTAP_TAPCELL_ROW_19_576 VGND VPWR sky130_fd_sc_hd__tapvpwrvgnd_1
XTAP_TAPCELL_ROW_19_587 VGND VPWR sky130_fd_sc_hd__tapvpwrvgnd_1
X_05562_ net922 _02045_ _02046_ _02052_ VGND VGND VPWR VPWR _01564_ sky130_fd_sc_hd__a31o_1
X_07301_ net803 picorv32_core.decoded_imm\[9\] VGND VGND VPWR VPWR _03441_ sky130_fd_sc_hd__nand2_1
XFILLER_51_348 VGND VGND VPWR VPWR sky130_fd_sc_hd__fill_1
XFILLER_32_540 VGND VGND VPWR VPWR sky130_fd_sc_hd__decap_8
X_08281_ net1669 net252 net412 VGND VGND VPWR VPWR _00505_ sky130_fd_sc_hd__mux2_1
X_05493_ net946 picorv32_core.count_cycle\[52\] net603 _01988_ VGND VGND VPWR VPWR
+ _01989_ sky130_fd_sc_hd__a211o_1
XFILLER_32_584 VGND VGND VPWR VPWR sky130_fd_sc_hd__fill_1
X_07232_ net2365 _03375_ _03377_ VGND VGND VPWR VPWR _00319_ sky130_fd_sc_hd__o21a_1
XFILLER_20_757 VPWR VGND VPWR VGND sky130_ef_sc_hd__decap_12
XTAP_TAPCELL_ROW_30_741 VGND VPWR sky130_fd_sc_hd__tapvpwrvgnd_1
X_07163_ picorv32_core.count_cycle\[32\] picorv32_core.count_cycle\[33\] picorv32_core.count_cycle\[31\]
+ _03329_ VGND VGND VPWR VPWR _03334_ sky130_fd_sc_hd__and4_1
X_06114_ net766 _02568_ VGND VGND VPWR VPWR _02570_ sky130_fd_sc_hd__nor2_1
XTAP_TAPCELL_ROW_76_1404 VGND VPWR sky130_fd_sc_hd__tapvpwrvgnd_1
XFILLER_133_615 VGND VGND VPWR VPWR sky130_fd_sc_hd__fill_1
X_07094_ picorv32_core.count_cycle\[7\] _03289_ net972 VGND VGND VPWR VPWR _03291_
+ sky130_fd_sc_hd__a21oi_1
XFILLER_133_637 VGND VGND VPWR VPWR sky130_fd_sc_hd__decap_6
X_06045_ net507 _02503_ _02506_ VGND VGND VPWR VPWR picorv32_core.alu_out\[22\] sky130_fd_sc_hd__a21o_1
Xfanout214 net216 VGND VGND VPWR VPWR net214 sky130_fd_sc_hd__clkbuf_2
X_09804_ picorv32_core.cpuregs\[8\]\[28\] picorv32_core.cpuregs\[9\]\[28\] picorv32_core.cpuregs\[10\]\[28\]
+ picorv32_core.cpuregs\[11\]\[28\] net896 net862 VGND VGND VPWR VPWR _04975_ sky130_fd_sc_hd__mux4_1
Xfanout236 net237 VGND VGND VPWR VPWR net236 sky130_fd_sc_hd__clkbuf_2
Xfanout225 _02773_ VGND VGND VPWR VPWR net225 sky130_fd_sc_hd__clkbuf_2
XFILLER_99_595 VGND VGND VPWR VPWR sky130_fd_sc_hd__fill_1
Xfanout247 net250 VGND VGND VPWR VPWR net247 sky130_fd_sc_hd__clkbuf_2
XFILLER_87_724 VGND VGND VPWR VPWR sky130_fd_sc_hd__decap_4
X_07996_ picorv32_core.decoded_imm\[26\] net591 net597 VGND VGND VPWR VPWR _04075_
+ sky130_fd_sc_hd__a21o_1
Xfanout258 _02739_ VGND VGND VPWR VPWR net258 sky130_fd_sc_hd__buf_1
Xfanout269 _02728_ VGND VGND VPWR VPWR net269 sky130_fd_sc_hd__dlymetal6s2s_1
XFILLER_101_589 VGND VGND VPWR VPWR sky130_fd_sc_hd__decap_8
X_09735_ net472 _04847_ _04907_ _04908_ VGND VGND VPWR VPWR _04909_ sky130_fd_sc_hd__a31o_1
X_06947_ net989 _03162_ VGND VGND VPWR VPWR _00249_ sky130_fd_sc_hd__and2_1
XFILLER_28_813 VPWR VGND VPWR VGND sky130_ef_sc_hd__decap_12
X_09666_ net777 net280 VGND VGND VPWR VPWR _04843_ sky130_fd_sc_hd__and2_1
XFILLER_39_194 VGND VGND VPWR VPWR sky130_fd_sc_hd__fill_1
XFILLER_131_57 VPWR VGND VPWR VGND sky130_ef_sc_hd__decap_12
XTAP_TAPCELL_ROW_87_1566 VGND VPWR sky130_fd_sc_hd__tapvpwrvgnd_1
X_06878_ _03094_ _03098_ VGND VGND VPWR VPWR _03099_ sky130_fd_sc_hd__nand2_1
XFILLER_54_131 VGND VGND VPWR VPWR sky130_fd_sc_hd__fill_1
X_08617_ net983 net1 net103 net2306 VGND VGND VPWR VPWR _04332_ sky130_fd_sc_hd__a31o_1
XTAP_TAPCELL_ROW_38_852 VGND VPWR sky130_fd_sc_hd__tapvpwrvgnd_1
XTAP_TAPCELL_ROW_38_863 VGND VPWR sky130_fd_sc_hd__tapvpwrvgnd_1
XFILLER_43_805 VGND VGND VPWR VPWR sky130_fd_sc_hd__decap_3
X_09597_ net832 _04774_ _04777_ net480 VGND VGND VPWR VPWR _04778_ sky130_fd_sc_hd__o211a_1
XFILLER_54_197 VGND VGND VPWR VPWR sky130_fd_sc_hd__fill_1
X_05829_ _02123_ _02306_ _02305_ VGND VGND VPWR VPWR _02307_ sky130_fd_sc_hd__a21o_1
XFILLER_70_679 VGND VGND VPWR VPWR sky130_fd_sc_hd__fill_1
X_08548_ _02795_ _04327_ VGND VGND VPWR VPWR _04328_ sky130_fd_sc_hd__or2_4
Xclkbuf_leaf_143_clk clknet_4_0_0_clk VGND VGND VPWR VPWR clknet_leaf_143_clk sky130_fd_sc_hd__clkbuf_8
X_08479_ _02666_ _04322_ VGND VGND VPWR VPWR _04323_ sky130_fd_sc_hd__nor2_2
XTAP_TAPCELL_ROW_118_2021 VGND VPWR sky130_fd_sc_hd__tapvpwrvgnd_1
XTAP_TAPCELL_ROW_118_2010 VGND VPWR sky130_fd_sc_hd__tapvpwrvgnd_1
X_10510_ clknet_leaf_96_clk _00396_ VGND VGND VPWR VPWR picorv32_core.latched_is_lh
+ sky130_fd_sc_hd__dfxtp_1
X_11490_ clknet_leaf_124_clk _01326_ VGND VGND VPWR VPWR net170 sky130_fd_sc_hd__dfxtp_1
X_10441_ clknet_leaf_115_clk _00328_ VGND VGND VPWR VPWR net63 sky130_fd_sc_hd__dfxtp_1
XFILLER_40_43 VGND VGND VPWR VPWR sky130_fd_sc_hd__decap_3
XFILLER_136_475 VGND VGND VPWR VPWR sky130_fd_sc_hd__fill_1
XFILLER_136_464 VGND VGND VPWR VPWR sky130_fd_sc_hd__fill_1
XTAP_TAPCELL_ROW_131_2210 VGND VPWR sky130_fd_sc_hd__tapvpwrvgnd_1
X_10372_ clknet_leaf_77_clk _00291_ VGND VGND VPWR VPWR picorv32_core.count_cycle\[30\]
+ sky130_fd_sc_hd__dfxtp_1
XFILLER_2_433 VGND VGND VPWR VPWR sky130_fd_sc_hd__decap_4
Xhold290 picorv32_core.cpuregs\[3\]\[20\] VGND VGND VPWR VPWR net1399 sky130_fd_sc_hd__dlygate4sd3_1
XTAP_TAPCELL_ROW_129_2172 VGND VPWR sky130_fd_sc_hd__tapvpwrvgnd_1
Xfanout770 net159 VGND VGND VPWR VPWR net770 sky130_fd_sc_hd__clkbuf_2
Xfanout781 net782 VGND VGND VPWR VPWR net781 sky130_fd_sc_hd__buf_2
Xfanout792 net147 VGND VGND VPWR VPWR net792 sky130_fd_sc_hd__clkbuf_4
XFILLER_93_749 VGND VGND VPWR VPWR sky130_fd_sc_hd__decap_8
XFILLER_46_632 VGND VGND VPWR VPWR sky130_fd_sc_hd__decap_4
XFILLER_65_73 VGND VGND VPWR VPWR sky130_fd_sc_hd__fill_2
XFILLER_61_602 VGND VGND VPWR VPWR sky130_fd_sc_hd__fill_1
XFILLER_46_676 VGND VGND VPWR VPWR sky130_fd_sc_hd__fill_2
XFILLER_45_186 VGND VGND VPWR VPWR sky130_fd_sc_hd__fill_1
XFILLER_61_657 VGND VGND VPWR VPWR sky130_fd_sc_hd__fill_1
XTAP_TAPCELL_ROW_16_535 VGND VPWR sky130_fd_sc_hd__tapvpwrvgnd_1
Xclkbuf_leaf_134_clk clknet_4_2_0_clk VGND VGND VPWR VPWR clknet_leaf_134_clk sky130_fd_sc_hd__clkbuf_8
X_10708_ clknet_leaf_26_clk _00559_ VGND VGND VPWR VPWR net113 sky130_fd_sc_hd__dfxtp_1
X_11688_ clknet_leaf_139_clk _01519_ VGND VGND VPWR VPWR picorv32_core.cpuregs\[27\]\[5\]
+ sky130_fd_sc_hd__dfxtp_1
Xclkload127 clknet_leaf_69_clk VGND VGND VPWR VPWR clkload127/Y sky130_fd_sc_hd__bufinv_16
Xclkload116 clknet_leaf_59_clk VGND VGND VPWR VPWR clkload116/Y sky130_fd_sc_hd__inv_8
Xclkload105 clknet_leaf_97_clk VGND VGND VPWR VPWR clkload105/Y sky130_fd_sc_hd__clkinvlp_4
X_10639_ clknet_leaf_130_clk _00493_ VGND VGND VPWR VPWR picorv32_core.cpuregs\[20\]\[7\]
+ sky130_fd_sc_hd__dfxtp_1
Xclkload138 clknet_leaf_73_clk VGND VGND VPWR VPWR clkload138/Y sky130_fd_sc_hd__inv_8
XTAP_TAPCELL_ROW_58_1145 VGND VPWR sky130_fd_sc_hd__tapvpwrvgnd_1
XFILLER_69_702 VGND VGND VPWR VPWR sky130_fd_sc_hd__fill_2
XFILLER_46_3 VPWR VGND VPWR VGND sky130_ef_sc_hd__decap_12
XTAP_TAPCELL_ROW_71_1334 VGND VPWR sky130_fd_sc_hd__tapvpwrvgnd_1
XPHY_EDGE_ROW_18_Right_18 VGND VGND VPWR VPWR sky130_fd_sc_hd__decap_3
X_07850_ net685 _03936_ net625 VGND VGND VPWR VPWR _03937_ sky130_fd_sc_hd__a21o_1
X_07781_ net178 net512 _03870_ _03871_ VGND VGND VPWR VPWR _00374_ sky130_fd_sc_hd__o22a_1
X_06801_ _03023_ _03026_ VGND VGND VPWR VPWR _03028_ sky130_fd_sc_hd__nor2_1
XFILLER_84_749 VGND VGND VPWR VPWR sky130_fd_sc_hd__decap_4
X_09520_ picorv32_core.cpuregs\[20\]\[15\] picorv32_core.cpuregs\[21\]\[15\] picorv32_core.cpuregs\[22\]\[15\]
+ picorv32_core.cpuregs\[23\]\[15\] net893 net859 VGND VGND VPWR VPWR _04704_ sky130_fd_sc_hd__mux4_1
Xinput3 mem_axi_bvalid VGND VGND VPWR VPWR net3 sky130_fd_sc_hd__clkbuf_1
X_06732_ picorv32_core.decoded_imm_j\[4\] _02916_ VGND VGND VPWR VPWR _02964_ sky130_fd_sc_hd__or2_1
X_09451_ picorv32_core.cpuregs\[20\]\[12\] picorv32_core.cpuregs\[21\]\[12\] picorv32_core.cpuregs\[22\]\[12\]
+ picorv32_core.cpuregs\[23\]\[12\] net879 net846 VGND VGND VPWR VPWR _04638_ sky130_fd_sc_hd__mux4_1
X_06663_ _02699_ picorv32_core.reg_next_pc\[9\] net557 VGND VGND VPWR VPWR _02921_
+ sky130_fd_sc_hd__mux2_2
XFILLER_52_613 VGND VGND VPWR VPWR sky130_fd_sc_hd__fill_1
XTAP_TAPCELL_ROW_35_811 VGND VPWR sky130_fd_sc_hd__tapvpwrvgnd_1
XFILLER_101_27 VGND VGND VPWR VPWR sky130_fd_sc_hd__decap_4
X_05614_ net922 _02094_ _02095_ _02100_ VGND VGND VPWR VPWR _02101_ sky130_fd_sc_hd__a31o_1
X_06594_ picorv32_core.count_instr\[46\] picorv32_core.count_instr\[45\] _02874_ VGND
+ VGND VPWR VPWR _02878_ sky130_fd_sc_hd__and3_1
X_09382_ net474 _04503_ _04571_ _04570_ VGND VGND VPWR VPWR _04572_ sky130_fd_sc_hd__a31o_1
XPHY_EDGE_ROW_27_Right_27 VGND VGND VPWR VPWR sky130_fd_sc_hd__decap_3
XFILLER_36_197 VGND VGND VPWR VPWR sky130_fd_sc_hd__decap_4
X_08402_ _01624_ _03583_ VGND VGND VPWR VPWR _04278_ sky130_fd_sc_hd__nor2_1
X_05545_ picorv32_core.count_instr\[56\] net937 net941 picorv32_core.count_instr\[24\]
+ VGND VGND VPWR VPWR _02037_ sky130_fd_sc_hd__a22o_1
X_08333_ _01595_ net960 net451 _04237_ VGND VGND VPWR VPWR _04238_ sky130_fd_sc_hd__a211o_1
Xclkbuf_leaf_125_clk clknet_4_9_0_clk VGND VGND VPWR VPWR clknet_leaf_125_clk sky130_fd_sc_hd__clkbuf_8
XTAP_TAPCELL_ROW_82_1496 VGND VPWR sky130_fd_sc_hd__tapvpwrvgnd_1
X_08264_ net2091 _02674_ net410 VGND VGND VPWR VPWR _00488_ sky130_fd_sc_hd__mux2_1
X_05476_ picorv32_core.count_instr\[51\] net938 net942 picorv32_core.count_instr\[19\]
+ VGND VGND VPWR VPWR _01973_ sky130_fd_sc_hd__a22o_1
X_07215_ picorv32_core.count_cycle\[52\] _03365_ net976 VGND VGND VPWR VPWR _03367_
+ sky130_fd_sc_hd__a21oi_1
X_08195_ net2244 net522 _04196_ picorv32_core.is_sb_sh_sw VGND VGND VPWR VPWR _00450_
+ sky130_fd_sc_hd__a22o_1
XFILLER_20_587 VGND VGND VPWR VPWR sky130_fd_sc_hd__fill_1
XFILLER_133_401 VGND VGND VPWR VPWR sky130_fd_sc_hd__decap_4
X_07146_ _03323_ net990 _03322_ VGND VGND VPWR VPWR _00287_ sky130_fd_sc_hd__and3b_1
X_07077_ net972 net1689 VGND VGND VPWR VPWR _00261_ sky130_fd_sc_hd__nor2_1
X_06028_ _02472_ _02480_ _02489_ _02254_ VGND VGND VPWR VPWR _02491_ sky130_fd_sc_hd__a31o_1
XPHY_EDGE_ROW_36_Right_36 VGND VGND VPWR VPWR sky130_fd_sc_hd__decap_3
XFILLER_86_17 VGND VGND VPWR VPWR sky130_fd_sc_hd__decap_3
XFILLER_87_543 VGND VGND VPWR VPWR sky130_fd_sc_hd__fill_1
XFILLER_59_223 VGND VGND VPWR VPWR sky130_fd_sc_hd__fill_1
X_07979_ picorv32_core.cpuregs\[20\]\[26\] picorv32_core.cpuregs\[21\]\[26\] picorv32_core.cpuregs\[22\]\[26\]
+ picorv32_core.cpuregs\[23\]\[26\] net759 net726 VGND VGND VPWR VPWR _04058_ sky130_fd_sc_hd__mux4_1
X_09718_ picorv32_core.cpuregs\[16\]\[24\] picorv32_core.cpuregs\[17\]\[24\] picorv32_core.cpuregs\[18\]\[24\]
+ picorv32_core.cpuregs\[19\]\[24\] net894 net860 VGND VGND VPWR VPWR _04893_ sky130_fd_sc_hd__mux4_1
XFILLER_28_610 VGND VGND VPWR VPWR sky130_fd_sc_hd__decap_3
XFILLER_55_462 VGND VGND VPWR VPWR sky130_fd_sc_hd__fill_1
XFILLER_55_440 VGND VGND VPWR VPWR sky130_fd_sc_hd__fill_1
X_10990_ clknet_leaf_113_clk _00841_ VGND VGND VPWR VPWR picorv32_core.cpuregs\[12\]\[4\]
+ sky130_fd_sc_hd__dfxtp_1
XFILLER_16_805 VGND VGND VPWR VPWR sky130_fd_sc_hd__decap_6
X_09649_ net611 _04823_ _04826_ net487 VGND VGND VPWR VPWR _04827_ sky130_fd_sc_hd__a211o_1
XFILLER_70_421 VGND VGND VPWR VPWR sky130_fd_sc_hd__fill_1
XFILLER_43_613 VGND VGND VPWR VPWR sky130_fd_sc_hd__decap_3
XPHY_EDGE_ROW_45_Right_45 VGND VGND VPWR VPWR sky130_fd_sc_hd__decap_3
XFILLER_43_668 VGND VGND VPWR VPWR sky130_fd_sc_hd__decap_4
X_11611_ clknet_leaf_35_clk _01442_ VGND VGND VPWR VPWR picorv32_core.cpuregs\[23\]\[24\]
+ sky130_fd_sc_hd__dfxtp_1
XFILLER_35_87 VGND VGND VPWR VPWR sky130_fd_sc_hd__decap_4
XFILLER_42_178 VGND VGND VPWR VPWR sky130_fd_sc_hd__fill_2
XFILLER_11_521 VGND VGND VPWR VPWR sky130_fd_sc_hd__decap_4
Xclkbuf_leaf_116_clk clknet_4_8_0_clk VGND VGND VPWR VPWR clknet_leaf_116_clk sky130_fd_sc_hd__clkbuf_8
X_11542_ clknet_leaf_44_clk _01373_ VGND VGND VPWR VPWR picorv32_core.cpuregs\[30\]\[23\]
+ sky130_fd_sc_hd__dfxtp_1
XFILLER_11_565 VGND VGND VPWR VPWR sky130_fd_sc_hd__fill_1
X_11473_ clknet_leaf_39_clk _01309_ VGND VGND VPWR VPWR picorv32_core.cpuregs\[24\]\[24\]
+ sky130_fd_sc_hd__dfxtp_1
XFILLER_51_86 VGND VGND VPWR VPWR sky130_fd_sc_hd__fill_1
X_10424_ clknet_leaf_82_clk _01555_ VGND VGND VPWR VPWR picorv32_core.reg_out\[17\]
+ sky130_fd_sc_hd__dfxtp_1
XPHY_EDGE_ROW_54_Right_54 VGND VGND VPWR VPWR sky130_fd_sc_hd__decap_3
XFILLER_112_607 VGND VGND VPWR VPWR sky130_fd_sc_hd__decap_4
XTAP_TAPCELL_ROW_111_1913 VGND VPWR sky130_fd_sc_hd__tapvpwrvgnd_1
X_10355_ clknet_leaf_99_clk _00274_ VGND VGND VPWR VPWR picorv32_core.count_cycle\[13\]
+ sky130_fd_sc_hd__dfxtp_1
XFILLER_3_753 VPWR VGND VPWR VGND sky130_ef_sc_hd__decap_12
XFILLER_3_797 VPWR VGND VPWR VGND sky130_ef_sc_hd__decap_12
X_10286_ clknet_leaf_125_clk _00205_ VGND VGND VPWR VPWR picorv32_core.reg_pc\[7\]
+ sky130_fd_sc_hd__dfxtp_1
XFILLER_78_554 VGND VGND VPWR VPWR sky130_fd_sc_hd__decap_3
XFILLER_66_727 VGND VGND VPWR VPWR sky130_fd_sc_hd__decap_4
XTAP_TAPCELL_ROW_53_1075 VGND VPWR sky130_fd_sc_hd__tapvpwrvgnd_1
XPHY_EDGE_ROW_63_Right_63 VGND VGND VPWR VPWR sky130_fd_sc_hd__decap_3
XTAP_TAPCELL_ROW_109_1886 VGND VPWR sky130_fd_sc_hd__tapvpwrvgnd_1
XFILLER_34_613 VGND VGND VPWR VPWR sky130_fd_sc_hd__decap_4
XFILLER_61_465 VGND VGND VPWR VPWR sky130_fd_sc_hd__fill_2
XPHY_EDGE_ROW_1_Left_143 VGND VGND VPWR VPWR sky130_fd_sc_hd__decap_3
X_05330_ _01834_ _01835_ VGND VGND VPWR VPWR _01837_ sky130_fd_sc_hd__nor2_1
XFILLER_14_392 VGND VGND VPWR VPWR sky130_fd_sc_hd__fill_2
Xclkbuf_leaf_107_clk clknet_4_10_0_clk VGND VGND VPWR VPWR clknet_leaf_107_clk sky130_fd_sc_hd__clkbuf_8
XTAP_TAPCELL_ROW_40_880 VGND VPWR sky130_fd_sc_hd__tapvpwrvgnd_1
X_05261_ picorv32_core.count_instr\[36\] net935 net943 picorv32_core.count_cycle\[36\]
+ VGND VGND VPWR VPWR _01773_ sky130_fd_sc_hd__a22o_1
X_07000_ _03170_ _03209_ _03210_ VGND VGND VPWR VPWR _03211_ sky130_fd_sc_hd__a21o_1
XPHY_EDGE_ROW_72_Right_72 VGND VGND VPWR VPWR sky130_fd_sc_hd__decap_3
X_05192_ axi_adapter.mem_valid _01712_ VGND VGND VPWR VPWR _01713_ sky130_fd_sc_hd__nand2_1
XTAP_TAPCELL_ROW_40_891 VGND VPWR sky130_fd_sc_hd__tapvpwrvgnd_1
XFILLER_88_307 VGND VGND VPWR VPWR sky130_fd_sc_hd__fill_1
X_08951_ net207 net2049 net356 VGND VGND VPWR VPWR _01124_ sky130_fd_sc_hd__mux2_1
XFILLER_115_478 VGND VGND VPWR VPWR sky130_fd_sc_hd__decap_4
XFILLER_69_521 VGND VGND VPWR VPWR sky130_fd_sc_hd__decap_6
XPHY_EDGE_ROW_47_Left_189 VGND VGND VPWR VPWR sky130_fd_sc_hd__decap_3
X_08882_ net219 net2224 net364 VGND VGND VPWR VPWR _01057_ sky130_fd_sc_hd__mux2_1
X_07902_ net636 _03976_ net684 VGND VGND VPWR VPWR _03986_ sky130_fd_sc_hd__o21a_1
XFILLER_111_651 VGND VGND VPWR VPWR sky130_fd_sc_hd__fill_2
X_07833_ picorv32_core.decoded_imm\[17\] net591 net596 VGND VGND VPWR VPWR _03921_
+ sky130_fd_sc_hd__a21o_1
XFILLER_57_727 VGND VGND VPWR VPWR sky130_fd_sc_hd__fill_1
XPHY_EDGE_ROW_81_Right_81 VGND VGND VPWR VPWR sky130_fd_sc_hd__decap_3
XFILLER_69_598 VGND VGND VPWR VPWR sky130_fd_sc_hd__fill_1
XFILLER_56_215 VGND VGND VPWR VPWR sky130_fd_sc_hd__decap_4
X_07764_ net629 _03854_ VGND VGND VPWR VPWR _03855_ sky130_fd_sc_hd__or2_1
XFILLER_112_48 VGND VGND VPWR VPWR sky130_fd_sc_hd__fill_1
XTAP_TAPCELL_ROW_84_1525 VGND VPWR sky130_fd_sc_hd__tapvpwrvgnd_1
X_09503_ net643 _04687_ VGND VGND VPWR VPWR _04688_ sky130_fd_sc_hd__or2_1
X_06715_ picorv32_core.decoded_imm_j\[2\] _02914_ VGND VGND VPWR VPWR _02949_ sky130_fd_sc_hd__xor2_1
X_07695_ picorv32_core.cpuregs\[16\]\[10\] picorv32_core.cpuregs\[17\]\[10\] picorv32_core.cpuregs\[18\]\[10\]
+ picorv32_core.cpuregs\[19\]\[10\] net736 net703 VGND VGND VPWR VPWR _03790_ sky130_fd_sc_hd__mux4_1
XFILLER_80_752 VGND VGND VPWR VPWR sky130_fd_sc_hd__decap_4
XFILLER_52_421 VGND VGND VPWR VPWR sky130_fd_sc_hd__decap_3
X_06646_ net514 _02911_ VGND VGND VPWR VPWR _02912_ sky130_fd_sc_hd__and2_1
X_09434_ picorv32_core.cpuregs\[20\]\[11\] picorv32_core.cpuregs\[21\]\[11\] picorv32_core.cpuregs\[22\]\[11\]
+ picorv32_core.cpuregs\[23\]\[11\] net878 net845 VGND VGND VPWR VPWR _04622_ sky130_fd_sc_hd__mux4_1
XPHY_EDGE_ROW_56_Left_198 VGND VGND VPWR VPWR sky130_fd_sc_hd__decap_3
XFILLER_24_156 VGND VGND VPWR VPWR sky130_fd_sc_hd__fill_2
X_06577_ picorv32_core.count_instr\[39\] _02864_ picorv32_core.count_instr\[40\] VGND
+ VGND VPWR VPWR _02867_ sky130_fd_sc_hd__a21o_1
X_09365_ picorv32_core.cpuregs\[20\]\[8\] picorv32_core.cpuregs\[21\]\[8\] picorv32_core.cpuregs\[22\]\[8\]
+ picorv32_core.cpuregs\[23\]\[8\] net880 net847 VGND VGND VPWR VPWR _04556_ sky130_fd_sc_hd__mux4_1
X_05528_ _02006_ _02009_ _02019_ VGND VGND VPWR VPWR _02021_ sky130_fd_sc_hd__a21o_1
XANTENNA_41 picorv32_core.mem_rdata_q\[22\] VGND VGND VPWR VPWR sky130_fd_sc_hd__diode_2
XANTENNA_30 _04651_ VGND VGND VPWR VPWR sky130_fd_sc_hd__diode_2
X_08316_ picorv32_core.is_sb_sh_sw _02600_ _04190_ _04231_ VGND VGND VPWR VPWR _00536_
+ sky130_fd_sc_hd__a22o_1
X_09296_ picorv32_core.cpuregs\[12\]\[5\] picorv32_core.cpuregs\[13\]\[5\] picorv32_core.cpuregs\[14\]\[5\]
+ picorv32_core.cpuregs\[15\]\[5\] net875 net842 VGND VGND VPWR VPWR _04490_ sky130_fd_sc_hd__mux4_1
XANTENNA_63 net662 VGND VGND VPWR VPWR sky130_fd_sc_hd__diode_2
XPHY_EDGE_ROW_90_Right_90 VGND VGND VPWR VPWR sky130_fd_sc_hd__decap_3
X_05459_ _01955_ _01956_ VGND VGND VPWR VPWR _01957_ sky130_fd_sc_hd__nor2_1
XANTENNA_74 _03574_ VGND VGND VPWR VPWR sky130_fd_sc_hd__diode_2
XANTENNA_52 net383 VGND VGND VPWR VPWR sky130_fd_sc_hd__diode_2
X_08247_ picorv32_core.mem_rdata_q\[27\] net23 net518 VGND VGND VPWR VPWR _00768_
+ sky130_fd_sc_hd__mux2_1
XANTENNA_85 net347 VGND VGND VPWR VPWR sky130_fd_sc_hd__diode_2
XANTENNA_96 net834 VGND VGND VPWR VPWR sky130_fd_sc_hd__diode_2
X_08178_ net2251 net522 _04193_ net2098 VGND VGND VPWR VPWR _00440_ sky130_fd_sc_hd__a22o_1
XFILLER_4_539 VGND VGND VPWR VPWR sky130_fd_sc_hd__fill_1
XFILLER_134_754 VGND VGND VPWR VPWR sky130_fd_sc_hd__fill_2
XFILLER_133_220 VGND VGND VPWR VPWR sky130_fd_sc_hd__decap_4
XFILLER_97_27 VGND VGND VPWR VPWR sky130_fd_sc_hd__decap_4
XTAP_TAPCELL_ROW_95_1687 VGND VPWR sky130_fd_sc_hd__tapvpwrvgnd_1
XTAP_TAPCELL_ROW_95_1676 VGND VPWR sky130_fd_sc_hd__tapvpwrvgnd_1
X_07129_ picorv32_core.count_cycle\[19\] picorv32_core.count_cycle\[20\] _03309_ VGND
+ VGND VPWR VPWR _03313_ sky130_fd_sc_hd__and3_1
X_10140_ clknet_leaf_44_clk _00062_ VGND VGND VPWR VPWR picorv32_core.cpuregs\[22\]\[23\]
+ sky130_fd_sc_hd__dfxtp_1
XFILLER_106_489 VPWR VGND VPWR VGND sky130_ef_sc_hd__decap_12
XFILLER_79_329 VGND VGND VPWR VPWR sky130_fd_sc_hd__fill_1
Xoutput170 net170 VGND VGND VPWR VPWR pcpi_rs1[7] sky130_fd_sc_hd__buf_2
XFILLER_0_701 VGND VGND VPWR VPWR sky130_fd_sc_hd__fill_2
Xoutput192 net192 VGND VGND VPWR VPWR pcpi_rs2[27] sky130_fd_sc_hd__buf_2
X_10071_ _00741_ _00742_ _00744_ _00743_ VGND VGND VPWR VPWR _05043_ sky130_fd_sc_hd__and4_1
Xoutput181 net181 VGND VGND VPWR VPWR pcpi_rs2[17] sky130_fd_sc_hd__buf_2
XFILLER_0_734 VGND VGND VPWR VPWR sky130_fd_sc_hd__decap_4
XTAP_TAPCELL_ROW_126_2131 VGND VPWR sky130_fd_sc_hd__tapvpwrvgnd_1
XFILLER_101_194 VGND VGND VPWR VPWR sky130_fd_sc_hd__fill_1
XFILLER_90_505 VPWR VGND VPWR VGND sky130_ef_sc_hd__decap_12
XFILLER_75_557 VGND VGND VPWR VPWR sky130_fd_sc_hd__decap_3
XFILLER_63_719 VGND VGND VPWR VPWR sky130_fd_sc_hd__fill_1
X_10973_ clknet_leaf_22_clk _00824_ VGND VGND VPWR VPWR picorv32_core.cpuregs\[13\]\[19\]
+ sky130_fd_sc_hd__dfxtp_1
XFILLER_43_410 VPWR VGND VPWR VGND sky130_ef_sc_hd__decap_12
XFILLER_71_785 VGND VGND VPWR VPWR sky130_fd_sc_hd__decap_8
XFILLER_71_774 VGND VGND VPWR VPWR sky130_fd_sc_hd__fill_2
XFILLER_15_167 VGND VGND VPWR VPWR sky130_fd_sc_hd__fill_1
XTAP_TAPCELL_ROW_26_685 VGND VPWR sky130_fd_sc_hd__tapvpwrvgnd_1
XFILLER_62_85 VGND VGND VPWR VPWR sky130_fd_sc_hd__fill_1
X_11525_ clknet_leaf_141_clk _01356_ VGND VGND VPWR VPWR picorv32_core.cpuregs\[30\]\[6\]
+ sky130_fd_sc_hd__dfxtp_1
XTAP_TAPCELL_ROW_137_2293 VGND VPWR sky130_fd_sc_hd__tapvpwrvgnd_1
XFILLER_7_69 VPWR VGND VPWR VGND sky130_ef_sc_hd__decap_12
X_11456_ clknet_leaf_131_clk _01292_ VGND VGND VPWR VPWR picorv32_core.cpuregs\[24\]\[7\]
+ sky130_fd_sc_hd__dfxtp_1
XFILLER_125_765 VPWR VGND VPWR VGND sky130_ef_sc_hd__decap_12
XTAP_TAPCELL_ROW_55_1104 VGND VPWR sky130_fd_sc_hd__tapvpwrvgnd_1
X_11387_ clknet_leaf_139_clk _01223_ VGND VGND VPWR VPWR picorv32_core.cpuregs\[31\]\[2\]
+ sky130_fd_sc_hd__dfxtp_1
X_10407_ clknet_leaf_125_clk _01547_ VGND VGND VPWR VPWR picorv32_core.reg_out\[0\]
+ sky130_fd_sc_hd__dfxtp_1
XFILLER_140_713 VPWR VGND VPWR VGND sky130_ef_sc_hd__decap_12
XFILLER_124_253 VGND VGND VPWR VPWR sky130_fd_sc_hd__decap_3
XFILLER_112_415 VGND VGND VPWR VPWR sky130_fd_sc_hd__decap_4
X_10338_ clknet_leaf_69_clk _00257_ VGND VGND VPWR VPWR picorv32_core.reg_next_pc\[28\]
+ sky130_fd_sc_hd__dfxtp_1
XFILLER_3_561 VGND VGND VPWR VPWR sky130_fd_sc_hd__fill_1
XFILLER_140_757 VPWR VGND VPWR VGND sky130_ef_sc_hd__decap_12
XFILLER_97_148 VGND VGND VPWR VPWR sky130_fd_sc_hd__fill_1
X_10269_ clknet_leaf_79_clk net2002 VGND VGND VPWR VPWR picorv32_core.count_instr\[53\]
+ sky130_fd_sc_hd__dfxtp_1
XFILLER_39_727 VGND VGND VPWR VPWR sky130_fd_sc_hd__fill_1
XFILLER_78_373 VGND VGND VPWR VPWR sky130_fd_sc_hd__decap_8
X_07480_ net796 _03607_ net533 VGND VGND VPWR VPWR _03608_ sky130_fd_sc_hd__mux2_1
X_06500_ picorv32_core.count_instr\[11\] _02815_ picorv32_core.count_instr\[12\] VGND
+ VGND VPWR VPWR _02818_ sky130_fd_sc_hd__a21o_1
XFILLER_34_421 VPWR VGND VPWR VGND sky130_ef_sc_hd__decap_12
XTAP_TAPCELL_ROW_66_1266 VGND VPWR sky130_fd_sc_hd__tapvpwrvgnd_1
XTAP_TAPCELL_ROW_66_1255 VGND VPWR sky130_fd_sc_hd__tapvpwrvgnd_1
XTAP_TAPCELL_ROW_45_961 VGND VPWR sky130_fd_sc_hd__tapvpwrvgnd_1
X_06431_ net218 net1482 net424 VGND VGND VPWR VPWR _00099_ sky130_fd_sc_hd__mux2_1
X_09150_ net1361 net207 net331 VGND VGND VPWR VPWR _01316_ sky130_fd_sc_hd__mux2_1
X_06362_ _02762_ _02763_ VGND VGND VPWR VPWR _02764_ sky130_fd_sc_hd__nor2_1
X_09081_ net1532 net219 net339 VGND VGND VPWR VPWR _01249_ sky130_fd_sc_hd__mux2_1
X_05313_ picorv32_core.latched_is_lb picorv32_core.latched_is_lh VGND VGND VPWR VPWR
+ _01821_ sky130_fd_sc_hd__or2_1
X_06293_ picorv32_core.reg_pc\[10\] _02701_ picorv32_core.reg_pc\[11\] VGND VGND VPWR
+ VPWR _02708_ sky130_fd_sc_hd__a21oi_1
X_08101_ picorv32_core.latched_is_lh net984 _04170_ _01639_ net2251 VGND VGND VPWR
+ VPWR _00396_ sky130_fd_sc_hd__a32o_1
XFILLER_135_518 VGND VGND VPWR VPWR sky130_fd_sc_hd__fill_2
X_08032_ net193 net511 _04107_ _04108_ VGND VGND VPWR VPWR _00388_ sky130_fd_sc_hd__o22a_1
X_05244_ net23 net820 VGND VGND VPWR VPWR _01757_ sky130_fd_sc_hd__nand2b_1
Xhold801 picorv32_core.cpuregs\[6\]\[20\] VGND VGND VPWR VPWR net1910 sky130_fd_sc_hd__dlygate4sd3_1
Xhold812 picorv32_core.cpuregs\[21\]\[24\] VGND VGND VPWR VPWR net1921 sky130_fd_sc_hd__dlygate4sd3_1
Xhold834 picorv32_core.cpuregs\[25\]\[16\] VGND VGND VPWR VPWR net1943 sky130_fd_sc_hd__dlygate4sd3_1
Xhold823 picorv32_core.cpuregs\[1\]\[11\] VGND VGND VPWR VPWR net1932 sky130_fd_sc_hd__dlygate4sd3_1
Xhold845 picorv32_core.cpuregs\[21\]\[3\] VGND VGND VPWR VPWR net1954 sky130_fd_sc_hd__dlygate4sd3_1
X_05175_ net984 _01630_ VGND VGND VPWR VPWR _01699_ sky130_fd_sc_hd__and2_1
Xhold889 picorv32_core.cpuregs\[2\]\[23\] VGND VGND VPWR VPWR net1998 sky130_fd_sc_hd__dlygate4sd3_1
Xhold856 picorv32_core.cpuregs\[18\]\[20\] VGND VGND VPWR VPWR net1965 sky130_fd_sc_hd__dlygate4sd3_1
XFILLER_107_15 VGND VGND VPWR VPWR sky130_fd_sc_hd__decap_3
XFILLER_88_115 VGND VGND VPWR VPWR sky130_fd_sc_hd__fill_1
Xhold878 picorv32_core.cpuregs\[9\]\[11\] VGND VGND VPWR VPWR net1987 sky130_fd_sc_hd__dlygate4sd3_1
Xhold867 picorv32_core.cpuregs\[1\]\[10\] VGND VGND VPWR VPWR net1976 sky130_fd_sc_hd__dlygate4sd3_1
X_09983_ net1578 net297 net312 VGND VGND VPWR VPWR _01460_ sky130_fd_sc_hd__mux2_1
X_08934_ net273 net2004 net355 VGND VGND VPWR VPWR _01107_ sky130_fd_sc_hd__mux2_1
XFILLER_97_660 VGND VGND VPWR VPWR sky130_fd_sc_hd__decap_8
XFILLER_69_384 VGND VGND VPWR VPWR sky130_fd_sc_hd__fill_1
XFILLER_57_524 VGND VGND VPWR VPWR sky130_fd_sc_hd__decap_8
XTAP_TAPCELL_ROW_4_358 VGND VPWR sky130_fd_sc_hd__tapvpwrvgnd_1
X_08865_ net290 net1629 net362 VGND VGND VPWR VPWR _01040_ sky130_fd_sc_hd__mux2_1
X_07816_ picorv32_core.cpuregs\[20\]\[17\] picorv32_core.cpuregs\[21\]\[17\] picorv32_core.cpuregs\[22\]\[17\]
+ picorv32_core.cpuregs\[23\]\[17\] net747 net714 VGND VGND VPWR VPWR _03904_ sky130_fd_sc_hd__mux4_1
XFILLER_57_557 VGND VGND VPWR VPWR sky130_fd_sc_hd__decap_3
XTAP_TAPCELL_ROW_4_369 VGND VPWR sky130_fd_sc_hd__tapvpwrvgnd_1
X_08796_ net300 net2045 net370 VGND VGND VPWR VPWR _00974_ sky130_fd_sc_hd__mux2_1
XPHY_EDGE_ROW_64_Left_206 VGND VGND VPWR VPWR sky130_fd_sc_hd__decap_3
X_07747_ net957 net513 _03838_ _03839_ VGND VGND VPWR VPWR _00372_ sky130_fd_sc_hd__o22a_1
XFILLER_38_782 VGND VGND VPWR VPWR sky130_fd_sc_hd__decap_3
XFILLER_38_793 VGND VGND VPWR VPWR sky130_fd_sc_hd__decap_3
XFILLER_37_281 VGND VGND VPWR VPWR sky130_fd_sc_hd__decap_3
XTAP_TAPCELL_ROW_121_2061 VGND VPWR sky130_fd_sc_hd__tapvpwrvgnd_1
XFILLER_52_240 VGND VGND VPWR VPWR sky130_fd_sc_hd__fill_1
XPHY_EDGE_ROW_0_Right_0 VGND VGND VPWR VPWR sky130_fd_sc_hd__decap_3
X_07678_ picorv32_core.cpuregs\[0\]\[9\] picorv32_core.cpuregs\[1\]\[9\] picorv32_core.cpuregs\[2\]\[9\]
+ picorv32_core.cpuregs\[3\]\[9\] net731 net698 VGND VGND VPWR VPWR _03774_ sky130_fd_sc_hd__mux4_1
X_06629_ net2272 _02898_ net997 VGND VGND VPWR VPWR _02901_ sky130_fd_sc_hd__o21ai_1
XFILLER_80_593 VPWR VGND VPWR VGND sky130_ef_sc_hd__decap_12
X_09417_ _04601_ _04604_ _04605_ net825 net649 VGND VGND VPWR VPWR _04606_ sky130_fd_sc_hd__a221o_1
XTAP_TAPCELL_ROW_23_633 VGND VPWR sky130_fd_sc_hd__tapvpwrvgnd_1
XTAP_TAPCELL_ROW_23_644 VGND VPWR sky130_fd_sc_hd__tapvpwrvgnd_1
X_09348_ net835 _04538_ net642 VGND VGND VPWR VPWR _04540_ sky130_fd_sc_hd__o21a_1
XTAP_TAPCELL_ROW_97_1716 VGND VPWR sky130_fd_sc_hd__tapvpwrvgnd_1
XTAP_TAPCELL_ROW_97_1705 VGND VPWR sky130_fd_sc_hd__tapvpwrvgnd_1
X_09279_ picorv32_core.cpuregs\[24\]\[4\] picorv32_core.cpuregs\[25\]\[4\] picorv32_core.cpuregs\[26\]\[4\]
+ picorv32_core.cpuregs\[27\]\[4\] net886 net853 VGND VGND VPWR VPWR _04474_ sky130_fd_sc_hd__mux4_1
X_11310_ clknet_leaf_106_clk _00011_ VGND VGND VPWR VPWR picorv32_core.cpu_state\[1\]
+ sky130_fd_sc_hd__dfxtp_1
XFILLER_113_3 VPWR VGND VPWR VGND sky130_ef_sc_hd__decap_12
XFILLER_107_721 VGND VGND VPWR VPWR sky130_fd_sc_hd__decap_6
XPHY_EDGE_ROW_73_Left_215 VGND VGND VPWR VPWR sky130_fd_sc_hd__decap_3
XFILLER_4_325 VGND VGND VPWR VPWR sky130_fd_sc_hd__fill_1
X_11241_ clknet_leaf_68_clk _01092_ VGND VGND VPWR VPWR picorv32_core.cpuregs\[5\]\[31\]
+ sky130_fd_sc_hd__dfxtp_1
XFILLER_106_231 VGND VGND VPWR VPWR sky130_fd_sc_hd__decap_3
X_11172_ clknet_leaf_64_clk _01023_ VGND VGND VPWR VPWR picorv32_core.cpuregs\[7\]\[26\]
+ sky130_fd_sc_hd__dfxtp_1
XFILLER_122_757 VPWR VGND VPWR VGND sky130_ef_sc_hd__decap_12
X_10123_ clknet_leaf_141_clk _00045_ VGND VGND VPWR VPWR picorv32_core.cpuregs\[22\]\[6\]
+ sky130_fd_sc_hd__dfxtp_1
XFILLER_95_608 VGND VGND VPWR VPWR sky130_fd_sc_hd__fill_1
XFILLER_88_660 VGND VGND VPWR VPWR sky130_fd_sc_hd__decap_6
XFILLER_88_693 VGND VGND VPWR VPWR sky130_fd_sc_hd__decap_6
X_10054_ net1630 net270 net305 VGND VGND VPWR VPWR _01529_ sky130_fd_sc_hd__mux2_1
XTAP_TAPCELL_ROW_50_1034 VGND VPWR sky130_fd_sc_hd__tapvpwrvgnd_1
XTAP_TAPCELL_ROW_50_1023 VGND VPWR sky130_fd_sc_hd__tapvpwrvgnd_1
XFILLER_0_586 VGND VGND VPWR VPWR sky130_fd_sc_hd__fill_2
XFILLER_87_192 VGND VGND VPWR VPWR sky130_fd_sc_hd__decap_3
XPHY_EDGE_ROW_82_Left_224 VGND VGND VPWR VPWR sky130_fd_sc_hd__decap_3
XFILLER_36_719 VGND VGND VPWR VPWR sky130_fd_sc_hd__fill_2
XFILLER_91_836 VGND VGND VPWR VPWR sky130_fd_sc_hd__fill_1
XFILLER_63_505 VGND VGND VPWR VPWR sky130_fd_sc_hd__fill_2
XPHY_EDGE_ROW_121_Right_121 VGND VGND VPWR VPWR sky130_fd_sc_hd__decap_3
XTAP_TAPCELL_ROW_106_1845 VGND VPWR sky130_fd_sc_hd__tapvpwrvgnd_1
XFILLER_16_421 VGND VGND VPWR VPWR sky130_fd_sc_hd__fill_1
XFILLER_28_292 VGND VGND VPWR VPWR sky130_fd_sc_hd__decap_6
X_10956_ clknet_leaf_136_clk _00807_ VGND VGND VPWR VPWR picorv32_core.cpuregs\[13\]\[2\]
+ sky130_fd_sc_hd__dfxtp_1
XTAP_TAPCELL_ROW_139_2322 VGND VPWR sky130_fd_sc_hd__tapvpwrvgnd_1
X_10887_ clknet_leaf_67_clk _00738_ VGND VGND VPWR VPWR picorv32_core.cpuregs\[16\]\[31\]
+ sky130_fd_sc_hd__dfxtp_1
XTAP_TAPCELL_ROW_42_920 VGND VPWR sky130_fd_sc_hd__tapvpwrvgnd_1
XPHY_EDGE_ROW_91_Left_233 VGND VGND VPWR VPWR sky130_fd_sc_hd__decap_3
XTAP_TAPCELL_ROW_61_1196 VGND VPWR sky130_fd_sc_hd__tapvpwrvgnd_1
XTAP_TAPCELL_ROW_61_1185 VGND VPWR sky130_fd_sc_hd__tapvpwrvgnd_1
X_11508_ clknet_leaf_60_clk _01344_ VGND VGND VPWR VPWR net158 sky130_fd_sc_hd__dfxtp_1
Xhold108 picorv32_core.cpuregs\[28\]\[3\] VGND VGND VPWR VPWR net1217 sky130_fd_sc_hd__dlygate4sd3_1
Xhold119 picorv32_core.cpuregs\[3\]\[26\] VGND VGND VPWR VPWR net1228 sky130_fd_sc_hd__dlygate4sd3_1
X_11439_ clknet_leaf_30_clk _01275_ VGND VGND VPWR VPWR picorv32_core.cpuregs\[1\]\[22\]
+ sky130_fd_sc_hd__dfxtp_1
XTAP_TAPCELL_ROW_117_1996 VGND VPWR sky130_fd_sc_hd__tapvpwrvgnd_1
X_06980_ _03177_ _03180_ _03192_ VGND VGND VPWR VPWR _03193_ sky130_fd_sc_hd__a21o_1
XFILLER_39_502 VGND VGND VPWR VPWR sky130_fd_sc_hd__fill_2
XFILLER_79_682 VGND VGND VPWR VPWR sky130_fd_sc_hd__decap_3
X_05931_ net178 _02400_ VGND VGND VPWR VPWR _02401_ sky130_fd_sc_hd__xnor2_1
X_08650_ net1204 net218 net393 VGND VGND VPWR VPWR _00801_ sky130_fd_sc_hd__mux2_1
X_05862_ _02329_ _02336_ _02337_ VGND VGND VPWR VPWR _02338_ sky130_fd_sc_hd__a21oi_1
XFILLER_66_365 VGND VGND VPWR VPWR sky130_fd_sc_hd__decap_4
XFILLER_54_527 VGND VGND VPWR VPWR sky130_fd_sc_hd__decap_4
XTAP_TAPCELL_ROW_1_317 VGND VPWR sky130_fd_sc_hd__tapvpwrvgnd_1
X_07601_ picorv32_core.cpuregs\[24\]\[5\] picorv32_core.cpuregs\[25\]\[5\] picorv32_core.cpuregs\[26\]\[5\]
+ picorv32_core.cpuregs\[27\]\[5\] net733 net700 VGND VGND VPWR VPWR _03701_ sky130_fd_sc_hd__mux4_1
XFILLER_66_398 VGND VGND VPWR VPWR sky130_fd_sc_hd__fill_1
X_08581_ axi_adapter.mem_valid net2 _01712_ axi_adapter.ack_awvalid VGND VGND VPWR
+ VPWR _04329_ sky130_fd_sc_hd__a31o_1
X_05793_ _02254_ _02271_ _02274_ VGND VGND VPWR VPWR picorv32_core.alu_out\[2\] sky130_fd_sc_hd__o21a_1
X_07532_ net1493 _03642_ net462 VGND VGND VPWR VPWR _00354_ sky130_fd_sc_hd__mux2_1
XFILLER_35_752 VPWR VGND VPWR VGND sky130_ef_sc_hd__decap_12
X_07463_ net1958 _03596_ net460 VGND VGND VPWR VPWR _00331_ sky130_fd_sc_hd__mux2_1
XFILLER_35_785 VPWR VGND VPWR VGND sky130_ef_sc_hd__decap_12
X_09202_ picorv32_core.reg_pc\[1\] net536 _04394_ net479 VGND VGND VPWR VPWR _04400_
+ sky130_fd_sc_hd__a22o_1
X_06414_ net291 net2188 net422 VGND VGND VPWR VPWR _00082_ sky130_fd_sc_hd__mux2_1
X_07394_ _03404_ _03531_ _03403_ VGND VGND VPWR VPWR _03534_ sky130_fd_sc_hd__a21o_1
X_09133_ net1745 net275 net330 VGND VGND VPWR VPWR _01299_ sky130_fd_sc_hd__mux2_1
XFILLER_136_805 VGND VGND VPWR VPWR sky130_fd_sc_hd__decap_6
X_06345_ picorv32_core.reg_pc\[21\] picorv32_core.reg_pc\[20\] _02742_ VGND VGND VPWR
+ VPWR _02750_ sky130_fd_sc_hd__and3_1
XFILLER_135_326 VGND VGND VPWR VPWR sky130_fd_sc_hd__fill_1
XTAP_TAPCELL_ROW_79_1457 VGND VPWR sky130_fd_sc_hd__tapvpwrvgnd_1
XTAP_TAPCELL_ROW_79_1446 VGND VPWR sky130_fd_sc_hd__tapvpwrvgnd_1
X_06276_ _02691_ _02694_ net563 VGND VGND VPWR VPWR _02695_ sky130_fd_sc_hd__mux2_1
X_09064_ net1321 net292 net336 VGND VGND VPWR VPWR _01232_ sky130_fd_sc_hd__mux2_1
Xhold620 picorv32_core.cpuregs\[1\]\[27\] VGND VGND VPWR VPWR net1729 sky130_fd_sc_hd__dlygate4sd3_1
XFILLER_135_337 VGND VGND VPWR VPWR sky130_fd_sc_hd__decap_4
X_08015_ net637 _04091_ VGND VGND VPWR VPWR _04092_ sky130_fd_sc_hd__or2_1
X_05227_ net13 _01717_ _01722_ net26 _01740_ VGND VGND VPWR VPWR _01741_ sky130_fd_sc_hd__a221o_1
Xhold631 net54 VGND VGND VPWR VPWR net1740 sky130_fd_sc_hd__dlygate4sd3_1
Xhold653 picorv32_core.cpuregs\[17\]\[25\] VGND VGND VPWR VPWR net1762 sky130_fd_sc_hd__dlygate4sd3_1
Xhold642 picorv32_core.cpuregs\[4\]\[29\] VGND VGND VPWR VPWR net1751 sky130_fd_sc_hd__dlygate4sd3_1
XTAP_TAPCELL_ROW_92_1646 VGND VPWR sky130_fd_sc_hd__tapvpwrvgnd_1
XTAP_TAPCELL_ROW_92_1635 VGND VPWR sky130_fd_sc_hd__tapvpwrvgnd_1
XFILLER_78_29 VGND VGND VPWR VPWR sky130_fd_sc_hd__decap_3
XTAP_TAPCELL_ROW_9_439 VGND VPWR sky130_fd_sc_hd__tapvpwrvgnd_1
X_05158_ _01678_ _01681_ _01684_ _01676_ picorv32_core.cpu_state\[5\] VGND VGND VPWR
+ VPWR _00015_ sky130_fd_sc_hd__a32o_1
Xhold697 picorv32_core.cpuregs\[18\]\[25\] VGND VGND VPWR VPWR net1806 sky130_fd_sc_hd__dlygate4sd3_1
Xhold686 picorv32_core.cpuregs\[22\]\[20\] VGND VGND VPWR VPWR net1795 sky130_fd_sc_hd__dlygate4sd3_1
XFILLER_89_435 VGND VGND VPWR VPWR sky130_fd_sc_hd__decap_3
Xhold675 picorv32_core.cpuregs\[7\]\[16\] VGND VGND VPWR VPWR net1784 sky130_fd_sc_hd__dlygate4sd3_1
Xhold664 picorv32_core.cpuregs\[30\]\[12\] VGND VGND VPWR VPWR net1773 sky130_fd_sc_hd__dlygate4sd3_1
X_09966_ net1701 net226 net318 VGND VGND VPWR VPWR _01444_ sky130_fd_sc_hd__mux2_1
XPHY_EDGE_ROW_139_Left_281 VGND VGND VPWR VPWR sky130_fd_sc_hd__decap_3
X_05089_ picorv32_core.instr_slt net1144 picorv32_core.instr_blt VGND VGND VPWR VPWR
+ _00032_ sky130_fd_sc_hd__or3_1
X_08917_ net211 net2108 net361 VGND VGND VPWR VPWR _01091_ sky130_fd_sc_hd__mux2_1
X_09897_ net2313 _05030_ _05032_ _04269_ VGND VGND VPWR VPWR _01382_ sky130_fd_sc_hd__o22a_1
X_08848_ net1725 net222 net368 VGND VGND VPWR VPWR _01024_ sky130_fd_sc_hd__mux2_1
XFILLER_57_332 VGND VGND VPWR VPWR sky130_fd_sc_hd__decap_4
Xclkbuf_leaf_96_clk clknet_4_11_0_clk VGND VGND VPWR VPWR clknet_leaf_96_clk sky130_fd_sc_hd__clkbuf_8
XTAP_TAPCELL_ROW_28_714 VGND VPWR sky130_fd_sc_hd__tapvpwrvgnd_1
XFILLER_45_505 VGND VGND VPWR VPWR sky130_fd_sc_hd__decap_4
X_08779_ net228 net1898 net376 VGND VGND VPWR VPWR _00926_ sky130_fd_sc_hd__mux2_1
XFILLER_26_741 VPWR VGND VPWR VGND sky130_ef_sc_hd__decap_12
X_10810_ clknet_leaf_31_clk _00661_ VGND VGND VPWR VPWR picorv32_core.cpuregs\[15\]\[19\]
+ sky130_fd_sc_hd__dfxtp_1
X_10741_ clknet_leaf_89_clk _00592_ VGND VGND VPWR VPWR picorv32_core.decoded_imm\[18\]
+ sky130_fd_sc_hd__dfxtp_2
XTAP_TAPCELL_ROW_101_1775 VGND VPWR sky130_fd_sc_hd__tapvpwrvgnd_1
XTAP_TAPCELL_ROW_101_1764 VGND VPWR sky130_fd_sc_hd__tapvpwrvgnd_1
X_10672_ clknet_leaf_84_clk _00526_ VGND VGND VPWR VPWR picorv32_core.decoded_imm_j\[18\]
+ sky130_fd_sc_hd__dfxtp_1
XFILLER_41_799 VGND VGND VPWR VPWR sky130_fd_sc_hd__fill_2
XFILLER_43_76 VGND VGND VPWR VPWR sky130_fd_sc_hd__fill_1
Xclkbuf_leaf_20_clk clknet_4_6_0_clk VGND VGND VPWR VPWR clknet_leaf_20_clk sky130_fd_sc_hd__clkbuf_8
XTAP_TAPCELL_ROW_134_2252 VGND VPWR sky130_fd_sc_hd__tapvpwrvgnd_1
XTAP_TAPCELL_ROW_134_2241 VGND VPWR sky130_fd_sc_hd__tapvpwrvgnd_1
Xpicorv32_axi_1030 VGND VGND VPWR VPWR picorv32_axi_1030/HI eoi[31] sky130_fd_sc_hd__conb_1
Xpicorv32_axi_1063 VGND VGND VPWR VPWR picorv32_axi_1063/HI pcpi_insn[23] sky130_fd_sc_hd__conb_1
Xpicorv32_axi_1041 VGND VGND VPWR VPWR picorv32_axi_1041/HI pcpi_insn[1] sky130_fd_sc_hd__conb_1
XFILLER_138_197 VGND VGND VPWR VPWR sky130_fd_sc_hd__decap_3
XFILLER_4_133 VGND VGND VPWR VPWR sky130_fd_sc_hd__decap_6
Xpicorv32_axi_1052 VGND VGND VPWR VPWR picorv32_axi_1052/HI pcpi_insn[12] sky130_fd_sc_hd__conb_1
Xpicorv32_axi_1074 VGND VGND VPWR VPWR picorv32_axi_1074/HI trace_data[1] sky130_fd_sc_hd__conb_1
X_11224_ clknet_leaf_26_clk _01075_ VGND VGND VPWR VPWR picorv32_core.cpuregs\[5\]\[14\]
+ sky130_fd_sc_hd__dfxtp_1
Xpicorv32_axi_1085 VGND VGND VPWR VPWR picorv32_axi_1085/HI trace_data[12] sky130_fd_sc_hd__conb_1
Xpicorv32_axi_1096 VGND VGND VPWR VPWR picorv32_axi_1096/HI trace_data[23] sky130_fd_sc_hd__conb_1
XFILLER_4_177 VPWR VGND VPWR VGND sky130_ef_sc_hd__decap_12
XFILLER_4_26 VGND VGND VPWR VPWR sky130_fd_sc_hd__fill_2
X_11155_ clknet_leaf_144_clk _01006_ VGND VGND VPWR VPWR picorv32_core.cpuregs\[7\]\[9\]
+ sky130_fd_sc_hd__dfxtp_1
X_10106_ net1128 VGND VGND VPWR VPWR _00956_ sky130_fd_sc_hd__clkbuf_1
X_11086_ clknet_leaf_109_clk _00937_ VGND VGND VPWR VPWR picorv32_core.cpuregs\[0\]\[4\]
+ sky130_fd_sc_hd__dfxtp_1
X_10037_ net1636 net207 net311 VGND VGND VPWR VPWR _01513_ sky130_fd_sc_hd__mux2_1
Xclkbuf_leaf_87_clk clknet_4_12_0_clk VGND VGND VPWR VPWR clknet_leaf_87_clk sky130_fd_sc_hd__clkbuf_8
XFILLER_48_365 VGND VGND VPWR VPWR sky130_fd_sc_hd__decap_6
XFILLER_17_741 VPWR VGND VPWR VGND sky130_ef_sc_hd__decap_12
XFILLER_29_590 VGND VGND VPWR VPWR sky130_fd_sc_hd__decap_8
X_10939_ clknet_leaf_26_clk _00790_ VGND VGND VPWR VPWR picorv32_core.cpuregs\[19\]\[17\]
+ sky130_fd_sc_hd__dfxtp_1
XTAP_TAPCELL_ROW_63_1225 VGND VPWR sky130_fd_sc_hd__tapvpwrvgnd_1
XTAP_TAPCELL_ROW_63_1214 VGND VPWR sky130_fd_sc_hd__tapvpwrvgnd_1
XFILLER_17_785 VPWR VGND VPWR VGND sky130_ef_sc_hd__decap_12
XFILLER_71_390 VGND VGND VPWR VPWR sky130_fd_sc_hd__fill_2
XFILLER_32_799 VPWR VGND VPWR VGND sky130_ef_sc_hd__decap_12
XFILLER_118_805 VGND VGND VPWR VPWR sky130_fd_sc_hd__decap_6
XFILLER_76_3 VGND VGND VPWR VPWR sky130_fd_sc_hd__decap_3
Xclkbuf_leaf_11_clk clknet_4_1_0_clk VGND VGND VPWR VPWR clknet_leaf_11_clk sky130_fd_sc_hd__clkbuf_8
X_06130_ net508 _02583_ _02584_ _02575_ VGND VGND VPWR VPWR picorv32_core.alu_out\[29\]
+ sky130_fd_sc_hd__a31o_1
XFILLER_117_337 VGND VGND VPWR VPWR sky130_fd_sc_hd__fill_2
X_06061_ _02497_ _02502_ _02510_ VGND VGND VPWR VPWR _02521_ sky130_fd_sc_hd__a21oi_1
XFILLER_132_318 VGND VGND VPWR VPWR sky130_fd_sc_hd__decap_4
X_09820_ _04988_ _04989_ VGND VGND VPWR VPWR _04990_ sky130_fd_sc_hd__nor2_1
XTAP_TAPCELL_ROW_74_1376 VGND VPWR sky130_fd_sc_hd__tapvpwrvgnd_1
Xfanout407 _04323_ VGND VGND VPWR VPWR net407 sky130_fd_sc_hd__buf_4
Xfanout429 net430 VGND VGND VPWR VPWR net429 sky130_fd_sc_hd__clkbuf_2
Xfanout418 net421 VGND VGND VPWR VPWR net418 sky130_fd_sc_hd__clkbuf_8
X_09751_ net770 net280 VGND VGND VPWR VPWR _04924_ sky130_fd_sc_hd__and2_1
X_06963_ net934 _02934_ VGND VGND VPWR VPWR _03177_ sky130_fd_sc_hd__nand2_1
XFILLER_104_27 VGND VGND VPWR VPWR sky130_fd_sc_hd__fill_1
Xclkbuf_leaf_78_clk clknet_4_15_0_clk VGND VGND VPWR VPWR clknet_leaf_78_clk sky130_fd_sc_hd__clkbuf_8
X_08702_ net1722 net274 net384 VGND VGND VPWR VPWR _00851_ sky130_fd_sc_hd__mux2_1
X_05914_ _02192_ net572 net607 VGND VGND VPWR VPWR _02386_ sky130_fd_sc_hd__a21o_1
X_09682_ _04850_ _04851_ _04854_ _04855_ net658 net645 VGND VGND VPWR VPWR _04859_
+ sky130_fd_sc_hd__mux4_1
XFILLER_94_471 VGND VGND VPWR VPWR sky130_fd_sc_hd__decap_4
X_06894_ _03109_ _03110_ _03113_ VGND VGND VPWR VPWR _03114_ sky130_fd_sc_hd__o21ai_1
XFILLER_66_162 VGND VGND VPWR VPWR sky130_fd_sc_hd__fill_1
XFILLER_55_836 VGND VGND VPWR VPWR sky130_fd_sc_hd__fill_1
XFILLER_27_505 VGND VGND VPWR VPWR sky130_fd_sc_hd__fill_2
XFILLER_66_195 VGND VGND VPWR VPWR sky130_fd_sc_hd__fill_1
X_05845_ net807 _02320_ VGND VGND VPWR VPWR _02322_ sky130_fd_sc_hd__or2_1
X_08633_ net1463 net290 net390 VGND VGND VPWR VPWR _00784_ sky130_fd_sc_hd__mux2_1
X_08564_ net271 net2136 net400 VGND VGND VPWR VPWR _00689_ sky130_fd_sc_hd__mux2_1
X_05776_ _02258_ net819 VGND VGND VPWR VPWR _02259_ sky130_fd_sc_hd__and2b_1
XFILLER_120_15 VPWR VGND VPWR VGND sky130_ef_sc_hd__decap_12
X_07515_ picorv32_core.reg_out\[25\] picorv32_core.reg_next_pc\[25\] net561 VGND VGND
+ VPWR VPWR _03631_ sky130_fd_sc_hd__mux2_1
X_08495_ net1767 net268 net406 VGND VGND VPWR VPWR _00625_ sky130_fd_sc_hd__mux2_1
XFILLER_50_530 VGND VGND VPWR VPWR sky130_fd_sc_hd__fill_2
XFILLER_23_777 VGND VGND VPWR VPWR sky130_fd_sc_hd__decap_6
X_07446_ _03582_ _03584_ VGND VGND VPWR VPWR _03585_ sky130_fd_sc_hd__and2_1
X_07377_ _03416_ _03419_ _03514_ _03418_ _03415_ VGND VGND VPWR VPWR _03517_ sky130_fd_sc_hd__a311o_1
XFILLER_13_57 VPWR VGND VPWR VGND sky130_ef_sc_hd__decap_12
XTAP_TAPCELL_ROW_33_783 VGND VPWR sky130_fd_sc_hd__tapvpwrvgnd_1
X_09116_ net211 net2153 net335 VGND VGND VPWR VPWR _01283_ sky130_fd_sc_hd__mux2_1
XFILLER_129_57 VPWR VGND VPWR VGND sky130_ef_sc_hd__decap_12
X_06328_ net1329 net260 net434 VGND VGND VPWR VPWR _00056_ sky130_fd_sc_hd__mux2_1
X_09047_ net222 net2164 net342 VGND VGND VPWR VPWR _01216_ sky130_fd_sc_hd__mux2_1
XFILLER_135_167 VGND VGND VPWR VPWR sky130_fd_sc_hd__fill_1
XFILLER_2_615 VPWR VGND VPWR VGND sky130_ef_sc_hd__decap_12
X_06259_ _02679_ _02680_ VGND VGND VPWR VPWR _02681_ sky130_fd_sc_hd__nor2_1
Xhold461 picorv32_core.cpuregs\[31\]\[31\] VGND VGND VPWR VPWR net1570 sky130_fd_sc_hd__dlygate4sd3_1
Xhold450 picorv32_core.cpuregs\[14\]\[18\] VGND VGND VPWR VPWR net1559 sky130_fd_sc_hd__dlygate4sd3_1
XFILLER_1_125 VPWR VGND VPWR VGND sky130_ef_sc_hd__decap_12
Xhold472 picorv32_core.cpuregs\[21\]\[5\] VGND VGND VPWR VPWR net1581 sky130_fd_sc_hd__dlygate4sd3_1
Xhold494 picorv32_core.cpuregs\[31\]\[0\] VGND VGND VPWR VPWR net1603 sky130_fd_sc_hd__dlygate4sd3_1
Xhold483 picorv32_core.cpuregs\[10\]\[1\] VGND VGND VPWR VPWR net1592 sky130_fd_sc_hd__dlygate4sd3_1
Xfanout941 net942 VGND VGND VPWR VPWR net941 sky130_fd_sc_hd__buf_2
Xfanout952 picorv32_core.latched_stalu VGND VGND VPWR VPWR net952 sky130_fd_sc_hd__clkbuf_4
Xfanout930 picorv32_core.mem_rdata_q\[12\] VGND VGND VPWR VPWR net930 sky130_fd_sc_hd__buf_2
XFILLER_1_169 VPWR VGND VPWR VGND sky130_ef_sc_hd__decap_12
X_09949_ net1393 net299 net316 VGND VGND VPWR VPWR _01427_ sky130_fd_sc_hd__mux2_1
XFILLER_38_10 VPWR VGND VPWR VGND sky130_ef_sc_hd__decap_12
Xclkbuf_leaf_69_clk clknet_4_13_0_clk VGND VGND VPWR VPWR clknet_leaf_69_clk sky130_fd_sc_hd__clkbuf_8
XFILLER_77_449 VGND VGND VPWR VPWR sky130_fd_sc_hd__decap_8
Xfanout974 net975 VGND VGND VPWR VPWR net974 sky130_fd_sc_hd__buf_2
Xfanout985 net986 VGND VGND VPWR VPWR net985 sky130_fd_sc_hd__clkbuf_2
Xfanout963 picorv32_core.mem_la_wdata\[6\] VGND VGND VPWR VPWR net963 sky130_fd_sc_hd__clkbuf_4
Xfanout996 net998 VGND VGND VPWR VPWR net996 sky130_fd_sc_hd__buf_2
Xhold1150 picorv32_core.count_cycle\[27\] VGND VGND VPWR VPWR net2259 sky130_fd_sc_hd__dlygate4sd3_1
XFILLER_85_460 VGND VGND VPWR VPWR sky130_fd_sc_hd__decap_6
Xhold1194 picorv32_core.mem_rdata_q\[18\] VGND VGND VPWR VPWR net2303 sky130_fd_sc_hd__dlygate4sd3_1
Xhold1183 picorv32_core.count_cycle\[1\] VGND VGND VPWR VPWR net2292 sky130_fd_sc_hd__dlygate4sd3_1
Xhold1172 picorv32_core.count_cycle\[3\] VGND VGND VPWR VPWR net2281 sky130_fd_sc_hd__dlygate4sd3_1
Xhold1161 picorv32_core.count_cycle\[36\] VGND VGND VPWR VPWR net2270 sky130_fd_sc_hd__dlygate4sd3_1
X_11842_ net45 VGND VGND VPWR VPWR net77 sky130_fd_sc_hd__clkbuf_1
XFILLER_73_655 VGND VGND VPWR VPWR sky130_fd_sc_hd__fill_2
XTAP_TAPCELL_ROW_103_1804 VGND VPWR sky130_fd_sc_hd__tapvpwrvgnd_1
XFILLER_14_755 VGND VGND VPWR VPWR sky130_fd_sc_hd__fill_1
X_10724_ clknet_leaf_108_clk _00575_ VGND VGND VPWR VPWR net137 sky130_fd_sc_hd__dfxtp_1
X_10655_ clknet_leaf_45_clk _00509_ VGND VGND VPWR VPWR picorv32_core.cpuregs\[20\]\[23\]
+ sky130_fd_sc_hd__dfxtp_1
XFILLER_70_85 VGND VGND VPWR VPWR sky130_fd_sc_hd__decap_3
Xclkload17 clknet_leaf_142_clk VGND VGND VPWR VPWR clkload17/Y sky130_fd_sc_hd__inv_12
XFILLER_9_269 VGND VGND VPWR VPWR sky130_fd_sc_hd__decap_3
XFILLER_127_668 VGND VGND VPWR VPWR sky130_fd_sc_hd__decap_4
Xclkload39 clknet_leaf_14_clk VGND VGND VPWR VPWR clkload39/Y sky130_fd_sc_hd__bufinv_16
X_10586_ clknet_leaf_96_clk _00440_ VGND VGND VPWR VPWR picorv32_core.instr_lh sky130_fd_sc_hd__dfxtp_1
Xclkload28 clknet_leaf_11_clk VGND VGND VPWR VPWR clkload28/Y sky130_fd_sc_hd__clkinv_8
XTAP_TAPCELL_ROW_11_466 VGND VPWR sky130_fd_sc_hd__tapvpwrvgnd_1
XFILLER_141_137 VGND VGND VPWR VPWR sky130_fd_sc_hd__decap_3
XTAP_TAPCELL_ROW_114_1955 VGND VPWR sky130_fd_sc_hd__tapvpwrvgnd_1
X_11207_ clknet_leaf_71_clk _01058_ VGND VGND VPWR VPWR picorv32_core.cpuregs\[6\]\[29\]
+ sky130_fd_sc_hd__dfxtp_1
XFILLER_122_340 VGND VGND VPWR VPWR sky130_fd_sc_hd__fill_2
X_11138_ clknet_leaf_39_clk _00989_ VGND VGND VPWR VPWR picorv32_core.cpuregs\[8\]\[24\]
+ sky130_fd_sc_hd__dfxtp_1
X_11069_ clknet_leaf_31_clk _00920_ VGND VGND VPWR VPWR picorv32_core.cpuregs\[10\]\[19\]
+ sky130_fd_sc_hd__dfxtp_1
Xclkbuf_leaf_0_clk clknet_4_0_0_clk VGND VGND VPWR VPWR clknet_leaf_0_clk sky130_fd_sc_hd__clkbuf_8
XFILLER_48_162 VGND VGND VPWR VPWR sky130_fd_sc_hd__fill_2
X_05630_ _02113_ _02114_ VGND VGND VPWR VPWR _02115_ sky130_fd_sc_hd__xnor2_1
XFILLER_64_699 VGND VGND VPWR VPWR sky130_fd_sc_hd__fill_1
XTAP_TAPCELL_ROW_19_577 VGND VPWR sky130_fd_sc_hd__tapvpwrvgnd_1
X_05561_ net912 net302 _02047_ _02051_ VGND VGND VPWR VPWR _02052_ sky130_fd_sc_hd__a31o_1
X_07300_ _03434_ _03435_ _03439_ VGND VGND VPWR VPWR _03440_ sky130_fd_sc_hd__or3_1
X_08280_ net1640 net258 net412 VGND VGND VPWR VPWR _00504_ sky130_fd_sc_hd__mux2_1
X_05492_ picorv32_core.count_instr\[52\] net938 net942 picorv32_core.count_instr\[20\]
+ VGND VGND VPWR VPWR _01988_ sky130_fd_sc_hd__a22o_1
X_07231_ picorv32_core.count_cycle\[58\] _03375_ net977 VGND VGND VPWR VPWR _03377_
+ sky130_fd_sc_hd__a21oi_1
XFILLER_118_613 VGND VGND VPWR VPWR sky130_fd_sc_hd__decap_6
XFILLER_20_769 VPWR VGND VPWR VGND sky130_ef_sc_hd__decap_12
XTAP_TAPCELL_ROW_30_742 VGND VPWR sky130_fd_sc_hd__tapvpwrvgnd_1
X_07162_ _03333_ net984 _03332_ VGND VGND VPWR VPWR _00293_ sky130_fd_sc_hd__and3b_1
X_06113_ net766 _02568_ VGND VGND VPWR VPWR _02569_ sky130_fd_sc_hd__and2_1
XTAP_TAPCELL_ROW_76_1405 VGND VPWR sky130_fd_sc_hd__tapvpwrvgnd_1
X_07093_ _03289_ _03290_ VGND VGND VPWR VPWR _00267_ sky130_fd_sc_hd__nor2_1
X_06044_ _02173_ _02504_ _02505_ VGND VGND VPWR VPWR _02506_ sky130_fd_sc_hd__a21o_1
XFILLER_141_671 VGND VGND VPWR VPWR sky130_fd_sc_hd__fill_1
Xfanout215 net216 VGND VGND VPWR VPWR net215 sky130_fd_sc_hd__dlymetal6s2s_1
Xfanout226 net227 VGND VGND VPWR VPWR net226 sky130_fd_sc_hd__clkbuf_2
Xfanout237 _02760_ VGND VGND VPWR VPWR net237 sky130_fd_sc_hd__clkbuf_2
XFILLER_115_15 VGND VGND VPWR VPWR sky130_fd_sc_hd__decap_8
X_09803_ _04967_ _04968_ _04973_ net487 VGND VGND VPWR VPWR _04974_ sky130_fd_sc_hd__a211o_1
X_07995_ _04072_ _04073_ net459 _04070_ VGND VGND VPWR VPWR _04074_ sky130_fd_sc_hd__o211a_1
Xfanout248 net250 VGND VGND VPWR VPWR net248 sky130_fd_sc_hd__clkbuf_2
Xfanout259 net260 VGND VGND VPWR VPWR net259 sky130_fd_sc_hd__clkbuf_2
X_09734_ net774 net542 _04845_ net470 VGND VGND VPWR VPWR _04908_ sky130_fd_sc_hd__o211a_1
X_06946_ net589 _03160_ _03161_ VGND VGND VPWR VPWR _03162_ sky130_fd_sc_hd__a21o_1
XFILLER_28_825 VGND VGND VPWR VPWR sky130_fd_sc_hd__decap_4
X_09665_ net285 _04827_ _04842_ _04822_ VGND VGND VPWR VPWR _01340_ sky130_fd_sc_hd__a31o_1
X_06877_ _03074_ _03096_ _03097_ VGND VGND VPWR VPWR _03098_ sky130_fd_sc_hd__a21oi_1
XTAP_TAPCELL_ROW_87_1567 VGND VPWR sky130_fd_sc_hd__tapvpwrvgnd_1
XFILLER_82_463 VGND VGND VPWR VPWR sky130_fd_sc_hd__fill_1
X_08616_ _01588_ axi_adapter.xfer_done net983 VGND VGND VPWR VPWR _04331_ sky130_fd_sc_hd__o21ai_1
XTAP_TAPCELL_ROW_38_853 VGND VPWR sky130_fd_sc_hd__tapvpwrvgnd_1
X_05828_ _02124_ net572 net606 VGND VGND VPWR VPWR _02306_ sky130_fd_sc_hd__a21o_1
XFILLER_131_69 VPWR VGND VPWR VGND sky130_ef_sc_hd__decap_12
X_09596_ _04767_ _04775_ _04776_ net645 net650 VGND VGND VPWR VPWR _04777_ sky130_fd_sc_hd__a221o_1
XFILLER_55_699 VGND VGND VPWR VPWR sky130_fd_sc_hd__decap_6
X_05759_ _02203_ _02240_ _02242_ _02241_ _01581_ VGND VGND VPWR VPWR _02243_ sky130_fd_sc_hd__a32o_1
X_08547_ net948 net949 net947 VGND VGND VPWR VPWR _04327_ sky130_fd_sc_hd__or3b_2
X_08478_ net947 net948 net949 VGND VGND VPWR VPWR _04322_ sky130_fd_sc_hd__nand3b_2
X_07429_ picorv32_core.cpuregs\[16\]\[31\] picorv32_core.cpuregs\[17\]\[31\] picorv32_core.cpuregs\[18\]\[31\]
+ picorv32_core.cpuregs\[19\]\[31\] net904 net869 VGND VGND VPWR VPWR _03569_ sky130_fd_sc_hd__mux4_1
XTAP_TAPCELL_ROW_118_2022 VGND VPWR sky130_fd_sc_hd__tapvpwrvgnd_1
XTAP_TAPCELL_ROW_118_2011 VGND VPWR sky130_fd_sc_hd__tapvpwrvgnd_1
XFILLER_10_213 VGND VGND VPWR VPWR sky130_fd_sc_hd__fill_2
XFILLER_7_729 VPWR VGND VPWR VGND sky130_ef_sc_hd__decap_12
X_10440_ clknet_leaf_115_clk _00327_ VGND VGND VPWR VPWR net62 sky130_fd_sc_hd__dfxtp_1
XFILLER_40_11 VGND VGND VPWR VPWR sky130_fd_sc_hd__fill_1
XTAP_TAPCELL_ROW_131_2200 VGND VPWR sky130_fd_sc_hd__tapvpwrvgnd_1
XFILLER_40_33 VGND VGND VPWR VPWR sky130_fd_sc_hd__fill_1
XTAP_TAPCELL_ROW_131_2211 VGND VPWR sky130_fd_sc_hd__tapvpwrvgnd_1
X_10371_ clknet_leaf_76_clk _00290_ VGND VGND VPWR VPWR picorv32_core.count_cycle\[29\]
+ sky130_fd_sc_hd__dfxtp_1
Xhold280 picorv32_core.cpuregs\[26\]\[30\] VGND VGND VPWR VPWR net1389 sky130_fd_sc_hd__dlygate4sd3_1
Xhold291 picorv32_core.cpuregs\[9\]\[28\] VGND VGND VPWR VPWR net1400 sky130_fd_sc_hd__dlygate4sd3_1
XFILLER_120_811 VGND VGND VPWR VPWR sky130_fd_sc_hd__fill_1
XFILLER_131_181 VGND VGND VPWR VPWR sky130_fd_sc_hd__fill_2
Xfanout760 net763 VGND VGND VPWR VPWR net760 sky130_fd_sc_hd__clkbuf_4
XFILLER_104_384 VGND VGND VPWR VPWR sky130_fd_sc_hd__fill_2
XTAP_TAPCELL_ROW_129_2173 VGND VPWR sky130_fd_sc_hd__tapvpwrvgnd_1
Xfanout771 net158 VGND VGND VPWR VPWR net771 sky130_fd_sc_hd__clkbuf_4
Xfanout782 net153 VGND VGND VPWR VPWR net782 sky130_fd_sc_hd__buf_2
Xfanout793 net794 VGND VGND VPWR VPWR net793 sky130_fd_sc_hd__buf_2
XFILLER_92_249 VGND VGND VPWR VPWR sky130_fd_sc_hd__decap_3
XFILLER_73_441 VGND VGND VPWR VPWR sky130_fd_sc_hd__decap_6
XFILLER_73_430 VGND VGND VPWR VPWR sky130_fd_sc_hd__fill_2
XFILLER_61_614 VGND VGND VPWR VPWR sky130_fd_sc_hd__fill_2
XTAP_TAPCELL_ROW_16_536 VGND VPWR sky130_fd_sc_hd__tapvpwrvgnd_1
XFILLER_14_574 VGND VGND VPWR VPWR sky130_fd_sc_hd__decap_4
X_10707_ clknet_leaf_6_clk _00558_ VGND VGND VPWR VPWR net112 sky130_fd_sc_hd__dfxtp_1
XFILLER_41_393 VPWR VGND VPWR VGND sky130_ef_sc_hd__decap_12
X_11687_ clknet_leaf_113_clk _01518_ VGND VGND VPWR VPWR picorv32_core.cpuregs\[27\]\[4\]
+ sky130_fd_sc_hd__dfxtp_1
XFILLER_127_443 VGND VGND VPWR VPWR sky130_fd_sc_hd__decap_4
Xclkload128 clknet_leaf_79_clk VGND VGND VPWR VPWR clkload128/X sky130_fd_sc_hd__clkbuf_8
Xclkload117 clknet_leaf_87_clk VGND VGND VPWR VPWR clkload117/Y sky130_fd_sc_hd__inv_6
Xclkload106 clknet_leaf_98_clk VGND VGND VPWR VPWR clkload106/X sky130_fd_sc_hd__clkbuf_8
X_10638_ clknet_leaf_141_clk _00492_ VGND VGND VPWR VPWR picorv32_core.cpuregs\[20\]\[6\]
+ sky130_fd_sc_hd__dfxtp_1
X_10569_ clknet_leaf_70_clk _00423_ VGND VGND VPWR VPWR picorv32_core.cpuregs\[25\]\[25\]
+ sky130_fd_sc_hd__dfxtp_1
Xclkload139 clknet_leaf_74_clk VGND VGND VPWR VPWR clkload139/Y sky130_fd_sc_hd__inv_8
XTAP_TAPCELL_ROW_58_1146 VGND VPWR sky130_fd_sc_hd__tapvpwrvgnd_1
XFILLER_123_660 VGND VGND VPWR VPWR sky130_fd_sc_hd__decap_3
XTAP_TAPCELL_ROW_71_1335 VGND VPWR sky130_fd_sc_hd__tapvpwrvgnd_1
XFILLER_96_544 VGND VGND VPWR VPWR sky130_fd_sc_hd__decap_8
XFILLER_96_533 VGND VGND VPWR VPWR sky130_fd_sc_hd__fill_2
X_07780_ picorv32_core.decoded_imm\[14\] net591 net596 VGND VGND VPWR VPWR _03871_
+ sky130_fd_sc_hd__a21o_1
X_06800_ _03023_ _03026_ VGND VGND VPWR VPWR _03027_ sky130_fd_sc_hd__nand2_1
XFILLER_56_419 VGND VGND VPWR VPWR sky130_fd_sc_hd__fill_1
XFILLER_49_493 VGND VGND VPWR VPWR sky130_fd_sc_hd__fill_2
X_06731_ _02956_ _02957_ _02954_ VGND VGND VPWR VPWR _02963_ sky130_fd_sc_hd__a21oi_1
Xinput4 mem_axi_rdata[0] VGND VGND VPWR VPWR net4 sky130_fd_sc_hd__buf_1
X_09450_ net612 _04633_ _04635_ _04636_ net488 VGND VGND VPWR VPWR _04637_ sky130_fd_sc_hd__a2111o_1
X_06662_ picorv32_core.reg_pc\[8\] net551 _02920_ net514 VGND VGND VPWR VPWR _00206_
+ sky130_fd_sc_hd__a22o_1
X_08401_ net1608 net461 _04277_ _03583_ VGND VGND VPWR VPWR _00577_ sky130_fd_sc_hd__o22a_1
XTAP_TAPCELL_ROW_35_812 VGND VPWR sky130_fd_sc_hd__tapvpwrvgnd_1
X_05613_ net579 _02098_ _02099_ net162 net916 VGND VGND VPWR VPWR _02100_ sky130_fd_sc_hd__a32o_1
X_06593_ picorv32_core.count_instr\[45\] _02874_ picorv32_core.count_instr\[46\] VGND
+ VGND VPWR VPWR _02877_ sky130_fd_sc_hd__a21o_1
X_09381_ net795 net548 VGND VGND VPWR VPWR _04571_ sky130_fd_sc_hd__or2_1
XFILLER_51_113 VGND VGND VPWR VPWR sky130_fd_sc_hd__fill_2
X_05544_ net20 net583 net574 VGND VGND VPWR VPWR _02036_ sky130_fd_sc_hd__a21o_1
X_08332_ net928 net969 net960 net927 VGND VGND VPWR VPWR _04237_ sky130_fd_sc_hd__a22o_1
XTAP_TAPCELL_ROW_82_1497 VGND VPWR sky130_fd_sc_hd__tapvpwrvgnd_1
X_08263_ net1620 net499 net411 VGND VGND VPWR VPWR _00487_ sky130_fd_sc_hd__mux2_1
X_07214_ _03365_ _03366_ VGND VGND VPWR VPWR _00312_ sky130_fd_sc_hd__nor2_1
X_05475_ net14 net584 net575 VGND VGND VPWR VPWR _01972_ sky130_fd_sc_hd__a21o_1
XFILLER_118_421 VPWR VGND VPWR VGND sky130_ef_sc_hd__decap_12
X_08194_ net1865 net475 _04189_ _04199_ VGND VGND VPWR VPWR _00449_ sky130_fd_sc_hd__a22o_1
X_07145_ picorv32_core.count_cycle\[25\] picorv32_core.count_cycle\[26\] _03319_ VGND
+ VGND VPWR VPWR _03323_ sky130_fd_sc_hd__and3_1
X_07076_ net995 _03280_ VGND VGND VPWR VPWR _00260_ sky130_fd_sc_hd__and2_1
X_06027_ _02472_ _02480_ VGND VGND VPWR VPWR _02490_ sky130_fd_sc_hd__and2_1
XFILLER_133_479 VGND VGND VPWR VPWR sky130_fd_sc_hd__fill_1
XFILLER_102_811 VGND VGND VPWR VPWR sky130_fd_sc_hd__fill_1
XFILLER_101_310 VGND VGND VPWR VPWR sky130_fd_sc_hd__fill_1
X_07978_ net190 net511 _04057_ VGND VGND VPWR VPWR _00385_ sky130_fd_sc_hd__o21a_1
X_09717_ picorv32_core.cpuregs\[20\]\[24\] picorv32_core.cpuregs\[21\]\[24\] picorv32_core.cpuregs\[22\]\[24\]
+ picorv32_core.cpuregs\[23\]\[24\] net894 net860 VGND VGND VPWR VPWR _04892_ sky130_fd_sc_hd__mux4_1
X_06929_ _03143_ _03145_ VGND VGND VPWR VPWR _03146_ sky130_fd_sc_hd__and2_1
XFILLER_28_633 VGND VGND VPWR VPWR sky130_fd_sc_hd__decap_4
X_09648_ net472 _04760_ _04824_ _04825_ VGND VGND VPWR VPWR _04826_ sky130_fd_sc_hd__a31o_1
X_09579_ net788 net544 VGND VGND VPWR VPWR _04760_ sky130_fd_sc_hd__or2_1
XFILLER_31_809 VGND VGND VPWR VPWR sky130_fd_sc_hd__decap_3
X_11610_ clknet_leaf_44_clk _01441_ VGND VGND VPWR VPWR picorv32_core.cpuregs\[23\]\[23\]
+ sky130_fd_sc_hd__dfxtp_1
X_11541_ clknet_leaf_32_clk _01372_ VGND VGND VPWR VPWR picorv32_core.cpuregs\[30\]\[22\]
+ sky130_fd_sc_hd__dfxtp_1
XFILLER_70_499 VGND VGND VPWR VPWR sky130_fd_sc_hd__fill_1
XFILLER_51_691 VGND VGND VPWR VPWR sky130_fd_sc_hd__decap_3
XFILLER_137_741 VPWR VGND VPWR VGND sky130_ef_sc_hd__decap_12
X_11472_ clknet_leaf_46_clk _01308_ VGND VGND VPWR VPWR picorv32_core.cpuregs\[24\]\[23\]
+ sky130_fd_sc_hd__dfxtp_1
XFILLER_109_465 VGND VGND VPWR VPWR sky130_fd_sc_hd__decap_3
X_10423_ clknet_leaf_83_clk _01554_ VGND VGND VPWR VPWR picorv32_core.reg_out\[16\]
+ sky130_fd_sc_hd__dfxtp_1
XFILLER_137_785 VPWR VGND VPWR VGND sky130_ef_sc_hd__decap_12
X_10354_ clknet_leaf_99_clk _00273_ VGND VGND VPWR VPWR picorv32_core.count_cycle\[12\]
+ sky130_fd_sc_hd__dfxtp_1
XTAP_TAPCELL_ROW_111_1914 VGND VPWR sky130_fd_sc_hd__tapvpwrvgnd_1
XFILLER_3_765 VPWR VGND VPWR VGND sky130_ef_sc_hd__decap_12
XFILLER_2_253 VGND VGND VPWR VPWR sky130_fd_sc_hd__decap_8
X_10285_ clknet_leaf_123_clk _00204_ VGND VGND VPWR VPWR picorv32_core.reg_pc\[6\]
+ sky130_fd_sc_hd__dfxtp_1
XTAP_TAPCELL_ROW_53_1076 VGND VPWR sky130_fd_sc_hd__tapvpwrvgnd_1
XFILLER_38_419 VGND VGND VPWR VPWR sky130_fd_sc_hd__fill_1
Xfanout590 _01683_ VGND VGND VPWR VPWR net590 sky130_fd_sc_hd__buf_2
XTAP_TAPCELL_ROW_109_1887 VGND VPWR sky130_fd_sc_hd__tapvpwrvgnd_1
XFILLER_74_783 VGND VGND VPWR VPWR sky130_fd_sc_hd__fill_1
XFILLER_74_772 VGND VGND VPWR VPWR sky130_fd_sc_hd__decap_3
XFILLER_92_72 VGND VGND VPWR VPWR sky130_fd_sc_hd__decap_3
XFILLER_33_113 VGND VGND VPWR VPWR sky130_fd_sc_hd__fill_1
XFILLER_46_496 VGND VGND VPWR VPWR sky130_fd_sc_hd__decap_4
XFILLER_21_308 VGND VGND VPWR VPWR sky130_fd_sc_hd__decap_4
X_05260_ net16 _01717_ _01722_ net30 _01771_ VGND VGND VPWR VPWR _01772_ sky130_fd_sc_hd__a221o_1
XTAP_TAPCELL_ROW_40_881 VGND VPWR sky130_fd_sc_hd__tapvpwrvgnd_1
X_05191_ net137 net136 net139 net138 VGND VGND VPWR VPWR _01712_ sky130_fd_sc_hd__or4_1
XTAP_TAPCELL_ROW_40_892 VGND VPWR sky130_fd_sc_hd__tapvpwrvgnd_1
X_08950_ _02791_ net2222 net356 VGND VGND VPWR VPWR _01123_ sky130_fd_sc_hd__mux2_1
XPHY_EDGE_ROW_135_Right_135 VGND VGND VPWR VPWR sky130_fd_sc_hd__decap_3
X_08881_ net222 net1708 net364 VGND VGND VPWR VPWR _01056_ sky130_fd_sc_hd__mux2_1
X_07901_ picorv32_core.cpuregs\[8\]\[21\] picorv32_core.cpuregs\[9\]\[21\] picorv32_core.cpuregs\[10\]\[21\]
+ picorv32_core.cpuregs\[11\]\[21\] net750 net717 VGND VGND VPWR VPWR _03985_ sky130_fd_sc_hd__mux4_1
XPHY_EDGE_ROW_102_Left_244 VGND VGND VPWR VPWR sky130_fd_sc_hd__decap_3
XFILLER_69_544 VPWR VGND VPWR VGND sky130_ef_sc_hd__decap_12
X_07832_ _03918_ _03919_ net458 _03916_ VGND VGND VPWR VPWR _03920_ sky130_fd_sc_hd__o211a_1
XFILLER_84_514 VGND VGND VPWR VPWR sky130_fd_sc_hd__fill_2
X_09502_ _04681_ _04682_ _04684_ _04683_ net654 net832 VGND VGND VPWR VPWR _04687_
+ sky130_fd_sc_hd__mux4_1
X_07763_ picorv32_core.cpuregs\[20\]\[14\] picorv32_core.cpuregs\[21\]\[14\] picorv32_core.cpuregs\[22\]\[14\]
+ picorv32_core.cpuregs\[23\]\[14\] net737 net704 VGND VGND VPWR VPWR _03854_ sky130_fd_sc_hd__mux4_1
XFILLER_112_27 VGND VGND VPWR VPWR sky130_fd_sc_hd__fill_1
XTAP_TAPCELL_ROW_84_1526 VGND VPWR sky130_fd_sc_hd__tapvpwrvgnd_1
X_06714_ picorv32_core.decoded_imm_j\[2\] _02914_ VGND VGND VPWR VPWR _02948_ sky130_fd_sc_hd__and2_1
X_07694_ net628 _03788_ VGND VGND VPWR VPWR _03789_ sky130_fd_sc_hd__or2_1
X_09433_ picorv32_core.cpuregs\[0\]\[11\] picorv32_core.cpuregs\[1\]\[11\] picorv32_core.cpuregs\[2\]\[11\]
+ picorv32_core.cpuregs\[3\]\[11\] net878 net845 VGND VGND VPWR VPWR _04621_ sky130_fd_sc_hd__mux4_1
X_06645_ _02671_ picorv32_core.reg_next_pc\[1\] net556 VGND VGND VPWR VPWR _02911_
+ sky130_fd_sc_hd__mux2_1
XPHY_EDGE_ROW_111_Left_253 VGND VGND VPWR VPWR sky130_fd_sc_hd__decap_3
XFILLER_13_809 VPWR VGND VPWR VGND sky130_ef_sc_hd__decap_12
X_09364_ picorv32_core.cpuregs\[0\]\[8\] picorv32_core.cpuregs\[1\]\[8\] picorv32_core.cpuregs\[2\]\[8\]
+ picorv32_core.cpuregs\[3\]\[8\] net877 net844 VGND VGND VPWR VPWR _04555_ sky130_fd_sc_hd__mux4_1
X_08315_ picorv32_core.is_jalr_addi_slti_sltiu_xori_ori_andi net523 _04183_ _04198_
+ _04233_ VGND VGND VPWR VPWR _00535_ sky130_fd_sc_hd__a221o_1
X_06576_ picorv32_core.count_instr\[39\] _02864_ _02866_ VGND VGND VPWR VPWR _00174_
+ sky130_fd_sc_hd__o21a_1
XANTENNA_20 _04239_ VGND VGND VPWR VPWR sky130_fd_sc_hd__diode_2
XANTENNA_31 _04863_ VGND VGND VPWR VPWR sky130_fd_sc_hd__diode_2
X_05527_ _02006_ _02009_ _02019_ VGND VGND VPWR VPWR _02020_ sky130_fd_sc_hd__nand3_1
X_09295_ picorv32_core.cpuregs\[16\]\[5\] picorv32_core.cpuregs\[17\]\[5\] picorv32_core.cpuregs\[18\]\[5\]
+ picorv32_core.cpuregs\[19\]\[5\] net875 net842 VGND VGND VPWR VPWR _04489_ sky130_fd_sc_hd__mux4_1
XFILLER_119_741 VPWR VGND VPWR VGND sky130_ef_sc_hd__decap_12
XANTENNA_64 net725 VGND VGND VPWR VPWR sky130_fd_sc_hd__diode_2
X_05458_ picorv32_core.reg_pc\[18\] picorv32_core.decoded_imm\[18\] VGND VGND VPWR
+ VPWR _01956_ sky130_fd_sc_hd__and2_1
XANTENNA_75 _03613_ VGND VGND VPWR VPWR sky130_fd_sc_hd__diode_2
XANTENNA_53 net383 VGND VGND VPWR VPWR sky130_fd_sc_hd__diode_2
XANTENNA_42 net20 VGND VGND VPWR VPWR sky130_fd_sc_hd__diode_2
X_08246_ net2317 _00767_ net438 VGND VGND VPWR VPWR _00476_ sky130_fd_sc_hd__mux2_1
X_08177_ net526 _04184_ VGND VGND VPWR VPWR _04193_ sky130_fd_sc_hd__and2_1
XANTENNA_86 net407 VGND VGND VPWR VPWR sky130_fd_sc_hd__diode_2
XFILLER_119_785 VPWR VGND VPWR VGND sky130_ef_sc_hd__decap_12
X_07128_ picorv32_core.count_cycle\[19\] _03309_ picorv32_core.count_cycle\[20\] VGND
+ VGND VPWR VPWR _03312_ sky130_fd_sc_hd__a21o_1
X_05389_ _01890_ _01891_ VGND VGND VPWR VPWR _01892_ sky130_fd_sc_hd__nand2b_1
XFILLER_21_57 VPWR VGND VPWR VGND sky130_ef_sc_hd__decap_12
XFILLER_137_57 VPWR VGND VPWR VGND sky130_ef_sc_hd__decap_12
XTAP_TAPCELL_ROW_95_1688 VGND VPWR sky130_fd_sc_hd__tapvpwrvgnd_1
XTAP_TAPCELL_ROW_95_1677 VGND VPWR sky130_fd_sc_hd__tapvpwrvgnd_1
Xoutput160 net160 VGND VGND VPWR VPWR pcpi_rs1[27] sky130_fd_sc_hd__buf_2
XPHY_EDGE_ROW_120_Left_262 VGND VGND VPWR VPWR sky130_fd_sc_hd__decap_3
X_07059_ _03254_ _03257_ _03256_ VGND VGND VPWR VPWR _03265_ sky130_fd_sc_hd__a21o_1
XFILLER_0_713 VGND VGND VPWR VPWR sky130_fd_sc_hd__decap_8
Xoutput193 net193 VGND VGND VPWR VPWR pcpi_rs2[28] sky130_fd_sc_hd__buf_2
Xoutput182 net182 VGND VGND VPWR VPWR pcpi_rs2[18] sky130_fd_sc_hd__buf_2
X_10070_ net2096 net207 net307 VGND VGND VPWR VPWR _01545_ sky130_fd_sc_hd__mux2_1
Xoutput171 net171 VGND VGND VPWR VPWR pcpi_rs1[8] sky130_fd_sc_hd__buf_2
XPHY_EDGE_ROW_102_Right_102 VGND VGND VPWR VPWR sky130_fd_sc_hd__decap_3
XFILLER_102_663 VPWR VGND VPWR VGND sky130_ef_sc_hd__decap_12
XFILLER_48_717 VGND VGND VPWR VPWR sky130_fd_sc_hd__fill_2
XFILLER_0_757 VPWR VGND VPWR VGND sky130_ef_sc_hd__decap_12
XTAP_TAPCELL_ROW_126_2132 VGND VPWR sky130_fd_sc_hd__tapvpwrvgnd_1
XFILLER_87_374 VGND VGND VPWR VPWR sky130_fd_sc_hd__fill_1
XFILLER_90_517 VGND VGND VPWR VPWR sky130_fd_sc_hd__fill_1
X_10972_ clknet_leaf_20_clk _00823_ VGND VGND VPWR VPWR picorv32_core.cpuregs\[13\]\[18\]
+ sky130_fd_sc_hd__dfxtp_1
XFILLER_28_474 VGND VGND VPWR VPWR sky130_fd_sc_hd__fill_2
XFILLER_43_422 VGND VGND VPWR VPWR sky130_fd_sc_hd__decap_8
XFILLER_62_53 VGND VGND VPWR VPWR sky130_fd_sc_hd__decap_3
XTAP_TAPCELL_ROW_26_675 VGND VPWR sky130_fd_sc_hd__tapvpwrvgnd_1
XTAP_TAPCELL_ROW_26_686 VGND VPWR sky130_fd_sc_hd__tapvpwrvgnd_1
XFILLER_43_488 VPWR VGND VPWR VGND sky130_ef_sc_hd__decap_12
XFILLER_62_97 VGND VGND VPWR VPWR sky130_fd_sc_hd__fill_2
XFILLER_8_813 VPWR VGND VPWR VGND sky130_ef_sc_hd__decap_12
X_11524_ clknet_leaf_138_clk _01355_ VGND VGND VPWR VPWR picorv32_core.cpuregs\[30\]\[5\]
+ sky130_fd_sc_hd__dfxtp_1
XTAP_TAPCELL_ROW_137_2294 VGND VPWR sky130_fd_sc_hd__tapvpwrvgnd_1
X_11455_ clknet_leaf_140_clk _01291_ VGND VGND VPWR VPWR picorv32_core.cpuregs\[24\]\[6\]
+ sky130_fd_sc_hd__dfxtp_1
X_10406_ clknet_leaf_59_clk _00325_ VGND VGND VPWR VPWR net165 sky130_fd_sc_hd__dfxtp_1
XTAP_TAPCELL_ROW_55_1105 VGND VPWR sky130_fd_sc_hd__tapvpwrvgnd_1
X_11386_ clknet_leaf_110_clk _01222_ VGND VGND VPWR VPWR picorv32_core.cpuregs\[31\]\[1\]
+ sky130_fd_sc_hd__dfxtp_1
XFILLER_140_725 VPWR VGND VPWR VGND sky130_ef_sc_hd__decap_12
XFILLER_125_777 VGND VGND VPWR VPWR sky130_fd_sc_hd__decap_6
X_10337_ clknet_leaf_69_clk _00256_ VGND VGND VPWR VPWR picorv32_core.reg_next_pc\[27\]
+ sky130_fd_sc_hd__dfxtp_1
X_10268_ clknet_leaf_80_clk _00187_ VGND VGND VPWR VPWR picorv32_core.count_instr\[52\]
+ sky130_fd_sc_hd__dfxtp_1
XFILLER_140_769 VPWR VGND VPWR VGND sky130_ef_sc_hd__decap_12
XFILLER_78_363 VGND VGND VPWR VPWR sky130_fd_sc_hd__fill_1
X_10199_ clknet_leaf_19_clk _00118_ VGND VGND VPWR VPWR picorv32_core.cpuregs\[9\]\[15\]
+ sky130_fd_sc_hd__dfxtp_1
XFILLER_38_249 VGND VGND VPWR VPWR sky130_fd_sc_hd__decap_3
XFILLER_19_474 VGND VGND VPWR VPWR sky130_fd_sc_hd__fill_1
XFILLER_34_433 VGND VGND VPWR VPWR sky130_fd_sc_hd__decap_8
X_06430_ net223 net1826 net424 VGND VGND VPWR VPWR _00098_ sky130_fd_sc_hd__mux2_1
XTAP_TAPCELL_ROW_66_1267 VGND VPWR sky130_fd_sc_hd__tapvpwrvgnd_1
XTAP_TAPCELL_ROW_66_1256 VGND VPWR sky130_fd_sc_hd__tapvpwrvgnd_1
XFILLER_34_477 VGND VGND VPWR VPWR sky130_fd_sc_hd__decap_4
XTAP_TAPCELL_ROW_45_951 VGND VPWR sky130_fd_sc_hd__tapvpwrvgnd_1
XTAP_TAPCELL_ROW_45_962 VGND VPWR sky130_fd_sc_hd__tapvpwrvgnd_1
X_06361_ picorv32_core.reg_pc\[24\] picorv32_core.reg_pc\[23\] _02755_ VGND VGND VPWR
+ VPWR _02763_ sky130_fd_sc_hd__and3_1
X_09080_ net1850 net221 net338 VGND VGND VPWR VPWR _01248_ sky130_fd_sc_hd__mux2_1
X_05312_ picorv32_core.latched_is_lb picorv32_core.latched_is_lh VGND VGND VPWR VPWR
+ _01820_ sky130_fd_sc_hd__nor2_1
X_06292_ picorv32_core.reg_out\[11\] picorv32_core.alu_out_q\[11\] net951 VGND VGND
+ VPWR VPWR _02707_ sky130_fd_sc_hd__mux2_1
X_08100_ net924 net908 _01635_ VGND VGND VPWR VPWR _04170_ sky130_fd_sc_hd__o21ai_1
X_08031_ picorv32_core.decoded_imm\[28\] net592 net597 VGND VGND VPWR VPWR _04108_
+ sky130_fd_sc_hd__a21o_1
X_05243_ _01752_ _01753_ _01754_ VGND VGND VPWR VPWR _01756_ sky130_fd_sc_hd__nand3_1
Xhold802 picorv32_core.cpuregs\[5\]\[28\] VGND VGND VPWR VPWR net1911 sky130_fd_sc_hd__dlygate4sd3_1
Xhold846 net53 VGND VGND VPWR VPWR net1955 sky130_fd_sc_hd__dlygate4sd3_1
XFILLER_116_755 VGND VGND VPWR VPWR sky130_fd_sc_hd__fill_1
Xhold813 picorv32_core.cpuregs\[16\]\[16\] VGND VGND VPWR VPWR net1922 sky130_fd_sc_hd__dlygate4sd3_1
Xhold824 picorv32_core.cpuregs\[5\]\[1\] VGND VGND VPWR VPWR net1933 sky130_fd_sc_hd__dlygate4sd3_1
Xhold835 picorv32_core.cpuregs\[21\]\[6\] VGND VGND VPWR VPWR net1944 sky130_fd_sc_hd__dlygate4sd3_1
X_05174_ net931 net921 VGND VGND VPWR VPWR _01698_ sky130_fd_sc_hd__nand2_1
Xhold868 picorv32_core.cpuregs\[6\]\[13\] VGND VGND VPWR VPWR net1977 sky130_fd_sc_hd__dlygate4sd3_1
Xhold857 picorv32_core.cpuregs\[13\]\[2\] VGND VGND VPWR VPWR net1966 sky130_fd_sc_hd__dlygate4sd3_1
Xhold879 picorv32_core.cpuregs\[6\]\[2\] VGND VGND VPWR VPWR net1988 sky130_fd_sc_hd__dlygate4sd3_1
X_09982_ net2092 net301 net312 VGND VGND VPWR VPWR _01459_ sky130_fd_sc_hd__mux2_1
XFILLER_103_449 VGND VGND VPWR VPWR sky130_fd_sc_hd__decap_6
X_08933_ net279 net1754 net354 VGND VGND VPWR VPWR _01106_ sky130_fd_sc_hd__mux2_1
XFILLER_130_246 VGND VGND VPWR VPWR sky130_fd_sc_hd__fill_2
XFILLER_57_503 VGND VGND VPWR VPWR sky130_fd_sc_hd__fill_1
XFILLER_123_15 VPWR VGND VPWR VGND sky130_ef_sc_hd__decap_12
X_08864_ net294 net1748 net362 VGND VGND VPWR VPWR _01039_ sky130_fd_sc_hd__mux2_1
X_07815_ net180 net512 _03902_ _03903_ VGND VGND VPWR VPWR _00376_ sky130_fd_sc_hd__o22a_1
XTAP_TAPCELL_ROW_4_359 VGND VPWR sky130_fd_sc_hd__tapvpwrvgnd_1
X_08795_ net428 net2018 net370 VGND VGND VPWR VPWR _00973_ sky130_fd_sc_hd__mux2_1
X_07746_ picorv32_core.decoded_imm\[12\] net590 net594 VGND VGND VPWR VPWR _03839_
+ sky130_fd_sc_hd__a21o_1
XFILLER_72_539 VGND VGND VPWR VPWR sky130_fd_sc_hd__fill_1
XTAP_TAPCELL_ROW_121_2062 VGND VPWR sky130_fd_sc_hd__tapvpwrvgnd_1
XFILLER_53_775 VGND VGND VPWR VPWR sky130_fd_sc_hd__decap_8
XFILLER_13_617 VGND VGND VPWR VPWR sky130_fd_sc_hd__decap_4
X_07677_ picorv32_core.cpuregs\[4\]\[9\] picorv32_core.cpuregs\[5\]\[9\] picorv32_core.cpuregs\[6\]\[9\]
+ picorv32_core.cpuregs\[7\]\[9\] net731 net698 VGND VGND VPWR VPWR _03773_ sky130_fd_sc_hd__mux4_1
X_09416_ _04596_ _04597_ net652 VGND VGND VPWR VPWR _04605_ sky130_fd_sc_hd__mux2_1
X_06628_ picorv32_core.count_instr\[58\] picorv32_core.count_instr\[57\] picorv32_core.count_instr\[56\]
+ _02894_ VGND VGND VPWR VPWR _02900_ sky130_fd_sc_hd__and4_1
XFILLER_8_109 VPWR VGND VPWR VGND sky130_ef_sc_hd__decap_12
XTAP_TAPCELL_ROW_23_634 VGND VPWR sky130_fd_sc_hd__tapvpwrvgnd_1
XTAP_TAPCELL_ROW_23_645 VGND VPWR sky130_fd_sc_hd__tapvpwrvgnd_1
X_09347_ _04532_ _04533_ _04534_ _04535_ net653 net642 VGND VGND VPWR VPWR _04539_
+ sky130_fd_sc_hd__mux4_1
X_06559_ picorv32_core.count_instr\[33\] _02854_ net973 VGND VGND VPWR VPWR _02856_
+ sky130_fd_sc_hd__a21oi_1
XTAP_TAPCELL_ROW_97_1706 VGND VPWR sky130_fd_sc_hd__tapvpwrvgnd_1
X_09278_ net837 _04472_ VGND VGND VPWR VPWR _04473_ sky130_fd_sc_hd__and2_1
XTAP_TAPCELL_ROW_97_1717 VGND VPWR sky130_fd_sc_hd__tapvpwrvgnd_1
X_08229_ picorv32_core.mem_rdata_q\[17\] picorv32_core.mem_rdata_q\[18\] picorv32_core.mem_rdata_q\[19\]
+ picorv32_core.mem_rdata_q\[2\] VGND VGND VPWR VPWR _04216_ sky130_fd_sc_hd__or4_1
X_11240_ clknet_leaf_65_clk _01091_ VGND VGND VPWR VPWR picorv32_core.cpuregs\[5\]\[30\]
+ sky130_fd_sc_hd__dfxtp_1
XFILLER_106_3 VPWR VGND VPWR VGND sky130_ef_sc_hd__decap_12
X_11171_ clknet_leaf_71_clk _01022_ VGND VGND VPWR VPWR picorv32_core.cpuregs\[7\]\[25\]
+ sky130_fd_sc_hd__dfxtp_1
X_10122_ clknet_leaf_141_clk _00044_ VGND VGND VPWR VPWR picorv32_core.cpuregs\[22\]\[5\]
+ sky130_fd_sc_hd__dfxtp_1
XFILLER_122_769 VPWR VGND VPWR VGND sky130_ef_sc_hd__decap_12
XFILLER_121_257 VGND VGND VPWR VPWR sky130_fd_sc_hd__decap_6
X_10053_ net1335 net275 net306 VGND VGND VPWR VPWR _01528_ sky130_fd_sc_hd__mux2_1
XTAP_TAPCELL_ROW_50_1035 VGND VPWR sky130_fd_sc_hd__tapvpwrvgnd_1
XTAP_TAPCELL_ROW_50_1024 VGND VPWR sky130_fd_sc_hd__tapvpwrvgnd_1
XTAP_TAPCELL_ROW_106_1846 VGND VPWR sky130_fd_sc_hd__tapvpwrvgnd_1
XTAP_TAPCELL_ROW_106_1835 VGND VPWR sky130_fd_sc_hd__tapvpwrvgnd_1
XFILLER_71_561 VPWR VGND VPWR VGND sky130_ef_sc_hd__decap_12
X_10955_ clknet_leaf_114_clk _00806_ VGND VGND VPWR VPWR picorv32_core.cpuregs\[13\]\[1\]
+ sky130_fd_sc_hd__dfxtp_1
XFILLER_44_753 VGND VGND VPWR VPWR sky130_fd_sc_hd__decap_3
X_10886_ clknet_leaf_65_clk _00737_ VGND VGND VPWR VPWR picorv32_core.cpuregs\[16\]\[30\]
+ sky130_fd_sc_hd__dfxtp_1
XFILLER_71_583 VGND VGND VPWR VPWR sky130_fd_sc_hd__decap_8
XTAP_TAPCELL_ROW_42_910 VGND VPWR sky130_fd_sc_hd__tapvpwrvgnd_1
XTAP_TAPCELL_ROW_42_921 VGND VPWR sky130_fd_sc_hd__tapvpwrvgnd_1
XTAP_TAPCELL_ROW_139_2323 VGND VPWR sky130_fd_sc_hd__tapvpwrvgnd_1
XFILLER_129_346 VGND VGND VPWR VPWR sky130_fd_sc_hd__decap_3
X_11507_ clknet_leaf_61_clk _01343_ VGND VGND VPWR VPWR net157 sky130_fd_sc_hd__dfxtp_1
XTAP_TAPCELL_ROW_61_1186 VGND VPWR sky130_fd_sc_hd__tapvpwrvgnd_1
XFILLER_8_654 VGND VGND VPWR VPWR sky130_fd_sc_hd__decap_3
Xhold109 picorv32_core.cpuregs\[11\]\[28\] VGND VGND VPWR VPWR net1218 sky130_fd_sc_hd__dlygate4sd3_1
X_11438_ clknet_leaf_41_clk _01274_ VGND VGND VPWR VPWR picorv32_core.cpuregs\[1\]\[21\]
+ sky130_fd_sc_hd__dfxtp_1
X_11369_ clknet_leaf_49_clk _01210_ VGND VGND VPWR VPWR picorv32_core.cpuregs\[18\]\[21\]
+ sky130_fd_sc_hd__dfxtp_1
XTAP_TAPCELL_ROW_117_1997 VGND VPWR sky130_fd_sc_hd__tapvpwrvgnd_1
XFILLER_113_725 VGND VGND VPWR VPWR sky130_fd_sc_hd__decap_3
XFILLER_112_257 VGND VGND VPWR VPWR sky130_fd_sc_hd__fill_1
XFILLER_79_650 VGND VGND VPWR VPWR sky130_fd_sc_hd__decap_4
XFILLER_67_812 VGND VGND VPWR VPWR sky130_fd_sc_hd__fill_1
X_05930_ _02331_ _02374_ _02399_ net672 VGND VGND VPWR VPWR _02400_ sky130_fd_sc_hd__o31a_1
XFILLER_21_3 VPWR VGND VPWR VGND sky130_ef_sc_hd__decap_12
XFILLER_39_525 VGND VGND VPWR VPWR sky130_fd_sc_hd__decap_8
XFILLER_94_642 VGND VGND VPWR VPWR sky130_fd_sc_hd__fill_2
X_05861_ _02329_ _02336_ net506 VGND VGND VPWR VPWR _02337_ sky130_fd_sc_hd__o21ai_1
XFILLER_39_547 VPWR VGND VPWR VGND sky130_ef_sc_hd__decap_12
X_08580_ net208 net1883 net401 VGND VGND VPWR VPWR _00705_ sky130_fd_sc_hd__mux2_1
XFILLER_94_686 VGND VGND VPWR VPWR sky130_fd_sc_hd__fill_1
XFILLER_94_675 VGND VGND VPWR VPWR sky130_fd_sc_hd__fill_2
XFILLER_54_506 VGND VGND VPWR VPWR sky130_fd_sc_hd__decap_4
XTAP_TAPCELL_ROW_1_318 VGND VPWR sky130_fd_sc_hd__tapvpwrvgnd_1
X_07600_ picorv32_core.cpuregs\[28\]\[5\] picorv32_core.cpuregs\[29\]\[5\] picorv32_core.cpuregs\[30\]\[5\]
+ picorv32_core.cpuregs\[31\]\[5\] net733 net700 VGND VGND VPWR VPWR _03700_ sky130_fd_sc_hd__mux4_1
X_07531_ net164 _03641_ net534 VGND VGND VPWR VPWR _03642_ sky130_fd_sc_hd__mux2_1
X_05792_ _02138_ _02273_ _02272_ net506 VGND VGND VPWR VPWR _02274_ sky130_fd_sc_hd__a211o_1
XFILLER_81_369 VGND VGND VPWR VPWR sky130_fd_sc_hd__decap_3
X_07462_ net170 _03595_ net532 VGND VGND VPWR VPWR _03596_ sky130_fd_sc_hd__mux2_1
XFILLER_22_403 VGND VGND VPWR VPWR sky130_fd_sc_hd__fill_1
XFILLER_35_797 VPWR VGND VPWR VGND sky130_ef_sc_hd__decap_12
X_07393_ _03408_ _03409_ VGND VGND VPWR VPWR _03533_ sky130_fd_sc_hd__and2b_1
X_09201_ _01637_ _03462_ VGND VGND VPWR VPWR _04399_ sky130_fd_sc_hd__nor2_1
X_06413_ net294 net2053 net422 VGND VGND VPWR VPWR _00081_ sky130_fd_sc_hd__mux2_1
X_06344_ picorv32_core.reg_pc\[20\] _02742_ picorv32_core.reg_pc\[21\] VGND VGND VPWR
+ VPWR _02749_ sky130_fd_sc_hd__a21oi_1
X_09132_ net1769 net277 net328 VGND VGND VPWR VPWR _01298_ sky130_fd_sc_hd__mux2_1
XFILLER_118_15 VPWR VGND VPWR VGND sky130_ef_sc_hd__decap_12
XTAP_TAPCELL_ROW_79_1447 VGND VPWR sky130_fd_sc_hd__tapvpwrvgnd_1
X_06275_ _02692_ _02693_ VGND VGND VPWR VPWR _02694_ sky130_fd_sc_hd__nor2_1
X_09063_ net2033 net296 net337 VGND VGND VPWR VPWR _01231_ sky130_fd_sc_hd__mux2_1
X_08014_ picorv32_core.cpuregs\[20\]\[28\] picorv32_core.cpuregs\[21\]\[28\] picorv32_core.cpuregs\[22\]\[28\]
+ picorv32_core.cpuregs\[23\]\[28\] net754 net721 VGND VGND VPWR VPWR _04091_ sky130_fd_sc_hd__mux4_1
X_05226_ net820 net5 _01718_ _01739_ VGND VGND VPWR VPWR _01740_ sky130_fd_sc_hd__o211a_1
Xhold621 picorv32_core.cpuregs\[29\]\[0\] VGND VGND VPWR VPWR net1730 sky130_fd_sc_hd__dlygate4sd3_1
Xhold610 picorv32_core.cpuregs\[26\]\[4\] VGND VGND VPWR VPWR net1719 sky130_fd_sc_hd__dlygate4sd3_1
Xhold654 picorv32_core.cpuregs\[16\]\[29\] VGND VGND VPWR VPWR net1763 sky130_fd_sc_hd__dlygate4sd3_1
Xhold632 picorv32_core.cpuregs\[13\]\[19\] VGND VGND VPWR VPWR net1741 sky130_fd_sc_hd__dlygate4sd3_1
XTAP_TAPCELL_ROW_92_1636 VGND VPWR sky130_fd_sc_hd__tapvpwrvgnd_1
Xhold643 picorv32_core.cpuregs\[23\]\[12\] VGND VGND VPWR VPWR net1752 sky130_fd_sc_hd__dlygate4sd3_1
XTAP_TAPCELL_ROW_9_429 VGND VPWR sky130_fd_sc_hd__tapvpwrvgnd_1
X_05157_ picorv32_core.is_sb_sh_sw _01682_ VGND VGND VPWR VPWR _01684_ sky130_fd_sc_hd__and2_1
XFILLER_131_522 VGND VGND VPWR VPWR sky130_fd_sc_hd__fill_1
Xhold665 picorv32_core.cpuregs\[17\]\[13\] VGND VGND VPWR VPWR net1774 sky130_fd_sc_hd__dlygate4sd3_1
Xhold676 picorv32_core.cpuregs\[4\]\[11\] VGND VGND VPWR VPWR net1785 sky130_fd_sc_hd__dlygate4sd3_1
Xhold687 picorv32_core.cpuregs\[17\]\[11\] VGND VGND VPWR VPWR net1796 sky130_fd_sc_hd__dlygate4sd3_1
X_09965_ net1356 net229 net319 VGND VGND VPWR VPWR _01443_ sky130_fd_sc_hd__mux2_1
X_05088_ picorv32_core.instr_sltu net1166 picorv32_core.instr_bltu VGND VGND VPWR
+ VPWR _00033_ sky130_fd_sc_hd__or3_1
Xhold698 picorv32_core.cpuregs\[1\]\[0\] VGND VGND VPWR VPWR net1807 sky130_fd_sc_hd__dlygate4sd3_1
X_08916_ net215 net1683 net361 VGND VGND VPWR VPWR _01090_ sky130_fd_sc_hd__mux2_1
X_09896_ _03583_ _05031_ _05030_ VGND VGND VPWR VPWR _05032_ sky130_fd_sc_hd__o21ai_1
X_08847_ net1471 net227 net368 VGND VGND VPWR VPWR _01023_ sky130_fd_sc_hd__mux2_1
XFILLER_94_29 VGND VGND VPWR VPWR sky130_fd_sc_hd__decap_3
XFILLER_85_642 VGND VGND VPWR VPWR sky130_fd_sc_hd__fill_1
XTAP_TAPCELL_ROW_28_704 VGND VPWR sky130_fd_sc_hd__tapvpwrvgnd_1
XTAP_TAPCELL_ROW_28_715 VGND VPWR sky130_fd_sc_hd__tapvpwrvgnd_1
X_08778_ net234 net1999 net375 VGND VGND VPWR VPWR _00925_ sky130_fd_sc_hd__mux2_1
XFILLER_38_580 VGND VGND VPWR VPWR sky130_fd_sc_hd__fill_1
X_07729_ picorv32_core.cpuregs\[20\]\[12\] picorv32_core.cpuregs\[21\]\[12\] picorv32_core.cpuregs\[22\]\[12\]
+ picorv32_core.cpuregs\[23\]\[12\] net737 net704 VGND VGND VPWR VPWR _03822_ sky130_fd_sc_hd__mux4_1
XFILLER_26_753 VGND VGND VPWR VPWR sky130_fd_sc_hd__decap_3
X_10740_ clknet_leaf_87_clk _00591_ VGND VGND VPWR VPWR picorv32_core.decoded_imm\[19\]
+ sky130_fd_sc_hd__dfxtp_2
XFILLER_53_572 VGND VGND VPWR VPWR sky130_fd_sc_hd__decap_8
XFILLER_53_561 VGND VGND VPWR VPWR sky130_fd_sc_hd__decap_3
XFILLER_25_285 VGND VGND VPWR VPWR sky130_fd_sc_hd__fill_1
X_10671_ clknet_leaf_84_clk _00525_ VGND VGND VPWR VPWR picorv32_core.decoded_imm_j\[17\]
+ sky130_fd_sc_hd__dfxtp_1
XFILLER_80_391 VGND VGND VPWR VPWR sky130_fd_sc_hd__decap_4
XFILLER_80_380 VGND VGND VPWR VPWR sky130_fd_sc_hd__fill_1
XFILLER_13_447 VGND VGND VPWR VPWR sky130_fd_sc_hd__fill_1
XFILLER_41_745 VGND VGND VPWR VPWR sky130_fd_sc_hd__fill_2
XTAP_TAPCELL_ROW_101_1776 VGND VPWR sky130_fd_sc_hd__tapvpwrvgnd_1
XTAP_TAPCELL_ROW_101_1765 VGND VPWR sky130_fd_sc_hd__tapvpwrvgnd_1
XFILLER_138_121 VPWR VGND VPWR VGND sky130_ef_sc_hd__decap_12
Xpicorv32_axi_1020 VGND VGND VPWR VPWR picorv32_axi_1020/HI eoi[21] sky130_fd_sc_hd__conb_1
XFILLER_138_154 VGND VGND VPWR VPWR sky130_fd_sc_hd__decap_4
XTAP_TAPCELL_ROW_134_2242 VGND VPWR sky130_fd_sc_hd__tapvpwrvgnd_1
Xpicorv32_axi_1053 VGND VGND VPWR VPWR picorv32_axi_1053/HI pcpi_insn[13] sky130_fd_sc_hd__conb_1
Xpicorv32_axi_1031 VGND VGND VPWR VPWR picorv32_axi_1031/HI mem_axi_araddr[0] sky130_fd_sc_hd__conb_1
XTAP_TAPCELL_ROW_134_2253 VGND VPWR sky130_fd_sc_hd__tapvpwrvgnd_1
Xpicorv32_axi_1042 VGND VGND VPWR VPWR picorv32_axi_1042/HI pcpi_insn[2] sky130_fd_sc_hd__conb_1
Xpicorv32_axi_1064 VGND VGND VPWR VPWR picorv32_axi_1064/HI pcpi_insn[24] sky130_fd_sc_hd__conb_1
Xpicorv32_axi_1097 VGND VGND VPWR VPWR picorv32_axi_1097/HI trace_data[24] sky130_fd_sc_hd__conb_1
Xpicorv32_axi_1075 VGND VGND VPWR VPWR picorv32_axi_1075/HI trace_data[2] sky130_fd_sc_hd__conb_1
XFILLER_107_552 VGND VGND VPWR VPWR sky130_fd_sc_hd__decap_8
X_11223_ clknet_leaf_15_clk _01074_ VGND VGND VPWR VPWR picorv32_core.cpuregs\[5\]\[13\]
+ sky130_fd_sc_hd__dfxtp_1
Xpicorv32_axi_1086 VGND VGND VPWR VPWR picorv32_axi_1086/HI trace_data[13] sky130_fd_sc_hd__conb_1
XFILLER_5_668 VGND VGND VPWR VPWR sky130_fd_sc_hd__decap_4
XFILLER_4_189 VGND VGND VPWR VPWR sky130_fd_sc_hd__decap_6
X_11154_ clknet_leaf_1_clk _01005_ VGND VGND VPWR VPWR picorv32_core.cpuregs\[7\]\[8\]
+ sky130_fd_sc_hd__dfxtp_1
X_10105_ net1124 VGND VGND VPWR VPWR _00955_ sky130_fd_sc_hd__clkbuf_1
X_11085_ clknet_leaf_116_clk _00936_ VGND VGND VPWR VPWR picorv32_core.cpuregs\[0\]\[3\]
+ sky130_fd_sc_hd__dfxtp_1
XFILLER_0_362 VGND VGND VPWR VPWR sky130_fd_sc_hd__fill_2
X_10036_ net1389 net210 net311 VGND VGND VPWR VPWR _01512_ sky130_fd_sc_hd__mux2_1
XFILLER_124_80 VGND VGND VPWR VPWR sky130_fd_sc_hd__decap_4
XFILLER_84_62 VGND VGND VPWR VPWR sky130_fd_sc_hd__fill_1
XFILLER_63_314 VGND VGND VPWR VPWR sky130_fd_sc_hd__decap_3
XFILLER_17_720 VGND VGND VPWR VPWR sky130_fd_sc_hd__decap_8
XFILLER_17_753 VPWR VGND VPWR VGND sky130_ef_sc_hd__decap_12
X_10938_ clknet_leaf_20_clk _00789_ VGND VGND VPWR VPWR picorv32_core.cpuregs\[19\]\[16\]
+ sky130_fd_sc_hd__dfxtp_1
XTAP_TAPCELL_ROW_63_1215 VGND VPWR sky130_fd_sc_hd__tapvpwrvgnd_1
XFILLER_17_797 VPWR VGND VPWR VGND sky130_ef_sc_hd__decap_12
X_10869_ clknet_leaf_14_clk _00720_ VGND VGND VPWR VPWR picorv32_core.cpuregs\[16\]\[13\]
+ sky130_fd_sc_hd__dfxtp_1
XFILLER_8_473 VGND VGND VPWR VPWR sky130_fd_sc_hd__decap_3
XFILLER_133_809 VPWR VGND VPWR VGND sky130_ef_sc_hd__decap_12
X_06060_ net773 _02518_ VGND VGND VPWR VPWR _02520_ sky130_fd_sc_hd__xnor2_1
XFILLER_113_522 VGND VGND VPWR VPWR sky130_fd_sc_hd__fill_1
XFILLER_140_352 VGND VGND VPWR VPWR sky130_fd_sc_hd__fill_2
XFILLER_125_393 VGND VGND VPWR VPWR sky130_fd_sc_hd__decap_6
XFILLER_99_767 VGND VGND VPWR VPWR sky130_fd_sc_hd__fill_1
Xfanout408 net409 VGND VGND VPWR VPWR net408 sky130_fd_sc_hd__buf_4
XTAP_TAPCELL_ROW_74_1377 VGND VPWR sky130_fd_sc_hd__tapvpwrvgnd_1
Xfanout419 net420 VGND VGND VPWR VPWR net419 sky130_fd_sc_hd__clkbuf_8
XFILLER_140_363 VGND VGND VPWR VPWR sky130_fd_sc_hd__fill_1
X_09750_ net284 _04910_ _04923_ _04905_ VGND VGND VPWR VPWR _01344_ sky130_fd_sc_hd__a31o_1
XFILLER_101_717 VGND VGND VPWR VPWR sky130_fd_sc_hd__fill_1
XFILLER_98_266 VGND VGND VPWR VPWR sky130_fd_sc_hd__decap_3
X_06962_ _03175_ _03176_ net989 VGND VGND VPWR VPWR _00250_ sky130_fd_sc_hd__o21a_1
X_09681_ picorv32_core.cpuregs\[8\]\[22\] picorv32_core.cpuregs\[9\]\[22\] picorv32_core.cpuregs\[10\]\[22\]
+ picorv32_core.cpuregs\[11\]\[22\] net894 net860 VGND VGND VPWR VPWR _04858_ sky130_fd_sc_hd__mux4_1
X_05913_ _02379_ _02383_ VGND VGND VPWR VPWR _02385_ sky130_fd_sc_hd__xnor2_1
X_08701_ net1969 net278 net382 VGND VGND VPWR VPWR _00850_ sky130_fd_sc_hd__mux2_1
X_06893_ net676 _03111_ _03112_ VGND VGND VPWR VPWR _03113_ sky130_fd_sc_hd__or3_1
X_08632_ net2141 net294 net390 VGND VGND VPWR VPWR _00783_ sky130_fd_sc_hd__mux2_1
XFILLER_82_645 VGND VGND VPWR VPWR sky130_fd_sc_hd__decap_8
XFILLER_82_634 VGND VGND VPWR VPWR sky130_fd_sc_hd__fill_1
X_05844_ net807 _02320_ VGND VGND VPWR VPWR _02321_ sky130_fd_sc_hd__and2_1
X_08563_ net274 net1639 net398 VGND VGND VPWR VPWR _00688_ sky130_fd_sc_hd__mux2_1
X_05775_ _01603_ _02257_ VGND VGND VPWR VPWR _02258_ sky130_fd_sc_hd__xnor2_1
X_07514_ net1955 _03630_ net463 VGND VGND VPWR VPWR _00348_ sky130_fd_sc_hd__mux2_1
XFILLER_120_27 VGND VGND VPWR VPWR sky130_fd_sc_hd__fill_1
X_08494_ net1394 net273 net408 VGND VGND VPWR VPWR _00624_ sky130_fd_sc_hd__mux2_1
XFILLER_23_723 VGND VGND VPWR VPWR sky130_fd_sc_hd__decap_4
X_07445_ _01628_ _03583_ VGND VGND VPWR VPWR _03584_ sky130_fd_sc_hd__nor2_1
XFILLER_10_417 VGND VGND VPWR VPWR sky130_fd_sc_hd__decap_3
X_07376_ _03515_ VGND VGND VPWR VPWR _03516_ sky130_fd_sc_hd__inv_2
XTAP_TAPCELL_ROW_33_784 VGND VPWR sky130_fd_sc_hd__tapvpwrvgnd_1
X_09115_ net215 net1330 net335 VGND VGND VPWR VPWR _01282_ sky130_fd_sc_hd__mux2_1
X_06327_ _02732_ _02735_ net565 VGND VGND VPWR VPWR _02736_ sky130_fd_sc_hd__mux2_1
XFILLER_13_69 VPWR VGND VPWR VGND sky130_ef_sc_hd__decap_12
XFILLER_135_113 VGND VGND VPWR VPWR sky130_fd_sc_hd__decap_6
X_09046_ net227 net2142 net343 VGND VGND VPWR VPWR _01215_ sky130_fd_sc_hd__mux2_1
XFILLER_129_69 VPWR VGND VPWR VGND sky130_ef_sc_hd__decap_12
X_06258_ picorv32_core.reg_pc\[3\] picorv32_core.reg_pc\[2\] picorv32_core.reg_pc\[4\]
+ VGND VGND VPWR VPWR _02680_ sky130_fd_sc_hd__a21oi_1
X_05209_ picorv32_core.count_instr\[32\] net935 net602 _01724_ VGND VGND VPWR VPWR
+ _01725_ sky130_fd_sc_hd__a211o_1
XFILLER_116_382 VGND VGND VPWR VPWR sky130_fd_sc_hd__fill_1
Xhold462 picorv32_core.cpuregs\[9\]\[4\] VGND VGND VPWR VPWR net1571 sky130_fd_sc_hd__dlygate4sd3_1
XFILLER_2_627 VGND VGND VPWR VPWR sky130_fd_sc_hd__decap_8
Xhold440 picorv32_core.cpuregs\[26\]\[6\] VGND VGND VPWR VPWR net1549 sky130_fd_sc_hd__dlygate4sd3_1
X_06189_ _02611_ _02620_ VGND VGND VPWR VPWR _02621_ sky130_fd_sc_hd__nor2_1
Xhold451 picorv32_core.cpuregs\[24\]\[10\] VGND VGND VPWR VPWR net1560 sky130_fd_sc_hd__dlygate4sd3_1
XFILLER_104_533 VGND VGND VPWR VPWR sky130_fd_sc_hd__decap_3
Xhold484 picorv32_core.cpuregs\[5\]\[17\] VGND VGND VPWR VPWR net1593 sky130_fd_sc_hd__dlygate4sd3_1
Xhold495 picorv32_core.cpuregs\[19\]\[13\] VGND VGND VPWR VPWR net1604 sky130_fd_sc_hd__dlygate4sd3_1
XFILLER_1_137 VPWR VGND VPWR VGND sky130_ef_sc_hd__decap_12
Xhold473 picorv32_core.cpuregs\[26\]\[7\] VGND VGND VPWR VPWR net1582 sky130_fd_sc_hd__dlygate4sd3_1
Xfanout942 picorv32_core.instr_rdinstr VGND VGND VPWR VPWR net942 sky130_fd_sc_hd__buf_2
Xfanout931 picorv32_core.is_beq_bne_blt_bge_bltu_bgeu VGND VGND VPWR VPWR net931 sky130_fd_sc_hd__clkbuf_4
Xfanout920 net921 VGND VGND VPWR VPWR net920 sky130_fd_sc_hd__clkbuf_4
X_09948_ net1550 net426 net316 VGND VGND VPWR VPWR _01426_ sky130_fd_sc_hd__mux2_1
Xfanout953 picorv32_core.latched_stalu VGND VGND VPWR VPWR net953 sky130_fd_sc_hd__clkbuf_4
Xfanout975 net979 VGND VGND VPWR VPWR net975 sky130_fd_sc_hd__clkbuf_4
Xfanout986 net987 VGND VGND VPWR VPWR net986 sky130_fd_sc_hd__clkbuf_2
Xfanout964 picorv32_core.mem_la_wdata\[5\] VGND VGND VPWR VPWR net964 sky130_fd_sc_hd__clkbuf_4
XFILLER_38_22 VGND VGND VPWR VPWR sky130_fd_sc_hd__decap_6
XFILLER_38_44 VGND VGND VPWR VPWR sky130_fd_sc_hd__fill_2
Xfanout997 net998 VGND VGND VPWR VPWR net997 sky130_fd_sc_hd__clkbuf_2
X_09879_ net1355 net261 net326 VGND VGND VPWR VPWR _01367_ sky130_fd_sc_hd__mux2_1
Xhold1140 picorv32_core.count_cycle\[15\] VGND VGND VPWR VPWR net2249 sky130_fd_sc_hd__dlygate4sd3_1
Xhold1151 picorv32_core.count_instr\[44\] VGND VGND VPWR VPWR net2260 sky130_fd_sc_hd__dlygate4sd3_1
XFILLER_58_653 VGND VGND VPWR VPWR sky130_fd_sc_hd__fill_2
Xhold1184 picorv32_core.count_instr\[54\] VGND VGND VPWR VPWR net2293 sky130_fd_sc_hd__dlygate4sd3_1
XFILLER_18_528 VGND VGND VPWR VPWR sky130_fd_sc_hd__decap_4
Xhold1173 picorv32_core.count_instr\[4\] VGND VGND VPWR VPWR net2282 sky130_fd_sc_hd__dlygate4sd3_1
Xhold1162 picorv32_core.count_instr\[38\] VGND VGND VPWR VPWR net2271 sky130_fd_sc_hd__dlygate4sd3_1
X_11841_ net44 VGND VGND VPWR VPWR net76 sky130_fd_sc_hd__clkbuf_1
Xhold1195 picorv32_core.mem_rdata_q\[16\] VGND VGND VPWR VPWR net2304 sky130_fd_sc_hd__dlygate4sd3_1
XTAP_TAPCELL_ROW_103_1805 VGND VPWR sky130_fd_sc_hd__tapvpwrvgnd_1
XFILLER_14_701 VGND VGND VPWR VPWR sky130_fd_sc_hd__fill_1
XFILLER_53_391 VGND VGND VPWR VPWR sky130_fd_sc_hd__fill_1
X_10723_ clknet_leaf_108_clk _00574_ VGND VGND VPWR VPWR net136 sky130_fd_sc_hd__dfxtp_1
XFILLER_9_215 VGND VGND VPWR VPWR sky130_fd_sc_hd__fill_1
XFILLER_41_575 VGND VGND VPWR VPWR sky130_fd_sc_hd__fill_2
X_10654_ clknet_leaf_33_clk _00508_ VGND VGND VPWR VPWR picorv32_core.cpuregs\[20\]\[22\]
+ sky130_fd_sc_hd__dfxtp_1
X_10585_ clknet_leaf_96_clk _00439_ VGND VGND VPWR VPWR picorv32_core.instr_lb sky130_fd_sc_hd__dfxtp_1
XTAP_TAPCELL_ROW_11_467 VGND VPWR sky130_fd_sc_hd__tapvpwrvgnd_1
Xclkload18 clknet_leaf_143_clk VGND VGND VPWR VPWR clkload18/Y sky130_fd_sc_hd__clkinv_8
Xclkload29 clknet_leaf_131_clk VGND VGND VPWR VPWR clkload29/Y sky130_fd_sc_hd__clkinv_2
XFILLER_126_157 VGND VGND VPWR VPWR sky130_fd_sc_hd__decap_6
XFILLER_115_809 VPWR VGND VPWR VGND sky130_ef_sc_hd__decap_12
XFILLER_5_465 VGND VGND VPWR VPWR sky130_fd_sc_hd__decap_6
XTAP_TAPCELL_ROW_114_1956 VGND VPWR sky130_fd_sc_hd__tapvpwrvgnd_1
XFILLER_134_190 VGND VGND VPWR VPWR sky130_fd_sc_hd__decap_6
X_11206_ clknet_leaf_37_clk _01057_ VGND VGND VPWR VPWR picorv32_core.cpuregs\[6\]\[28\]
+ sky130_fd_sc_hd__dfxtp_1
X_11137_ clknet_leaf_46_clk _00988_ VGND VGND VPWR VPWR picorv32_core.cpuregs\[8\]\[23\]
+ sky130_fd_sc_hd__dfxtp_1
XFILLER_122_363 VGND VGND VPWR VPWR sky130_fd_sc_hd__fill_1
XFILLER_110_514 VGND VGND VPWR VPWR sky130_fd_sc_hd__decap_4
XFILLER_1_671 VGND VGND VPWR VPWR sky130_fd_sc_hd__fill_1
XFILLER_110_547 VGND VGND VPWR VPWR sky130_fd_sc_hd__decap_8
XFILLER_95_50 VGND VGND VPWR VPWR sky130_fd_sc_hd__decap_6
XFILLER_0_181 VPWR VGND VPWR VGND sky130_ef_sc_hd__decap_12
X_11068_ clknet_leaf_20_clk _00919_ VGND VGND VPWR VPWR picorv32_core.cpuregs\[10\]\[18\]
+ sky130_fd_sc_hd__dfxtp_1
XFILLER_76_450 VPWR VGND VPWR VGND sky130_ef_sc_hd__decap_12
XFILLER_64_645 VGND VGND VPWR VPWR sky130_fd_sc_hd__fill_2
X_10019_ net1455 net277 net308 VGND VGND VPWR VPWR _01495_ sky130_fd_sc_hd__mux2_1
XFILLER_64_678 VGND VGND VPWR VPWR sky130_fd_sc_hd__decap_4
XFILLER_52_807 VGND VGND VPWR VPWR sky130_fd_sc_hd__fill_1
X_05560_ net580 _02049_ _02050_ net771 net916 VGND VGND VPWR VPWR _02051_ sky130_fd_sc_hd__a32o_1
XTAP_TAPCELL_ROW_19_578 VGND VPWR sky130_fd_sc_hd__tapvpwrvgnd_1
XFILLER_17_594 VGND VGND VPWR VPWR sky130_fd_sc_hd__fill_1
X_05491_ net16 net584 net574 VGND VGND VPWR VPWR _01987_ sky130_fd_sc_hd__a21o_1
X_07230_ net2046 _03374_ _03376_ VGND VGND VPWR VPWR _00318_ sky130_fd_sc_hd__o21a_1
XFILLER_20_726 VPWR VGND VPWR VGND sky130_ef_sc_hd__decap_12
X_07161_ picorv32_core.count_cycle\[32\] picorv32_core.count_cycle\[31\] _03329_ VGND
+ VGND VPWR VPWR _03333_ sky130_fd_sc_hd__and3_1
XTAP_TAPCELL_ROW_30_743 VGND VPWR sky130_fd_sc_hd__tapvpwrvgnd_1
X_06112_ net193 _02567_ VGND VGND VPWR VPWR _02568_ sky130_fd_sc_hd__xnor2_1
XTAP_TAPCELL_ROW_76_1406 VGND VPWR sky130_fd_sc_hd__tapvpwrvgnd_1
XFILLER_133_617 VGND VGND VPWR VPWR sky130_fd_sc_hd__decap_3
X_07092_ net2274 _03288_ net985 VGND VGND VPWR VPWR _03290_ sky130_fd_sc_hd__o21ai_1
X_06043_ net777 net187 net570 VGND VGND VPWR VPWR _02505_ sky130_fd_sc_hd__and3_1
XFILLER_113_341 VGND VGND VPWR VPWR sky130_fd_sc_hd__fill_1
XFILLER_5_81 VPWR VGND VPWR VGND sky130_ef_sc_hd__decap_12
Xfanout227 _02773_ VGND VGND VPWR VPWR net227 sky130_fd_sc_hd__clkbuf_2
Xfanout238 _02760_ VGND VGND VPWR VPWR net238 sky130_fd_sc_hd__clkbuf_2
Xfanout216 _02786_ VGND VGND VPWR VPWR net216 sky130_fd_sc_hd__clkbuf_2
X_09802_ net471 _04907_ _04972_ _04971_ VGND VGND VPWR VPWR _04973_ sky130_fd_sc_hd__a31o_1
XFILLER_87_737 VGND VGND VPWR VPWR sky130_fd_sc_hd__decap_3
XFILLER_141_694 VGND VGND VPWR VPWR sky130_fd_sc_hd__fill_2
X_07994_ net686 _04071_ net626 VGND VGND VPWR VPWR _04073_ sky130_fd_sc_hd__a21o_1
Xfanout249 net250 VGND VGND VPWR VPWR net249 sky130_fd_sc_hd__dlymetal6s2s_1
XFILLER_101_558 VGND VGND VPWR VPWR sky130_fd_sc_hd__fill_2
X_09733_ _01601_ net542 VGND VGND VPWR VPWR _04907_ sky130_fd_sc_hd__nand2_1
X_06945_ net667 picorv32_core.reg_next_pc\[20\] _02932_ net489 VGND VGND VPWR VPWR
+ _03161_ sky130_fd_sc_hd__a22o_1
XFILLER_86_269 VGND VGND VPWR VPWR sky130_fd_sc_hd__fill_2
XFILLER_131_15 VPWR VGND VPWR VGND sky130_ef_sc_hd__decap_12
X_09664_ picorv32_core.reg_pc\[21\] net537 _04841_ net484 VGND VGND VPWR VPWR _04842_
+ sky130_fd_sc_hd__a211o_1
X_06876_ _03081_ _03095_ _03096_ _03072_ VGND VGND VPWR VPWR _03097_ sky130_fd_sc_hd__a22o_1
XFILLER_55_612 VGND VGND VPWR VPWR sky130_fd_sc_hd__decap_4
X_08615_ net208 net2038 net397 VGND VGND VPWR VPWR _00738_ sky130_fd_sc_hd__mux2_1
X_09595_ _04772_ _04773_ net659 VGND VGND VPWR VPWR _04776_ sky130_fd_sc_hd__mux2_1
XTAP_TAPCELL_ROW_87_1568 VGND VPWR sky130_fd_sc_hd__tapvpwrvgnd_1
XFILLER_27_347 VGND VGND VPWR VPWR sky130_fd_sc_hd__fill_2
XFILLER_27_358 VGND VGND VPWR VPWR sky130_fd_sc_hd__decap_4
XTAP_TAPCELL_ROW_38_854 VGND VPWR sky130_fd_sc_hd__tapvpwrvgnd_1
X_05827_ net809 net963 net567 VGND VGND VPWR VPWR _02305_ sky130_fd_sc_hd__and3_1
XFILLER_91_19 VGND VGND VPWR VPWR sky130_fd_sc_hd__decap_4
X_08546_ net1487 net206 net405 VGND VGND VPWR VPWR _00673_ sky130_fd_sc_hd__mux2_1
X_05758_ picorv32_core.instr_bne picorv32_core.is_sltiu_bltu_sltu VGND VGND VPWR VPWR
+ _02242_ sky130_fd_sc_hd__nor2_1
XFILLER_35_391 VGND VGND VPWR VPWR sky130_fd_sc_hd__fill_1
X_05689_ net777 net187 VGND VGND VPWR VPWR _02173_ sky130_fd_sc_hd__or2_1
X_08477_ picorv32_core.decoded_imm\[1\] net527 _04320_ _04321_ VGND VGND VPWR VPWR
+ _00609_ sky130_fd_sc_hd__o22a_1
X_07428_ net869 _03565_ _03566_ _03567_ net839 VGND VGND VPWR VPWR _03568_ sky130_fd_sc_hd__o221a_1
XTAP_TAPCELL_ROW_118_2012 VGND VPWR sky130_fd_sc_hd__tapvpwrvgnd_1
XFILLER_11_726 VGND VGND VPWR VPWR sky130_fd_sc_hd__fill_2
XTAP_TAPCELL_ROW_118_2023 VGND VPWR sky130_fd_sc_hd__tapvpwrvgnd_1
XFILLER_109_614 VGND VGND VPWR VPWR sky130_fd_sc_hd__fill_2
X_07359_ net789 picorv32_core.decoded_imm\[16\] _03498_ VGND VGND VPWR VPWR _03499_
+ sky130_fd_sc_hd__a21o_1
XTAP_TAPCELL_ROW_131_2201 VGND VPWR sky130_fd_sc_hd__tapvpwrvgnd_1
XFILLER_109_669 VGND VGND VPWR VPWR sky130_fd_sc_hd__decap_3
X_10370_ clknet_leaf_77_clk _00289_ VGND VGND VPWR VPWR picorv32_core.count_cycle\[28\]
+ sky130_fd_sc_hd__dfxtp_1
XFILLER_40_67 VGND VGND VPWR VPWR sky130_fd_sc_hd__fill_1
XFILLER_136_499 VGND VGND VPWR VPWR sky130_fd_sc_hd__fill_1
X_09029_ net298 net1829 net340 VGND VGND VPWR VPWR _01198_ sky130_fd_sc_hd__mux2_1
Xhold270 picorv32_core.cpuregs\[25\]\[11\] VGND VGND VPWR VPWR net1379 sky130_fd_sc_hd__dlygate4sd3_1
XFILLER_132_672 VGND VGND VPWR VPWR sky130_fd_sc_hd__decap_3
XFILLER_132_661 VGND VGND VPWR VPWR sky130_fd_sc_hd__fill_1
Xhold292 picorv32_core.cpuregs\[1\]\[24\] VGND VGND VPWR VPWR net1401 sky130_fd_sc_hd__dlygate4sd3_1
Xhold281 picorv32_core.cpuregs\[29\]\[2\] VGND VGND VPWR VPWR net1390 sky130_fd_sc_hd__dlygate4sd3_1
Xfanout750 net751 VGND VGND VPWR VPWR net750 sky130_fd_sc_hd__buf_4
Xfanout761 net762 VGND VGND VPWR VPWR net761 sky130_fd_sc_hd__buf_4
XTAP_TAPCELL_ROW_129_2174 VGND VPWR sky130_fd_sc_hd__tapvpwrvgnd_1
Xfanout772 net158 VGND VGND VPWR VPWR net772 sky130_fd_sc_hd__buf_1
Xfanout783 net784 VGND VGND VPWR VPWR net783 sky130_fd_sc_hd__clkbuf_2
Xfanout794 net146 VGND VGND VPWR VPWR net794 sky130_fd_sc_hd__buf_2
XFILLER_45_111 VGND VGND VPWR VPWR sky130_fd_sc_hd__fill_1
XFILLER_45_133 VGND VGND VPWR VPWR sky130_fd_sc_hd__fill_1
XFILLER_46_645 VGND VGND VPWR VPWR sky130_fd_sc_hd__fill_2
XFILLER_14_531 VGND VGND VPWR VPWR sky130_fd_sc_hd__fill_1
XTAP_TAPCELL_ROW_16_537 VGND VPWR sky130_fd_sc_hd__tapvpwrvgnd_1
XFILLER_81_52 VGND VGND VPWR VPWR sky130_fd_sc_hd__decap_4
X_10706_ clknet_leaf_28_clk _00557_ VGND VGND VPWR VPWR net111 sky130_fd_sc_hd__dfxtp_1
XFILLER_41_372 VGND VGND VPWR VPWR sky130_fd_sc_hd__decap_6
XFILLER_41_383 VGND VGND VPWR VPWR sky130_fd_sc_hd__decap_8
X_11686_ clknet_leaf_118_clk _01517_ VGND VGND VPWR VPWR picorv32_core.cpuregs\[27\]\[3\]
+ sky130_fd_sc_hd__dfxtp_1
Xclkload118 clknet_leaf_88_clk VGND VGND VPWR VPWR clkload118/Y sky130_fd_sc_hd__clkinvlp_4
Xclkload107 clknet_leaf_99_clk VGND VGND VPWR VPWR clkload107/Y sky130_fd_sc_hd__clkinv_2
XFILLER_10_781 VPWR VGND VPWR VGND sky130_ef_sc_hd__decap_12
X_10637_ clknet_leaf_138_clk _00491_ VGND VGND VPWR VPWR picorv32_core.cpuregs\[20\]\[5\]
+ sky130_fd_sc_hd__dfxtp_1
X_10568_ clknet_leaf_40_clk _00422_ VGND VGND VPWR VPWR picorv32_core.cpuregs\[25\]\[24\]
+ sky130_fd_sc_hd__dfxtp_1
XPHY_EDGE_ROW_116_Right_116 VGND VGND VPWR VPWR sky130_fd_sc_hd__decap_3
XFILLER_115_617 VGND VGND VPWR VPWR sky130_fd_sc_hd__decap_4
Xclkload129 clknet_leaf_80_clk VGND VGND VPWR VPWR clkload129/Y sky130_fd_sc_hd__bufinv_16
X_10499_ clknet_leaf_47_clk _00385_ VGND VGND VPWR VPWR net190 sky130_fd_sc_hd__dfxtp_4
XTAP_TAPCELL_ROW_58_1147 VGND VPWR sky130_fd_sc_hd__tapvpwrvgnd_1
XFILLER_107_190 VGND VGND VPWR VPWR sky130_fd_sc_hd__fill_2
XTAP_TAPCELL_ROW_71_1336 VGND VPWR sky130_fd_sc_hd__tapvpwrvgnd_1
XFILLER_77_781 VGND VGND VPWR VPWR sky130_fd_sc_hd__decap_3
Xinput5 mem_axi_rdata[10] VGND VGND VPWR VPWR net5 sky130_fd_sc_hd__dlymetal6s2s_1
X_06730_ net514 _02959_ _02962_ net551 net1436 VGND VGND VPWR VPWR _00232_ sky130_fd_sc_hd__a32o_1
XFILLER_37_634 VGND VGND VPWR VPWR sky130_fd_sc_hd__decap_4
X_06661_ _02696_ picorv32_core.reg_next_pc\[8\] net556 VGND VGND VPWR VPWR _02920_
+ sky130_fd_sc_hd__mux2_2
XFILLER_37_667 VGND VGND VPWR VPWR sky130_fd_sc_hd__decap_4
X_05612_ picorv32_core.count_cycle\[29\] net600 VGND VGND VPWR VPWR _02099_ sky130_fd_sc_hd__or2_1
XFILLER_25_818 VGND VGND VPWR VPWR sky130_fd_sc_hd__decap_4
X_08400_ _04271_ _04276_ _04270_ VGND VGND VPWR VPWR _04277_ sky130_fd_sc_hd__a21oi_1
XTAP_TAPCELL_ROW_35_813 VGND VPWR sky130_fd_sc_hd__tapvpwrvgnd_1
X_06592_ picorv32_core.count_instr\[45\] _02874_ _02876_ VGND VGND VPWR VPWR _00180_
+ sky130_fd_sc_hd__o21a_1
X_09380_ net801 net548 _04569_ _01705_ VGND VGND VPWR VPWR _04570_ sky130_fd_sc_hd__o211a_1
X_05543_ _02030_ _02033_ VGND VGND VPWR VPWR _02035_ sky130_fd_sc_hd__or2_1
XFILLER_51_169 VGND VGND VPWR VPWR sky130_fd_sc_hd__decap_4
X_08331_ net962 net1175 net453 VGND VGND VPWR VPWR _00548_ sky130_fd_sc_hd__mux2_1
X_05474_ _01969_ _01970_ VGND VGND VPWR VPWR _01971_ sky130_fd_sc_hd__xor2_1
XTAP_TAPCELL_ROW_82_1498 VGND VPWR sky130_fd_sc_hd__tapvpwrvgnd_1
XTAP_TAPCELL_ROW_82_1487 VGND VPWR sky130_fd_sc_hd__tapvpwrvgnd_1
X_08262_ net1198 net504 net411 VGND VGND VPWR VPWR _00486_ sky130_fd_sc_hd__mux2_1
XFILLER_118_400 VGND VGND VPWR VPWR sky130_fd_sc_hd__fill_2
X_07213_ net2248 _03363_ net991 VGND VGND VPWR VPWR _03366_ sky130_fd_sc_hd__o21ai_1
XFILLER_118_433 VGND VGND VPWR VPWR sky130_fd_sc_hd__decap_4
X_08193_ net1156 net476 _04188_ _04199_ VGND VGND VPWR VPWR _00448_ sky130_fd_sc_hd__a22o_1
X_07144_ picorv32_core.count_cycle\[25\] _03319_ picorv32_core.count_cycle\[26\] VGND
+ VGND VPWR VPWR _03322_ sky130_fd_sc_hd__a21o_1
X_07075_ _01700_ _03278_ _03279_ VGND VGND VPWR VPWR _03280_ sky130_fd_sc_hd__a21o_1
XFILLER_106_617 VPWR VGND VPWR VGND sky130_ef_sc_hd__decap_12
XFILLER_10_26 VGND VGND VPWR VPWR sky130_fd_sc_hd__fill_2
XFILLER_126_15 VPWR VGND VPWR VGND sky130_ef_sc_hd__decap_12
X_06026_ _02486_ _02488_ VGND VGND VPWR VPWR _02489_ sky130_fd_sc_hd__nand2_1
X_07977_ picorv32_core.decoded_imm\[25\] net593 net459 _04056_ net598 VGND VGND VPWR
+ VPWR _04057_ sky130_fd_sc_hd__a221o_1
XFILLER_101_333 VGND VGND VPWR VPWR sky130_fd_sc_hd__decap_3
X_09716_ net487 _04887_ _04889_ _04890_ VGND VGND VPWR VPWR _04891_ sky130_fd_sc_hd__or4_1
X_06928_ _03123_ _03144_ _03130_ VGND VGND VPWR VPWR _03145_ sky130_fd_sc_hd__o21a_1
XFILLER_74_217 VGND VGND VPWR VPWR sky130_fd_sc_hd__decap_4
XFILLER_19_57 VPWR VGND VPWR VGND sky130_ef_sc_hd__decap_12
X_09647_ net782 net544 _04761_ net470 VGND VGND VPWR VPWR _04825_ sky130_fd_sc_hd__o211a_1
X_06859_ picorv32_core.decoded_imm_j\[14\] _02926_ VGND VGND VPWR VPWR _03081_ sky130_fd_sc_hd__or2_1
XFILLER_70_401 VPWR VGND VPWR VGND sky130_ef_sc_hd__decap_12
XFILLER_28_678 VGND VGND VPWR VPWR sky130_fd_sc_hd__decap_3
X_09578_ _03507_ _03509_ _03500_ net263 VGND VGND VPWR VPWR _04759_ sky130_fd_sc_hd__a211o_1
XFILLER_55_497 VGND VGND VPWR VPWR sky130_fd_sc_hd__decap_6
XFILLER_43_637 VGND VGND VPWR VPWR sky130_fd_sc_hd__fill_1
X_08529_ net1490 net273 net404 VGND VGND VPWR VPWR _00656_ sky130_fd_sc_hd__mux2_1
XFILLER_30_309 VGND VGND VPWR VPWR sky130_fd_sc_hd__decap_3
X_11540_ clknet_leaf_48_clk _01371_ VGND VGND VPWR VPWR picorv32_core.cpuregs\[30\]\[21\]
+ sky130_fd_sc_hd__dfxtp_1
XFILLER_136_3 VPWR VGND VPWR VGND sky130_ef_sc_hd__decap_12
XFILLER_50_180 VGND VGND VPWR VPWR sky130_fd_sc_hd__decap_4
XFILLER_7_505 VGND VGND VPWR VPWR sky130_fd_sc_hd__fill_1
X_11471_ clknet_leaf_32_clk _01307_ VGND VGND VPWR VPWR picorv32_core.cpuregs\[24\]\[22\]
+ sky130_fd_sc_hd__dfxtp_1
XFILLER_51_55 VGND VGND VPWR VPWR sky130_fd_sc_hd__fill_1
XFILLER_137_753 VPWR VGND VPWR VGND sky130_ef_sc_hd__decap_12
X_10422_ clknet_leaf_83_clk _01553_ VGND VGND VPWR VPWR picorv32_core.reg_out\[15\]
+ sky130_fd_sc_hd__dfxtp_1
XFILLER_137_797 VPWR VGND VPWR VGND sky130_ef_sc_hd__decap_12
X_10353_ clknet_leaf_99_clk _00272_ VGND VGND VPWR VPWR picorv32_core.count_cycle\[11\]
+ sky130_fd_sc_hd__dfxtp_1
XFILLER_2_221 VPWR VGND VPWR VGND sky130_ef_sc_hd__decap_12
XTAP_TAPCELL_ROW_111_1915 VGND VPWR sky130_fd_sc_hd__tapvpwrvgnd_1
XFILLER_3_777 VGND VGND VPWR VPWR sky130_fd_sc_hd__decap_6
X_10284_ clknet_leaf_124_clk _00203_ VGND VGND VPWR VPWR picorv32_core.reg_pc\[5\]
+ sky130_fd_sc_hd__dfxtp_1
XFILLER_120_620 VGND VGND VPWR VPWR sky130_fd_sc_hd__fill_1
XTAP_TAPCELL_ROW_53_1077 VGND VPWR sky130_fd_sc_hd__tapvpwrvgnd_1
Xfanout580 _01726_ VGND VGND VPWR VPWR net580 sky130_fd_sc_hd__clkbuf_2
XFILLER_78_589 VGND VGND VPWR VPWR sky130_fd_sc_hd__fill_2
Xfanout591 net593 VGND VGND VPWR VPWR net591 sky130_fd_sc_hd__clkbuf_4
XFILLER_59_792 VGND VGND VPWR VPWR sky130_fd_sc_hd__decap_3
XFILLER_93_559 VGND VGND VPWR VPWR sky130_fd_sc_hd__fill_1
XTAP_TAPCELL_ROW_109_1888 VGND VPWR sky130_fd_sc_hd__tapvpwrvgnd_1
XFILLER_46_453 VPWR VGND VPWR VGND sky130_ef_sc_hd__decap_12
XFILLER_46_475 VGND VGND VPWR VPWR sky130_fd_sc_hd__fill_1
XFILLER_46_486 VGND VGND VPWR VPWR sky130_fd_sc_hd__fill_1
XFILLER_34_659 VGND VGND VPWR VPWR sky130_fd_sc_hd__fill_2
XFILLER_33_169 VGND VGND VPWR VPWR sky130_fd_sc_hd__decap_4
XFILLER_30_832 VGND VGND VPWR VPWR sky130_fd_sc_hd__fill_2
X_11669_ clknet_leaf_18_clk _01500_ VGND VGND VPWR VPWR picorv32_core.cpuregs\[26\]\[18\]
+ sky130_fd_sc_hd__dfxtp_1
X_05190_ net981 _01711_ VGND VGND VPWR VPWR _00011_ sky130_fd_sc_hd__nand2_1
XTAP_TAPCELL_ROW_40_882 VGND VPWR sky130_fd_sc_hd__tapvpwrvgnd_1
XFILLER_51_3 VGND VGND VPWR VPWR sky130_fd_sc_hd__decap_3
X_08880_ net227 net1737 net364 VGND VGND VPWR VPWR _01055_ sky130_fd_sc_hd__mux2_1
X_07900_ net636 _03983_ VGND VGND VPWR VPWR _03984_ sky130_fd_sc_hd__or2_1
X_07831_ net685 _03917_ net625 VGND VGND VPWR VPWR _03919_ sky130_fd_sc_hd__a21o_1
XFILLER_69_556 VGND VGND VPWR VPWR sky130_fd_sc_hd__decap_4
XFILLER_29_409 VGND VGND VPWR VPWR sky130_fd_sc_hd__fill_2
XFILLER_110_152 VGND VGND VPWR VPWR sky130_fd_sc_hd__decap_4
XFILLER_57_729 VPWR VGND VPWR VGND sky130_ef_sc_hd__decap_12
X_09501_ picorv32_core.cpuregs\[8\]\[14\] picorv32_core.cpuregs\[9\]\[14\] picorv32_core.cpuregs\[10\]\[14\]
+ picorv32_core.cpuregs\[11\]\[14\] net889 net855 VGND VGND VPWR VPWR _04686_ sky130_fd_sc_hd__mux4_1
X_07762_ net177 net513 _03853_ VGND VGND VPWR VPWR _00373_ sky130_fd_sc_hd__o21a_1
XFILLER_37_442 VGND VGND VPWR VPWR sky130_fd_sc_hd__decap_6
XTAP_TAPCELL_ROW_84_1516 VGND VPWR sky130_fd_sc_hd__tapvpwrvgnd_1
XFILLER_52_401 VGND VGND VPWR VPWR sky130_fd_sc_hd__fill_1
X_06713_ net673 _02914_ net970 VGND VGND VPWR VPWR _02947_ sky130_fd_sc_hd__o21ai_1
X_07693_ picorv32_core.cpuregs\[20\]\[10\] picorv32_core.cpuregs\[21\]\[10\] picorv32_core.cpuregs\[22\]\[10\]
+ picorv32_core.cpuregs\[23\]\[10\] net731 net698 VGND VGND VPWR VPWR _03788_ sky130_fd_sc_hd__mux4_1
XFILLER_92_581 VGND VGND VPWR VPWR sky130_fd_sc_hd__decap_4
XTAP_TAPCELL_ROW_84_1527 VGND VPWR sky130_fd_sc_hd__tapvpwrvgnd_1
X_09432_ picorv32_core.cpuregs\[4\]\[11\] picorv32_core.cpuregs\[5\]\[11\] picorv32_core.cpuregs\[6\]\[11\]
+ picorv32_core.cpuregs\[7\]\[11\] net878 net845 VGND VGND VPWR VPWR _04620_ sky130_fd_sc_hd__mux4_1
XFILLER_25_659 VGND VGND VPWR VPWR sky130_fd_sc_hd__fill_1
X_06644_ picorv32_core.latched_branch picorv32_core.latched_store VGND VGND VPWR VPWR
+ _02910_ sky130_fd_sc_hd__nand2_4
X_06575_ picorv32_core.count_instr\[39\] _02864_ net974 VGND VGND VPWR VPWR _02866_
+ sky130_fd_sc_hd__a21oi_1
X_09363_ picorv32_core.cpuregs\[4\]\[8\] picorv32_core.cpuregs\[5\]\[8\] picorv32_core.cpuregs\[6\]\[8\]
+ picorv32_core.cpuregs\[7\]\[8\] net881 net848 VGND VGND VPWR VPWR _04554_ sky130_fd_sc_hd__mux4_1
X_05526_ _02017_ _02018_ VGND VGND VPWR VPWR _02019_ sky130_fd_sc_hd__nand2b_1
X_08314_ picorv32_core.instr_jalr net531 VGND VGND VPWR VPWR _04233_ sky130_fd_sc_hd__and2_1
XANTENNA_32 _04964_ VGND VGND VPWR VPWR sky130_fd_sc_hd__diode_2
XANTENNA_10 _02796_ VGND VGND VPWR VPWR sky130_fd_sc_hd__diode_2
XANTENNA_21 _04261_ VGND VGND VPWR VPWR sky130_fd_sc_hd__diode_2
X_09294_ picorv32_core.cpuregs\[20\]\[5\] picorv32_core.cpuregs\[21\]\[5\] picorv32_core.cpuregs\[22\]\[5\]
+ picorv32_core.cpuregs\[23\]\[5\] net875 net842 VGND VGND VPWR VPWR _04488_ sky130_fd_sc_hd__mux4_1
X_05457_ picorv32_core.reg_pc\[18\] picorv32_core.decoded_imm\[18\] VGND VGND VPWR
+ VPWR _01955_ sky130_fd_sc_hd__nor2_1
XANTENNA_43 net23 VGND VGND VPWR VPWR sky130_fd_sc_hd__diode_2
X_08245_ picorv32_core.mem_rdata_q\[26\] net22 net518 VGND VGND VPWR VPWR _00767_
+ sky130_fd_sc_hd__mux2_1
XANTENNA_54 net387 VGND VGND VPWR VPWR sky130_fd_sc_hd__diode_2
XANTENNA_65 net746 VGND VGND VPWR VPWR sky130_fd_sc_hd__diode_2
XFILLER_119_753 VPWR VGND VPWR VGND sky130_ef_sc_hd__decap_12
XANTENNA_76 _03702_ VGND VGND VPWR VPWR sky130_fd_sc_hd__diode_2
X_05388_ picorv32_core.reg_pc\[13\] picorv32_core.decoded_imm\[13\] VGND VGND VPWR
+ VPWR _01891_ sky130_fd_sc_hd__nand2_1
XANTENNA_87 net613 VGND VGND VPWR VPWR sky130_fd_sc_hd__diode_2
X_08176_ net1267 net522 _04181_ net2098 VGND VGND VPWR VPWR _00439_ sky130_fd_sc_hd__a22o_1
XFILLER_119_797 VPWR VGND VPWR VGND sky130_ef_sc_hd__decap_12
X_07127_ net2335 _03309_ _03311_ VGND VGND VPWR VPWR _00280_ sky130_fd_sc_hd__o21a_1
XFILLER_21_69 VPWR VGND VPWR VGND sky130_ef_sc_hd__decap_12
XFILLER_137_69 VPWR VGND VPWR VGND sky130_ef_sc_hd__decap_12
XTAP_TAPCELL_ROW_95_1689 VGND VPWR sky130_fd_sc_hd__tapvpwrvgnd_1
XTAP_TAPCELL_ROW_95_1678 VGND VPWR sky130_fd_sc_hd__tapvpwrvgnd_1
Xoutput161 net767 VGND VGND VPWR VPWR pcpi_rs1[28] sky130_fd_sc_hd__buf_2
Xoutput150 net786 VGND VGND VPWR VPWR pcpi_rs1[18] sky130_fd_sc_hd__buf_2
X_07058_ _02941_ _03248_ _02942_ VGND VGND VPWR VPWR _03264_ sky130_fd_sc_hd__a21oi_1
XFILLER_88_810 VGND VGND VPWR VPWR sky130_fd_sc_hd__fill_2
Xoutput194 net194 VGND VGND VPWR VPWR pcpi_rs2[29] sky130_fd_sc_hd__buf_2
Xoutput183 net183 VGND VGND VPWR VPWR pcpi_rs2[19] sky130_fd_sc_hd__buf_2
X_06009_ net781 _02471_ VGND VGND VPWR VPWR _02473_ sky130_fd_sc_hd__or2_1
Xoutput172 net804 VGND VGND VPWR VPWR pcpi_rs1[9] sky130_fd_sc_hd__buf_2
XFILLER_102_653 VGND VGND VPWR VPWR sky130_fd_sc_hd__decap_3
XFILLER_0_769 VGND VGND VPWR VPWR sky130_fd_sc_hd__decap_4
XFILLER_101_163 VGND VGND VPWR VPWR sky130_fd_sc_hd__decap_4
XTAP_TAPCELL_ROW_126_2133 VGND VPWR sky130_fd_sc_hd__tapvpwrvgnd_1
XFILLER_56_740 VGND VGND VPWR VPWR sky130_fd_sc_hd__decap_6
X_10971_ clknet_leaf_24_clk _00822_ VGND VGND VPWR VPWR picorv32_core.cpuregs\[13\]\[17\]
+ sky130_fd_sc_hd__dfxtp_1
XFILLER_16_615 VGND VGND VPWR VPWR sky130_fd_sc_hd__fill_1
XFILLER_83_581 VGND VGND VPWR VPWR sky130_fd_sc_hd__fill_1
XFILLER_71_754 VPWR VGND VPWR VGND sky130_ef_sc_hd__decap_12
XFILLER_70_253 VGND VGND VPWR VPWR sky130_fd_sc_hd__decap_3
XFILLER_43_467 VGND VGND VPWR VPWR sky130_fd_sc_hd__fill_2
XTAP_TAPCELL_ROW_26_676 VGND VPWR sky130_fd_sc_hd__tapvpwrvgnd_1
XTAP_TAPCELL_ROW_26_687 VGND VPWR sky130_fd_sc_hd__tapvpwrvgnd_1
XFILLER_8_825 VPWR VGND VPWR VGND sky130_ef_sc_hd__decap_12
X_11523_ clknet_leaf_111_clk _01354_ VGND VGND VPWR VPWR picorv32_core.cpuregs\[30\]\[4\]
+ sky130_fd_sc_hd__dfxtp_1
XTAP_TAPCELL_ROW_137_2295 VGND VPWR sky130_fd_sc_hd__tapvpwrvgnd_1
XFILLER_7_335 VGND VGND VPWR VPWR sky130_fd_sc_hd__fill_1
X_11454_ clknet_leaf_139_clk _01290_ VGND VGND VPWR VPWR picorv32_core.cpuregs\[24\]\[5\]
+ sky130_fd_sc_hd__dfxtp_1
XFILLER_109_274 VGND VGND VPWR VPWR sky130_fd_sc_hd__decap_6
X_10405_ clknet_leaf_77_clk _00324_ VGND VGND VPWR VPWR picorv32_core.count_cycle\[63\]
+ sky130_fd_sc_hd__dfxtp_1
XTAP_TAPCELL_ROW_55_1106 VGND VPWR sky130_fd_sc_hd__tapvpwrvgnd_1
X_11385_ clknet_leaf_134_clk _01221_ VGND VGND VPWR VPWR picorv32_core.cpuregs\[31\]\[0\]
+ sky130_fd_sc_hd__dfxtp_1
X_10336_ clknet_leaf_59_clk _00255_ VGND VGND VPWR VPWR picorv32_core.reg_next_pc\[26\]
+ sky130_fd_sc_hd__dfxtp_1
XFILLER_79_810 VGND VGND VPWR VPWR sky130_fd_sc_hd__fill_1
XFILLER_140_737 VPWR VGND VPWR VGND sky130_ef_sc_hd__decap_12
X_10267_ clknet_leaf_80_clk _00186_ VGND VGND VPWR VPWR picorv32_core.count_instr\[51\]
+ sky130_fd_sc_hd__dfxtp_1
XFILLER_3_596 VGND VGND VPWR VPWR sky130_fd_sc_hd__fill_1
Xclkbuf_4_9_0_clk clknet_0_clk VGND VGND VPWR VPWR clknet_4_9_0_clk sky130_fd_sc_hd__clkbuf_8
XFILLER_105_491 VPWR VGND VPWR VGND sky130_ef_sc_hd__decap_12
X_10198_ clknet_leaf_24_clk _00117_ VGND VGND VPWR VPWR picorv32_core.cpuregs\[9\]\[14\]
+ sky130_fd_sc_hd__dfxtp_1
XFILLER_93_345 VGND VGND VPWR VPWR sky130_fd_sc_hd__fill_1
XTAP_TAPCELL_ROW_6_390 VGND VPWR sky130_fd_sc_hd__tapvpwrvgnd_1
XFILLER_16_6 VPWR VGND VPWR VGND sky130_ef_sc_hd__decap_12
XTAP_TAPCELL_ROW_66_1268 VGND VPWR sky130_fd_sc_hd__tapvpwrvgnd_1
XTAP_TAPCELL_ROW_66_1257 VGND VPWR sky130_fd_sc_hd__tapvpwrvgnd_1
XTAP_TAPCELL_ROW_45_952 VGND VPWR sky130_fd_sc_hd__tapvpwrvgnd_1
XTAP_TAPCELL_ROW_45_963 VGND VPWR sky130_fd_sc_hd__tapvpwrvgnd_1
XFILLER_99_3 VPWR VGND VPWR VGND sky130_ef_sc_hd__decap_12
X_06360_ picorv32_core.reg_pc\[23\] _02755_ picorv32_core.reg_pc\[24\] VGND VGND VPWR
+ VPWR _02762_ sky130_fd_sc_hd__a21oi_1
X_05311_ net34 _01818_ VGND VGND VPWR VPWR _01819_ sky130_fd_sc_hd__or2_1
X_06291_ net1271 net295 net433 VGND VGND VPWR VPWR _00049_ sky130_fd_sc_hd__mux2_1
XFILLER_135_509 VGND VGND VPWR VPWR sky130_fd_sc_hd__fill_1
X_08030_ _04104_ _04106_ net459 _04103_ VGND VGND VPWR VPWR _04107_ sky130_fd_sc_hd__o211a_1
Xinput30 mem_axi_rdata[4] VGND VGND VPWR VPWR net30 sky130_fd_sc_hd__buf_1
X_05242_ _01753_ _01754_ _01752_ VGND VGND VPWR VPWR _01755_ sky130_fd_sc_hd__a21o_1
Xhold803 picorv32_core.cpuregs\[27\]\[30\] VGND VGND VPWR VPWR net1912 sky130_fd_sc_hd__dlygate4sd3_1
Xhold814 picorv32_core.cpuregs\[5\]\[20\] VGND VGND VPWR VPWR net1923 sky130_fd_sc_hd__dlygate4sd3_1
Xhold836 net63 VGND VGND VPWR VPWR net1945 sky130_fd_sc_hd__dlygate4sd3_1
Xhold825 picorv32_core.cpuregs\[22\]\[11\] VGND VGND VPWR VPWR net1934 sky130_fd_sc_hd__dlygate4sd3_1
X_05173_ _01682_ _01696_ _01678_ VGND VGND VPWR VPWR _01697_ sky130_fd_sc_hd__a21boi_1
Xhold847 picorv32_core.cpuregs\[23\]\[31\] VGND VGND VPWR VPWR net1956 sky130_fd_sc_hd__dlygate4sd3_1
Xhold869 picorv32_core.cpuregs\[10\]\[31\] VGND VGND VPWR VPWR net1978 sky130_fd_sc_hd__dlygate4sd3_1
Xhold858 picorv32_core.cpuregs\[8\]\[19\] VGND VGND VPWR VPWR net1967 sky130_fd_sc_hd__dlygate4sd3_1
XFILLER_89_607 VGND VGND VPWR VPWR sky130_fd_sc_hd__decap_8
X_09981_ net1424 net428 net313 VGND VGND VPWR VPWR _01458_ sky130_fd_sc_hd__mux2_1
XFILLER_69_320 VGND VGND VPWR VPWR sky130_fd_sc_hd__decap_3
X_08932_ net286 net1930 net354 VGND VGND VPWR VPWR _01105_ sky130_fd_sc_hd__mux2_1
XFILLER_111_472 VGND VGND VPWR VPWR sky130_fd_sc_hd__fill_2
X_08863_ net298 net1653 net362 VGND VGND VPWR VPWR _01038_ sky130_fd_sc_hd__mux2_1
XFILLER_123_27 VPWR VGND VPWR VGND sky130_ef_sc_hd__decap_12
X_07814_ picorv32_core.decoded_imm\[16\] net591 net596 VGND VGND VPWR VPWR _03903_
+ sky130_fd_sc_hd__a21o_1
X_08794_ net432 net2184 net370 VGND VGND VPWR VPWR _00972_ sky130_fd_sc_hd__mux2_1
X_07745_ _03836_ _03837_ net457 _03834_ VGND VGND VPWR VPWR _03838_ sky130_fd_sc_hd__o211a_1
X_07676_ picorv32_core.cpuregs\[24\]\[9\] picorv32_core.cpuregs\[25\]\[9\] picorv32_core.cpuregs\[26\]\[9\]
+ picorv32_core.cpuregs\[27\]\[9\] net731 net698 VGND VGND VPWR VPWR _03772_ sky130_fd_sc_hd__mux4_1
X_09415_ net836 _04602_ net642 VGND VGND VPWR VPWR _04604_ sky130_fd_sc_hd__o21a_1
XTAP_TAPCELL_ROW_121_2063 VGND VPWR sky130_fd_sc_hd__tapvpwrvgnd_1
X_06627_ _02898_ _02899_ VGND VGND VPWR VPWR _00192_ sky130_fd_sc_hd__nor2_1
XFILLER_12_106 VGND VGND VPWR VPWR sky130_fd_sc_hd__fill_2
X_06558_ _02854_ _02855_ VGND VGND VPWR VPWR _00167_ sky130_fd_sc_hd__nor2_1
XTAP_TAPCELL_ROW_23_635 VGND VPWR sky130_fd_sc_hd__tapvpwrvgnd_1
X_09346_ picorv32_core.cpuregs\[8\]\[7\] picorv32_core.cpuregs\[9\]\[7\] picorv32_core.cpuregs\[10\]\[7\]
+ picorv32_core.cpuregs\[11\]\[7\] net876 net843 VGND VGND VPWR VPWR _04538_ sky130_fd_sc_hd__mux4_1
XTAP_TAPCELL_ROW_97_1707 VGND VPWR sky130_fd_sc_hd__tapvpwrvgnd_1
X_05509_ net911 net302 _01999_ _02003_ VGND VGND VPWR VPWR _02004_ sky130_fd_sc_hd__a31o_1
X_06489_ _02810_ _02811_ VGND VGND VPWR VPWR _00142_ sky130_fd_sc_hd__nor2_1
X_09277_ picorv32_core.cpuregs\[28\]\[4\] picorv32_core.cpuregs\[29\]\[4\] picorv32_core.cpuregs\[30\]\[4\]
+ picorv32_core.cpuregs\[31\]\[4\] net887 net853 VGND VGND VPWR VPWR _04472_ sky130_fd_sc_hd__mux4_1
XTAP_TAPCELL_ROW_97_1718 VGND VPWR sky130_fd_sc_hd__tapvpwrvgnd_1
X_08228_ picorv32_core.mem_rdata_q\[3\] picorv32_core.mem_rdata_q\[4\] picorv32_core.mem_rdata_q\[5\]
+ picorv32_core.mem_rdata_q\[6\] VGND VGND VPWR VPWR _04215_ sky130_fd_sc_hd__nand4b_1
XFILLER_119_550 VGND VGND VPWR VPWR sky130_fd_sc_hd__fill_2
X_08159_ net931 net988 net531 VGND VGND VPWR VPWR _04185_ sky130_fd_sc_hd__and3_1
X_11170_ clknet_leaf_35_clk _01021_ VGND VGND VPWR VPWR picorv32_core.cpuregs\[7\]\[24\]
+ sky130_fd_sc_hd__dfxtp_1
X_10121_ clknet_leaf_121_clk _00043_ VGND VGND VPWR VPWR picorv32_core.cpuregs\[22\]\[4\]
+ sky130_fd_sc_hd__dfxtp_1
X_10052_ net1385 net277 net304 VGND VGND VPWR VPWR _01527_ sky130_fd_sc_hd__mux2_1
XFILLER_130_781 VPWR VGND VPWR VGND sky130_ef_sc_hd__decap_12
XTAP_TAPCELL_ROW_50_1036 VGND VPWR sky130_fd_sc_hd__tapvpwrvgnd_1
XTAP_TAPCELL_ROW_50_1025 VGND VPWR sky130_fd_sc_hd__tapvpwrvgnd_1
XFILLER_48_504 VPWR VGND VPWR VGND sky130_ef_sc_hd__decap_12
XFILLER_48_537 VGND VGND VPWR VPWR sky130_fd_sc_hd__fill_1
XTAP_TAPCELL_ROW_106_1836 VGND VPWR sky130_fd_sc_hd__tapvpwrvgnd_1
XFILLER_44_721 VGND VGND VPWR VPWR sky130_fd_sc_hd__fill_1
XFILLER_44_732 VGND VGND VPWR VPWR sky130_fd_sc_hd__fill_1
XTAP_TAPCELL_ROW_106_1847 VGND VPWR sky130_fd_sc_hd__tapvpwrvgnd_1
X_10954_ clknet_leaf_131_clk _00805_ VGND VGND VPWR VPWR picorv32_core.cpuregs\[13\]\[0\]
+ sky130_fd_sc_hd__dfxtp_1
X_10885_ clknet_leaf_67_clk _00736_ VGND VGND VPWR VPWR picorv32_core.cpuregs\[16\]\[29\]
+ sky130_fd_sc_hd__dfxtp_1
XFILLER_71_573 VGND VGND VPWR VPWR sky130_fd_sc_hd__decap_3
XTAP_TAPCELL_ROW_42_911 VGND VPWR sky130_fd_sc_hd__tapvpwrvgnd_1
XFILLER_43_275 VGND VGND VPWR VPWR sky130_fd_sc_hd__decap_4
XTAP_TAPCELL_ROW_139_2324 VGND VPWR sky130_fd_sc_hd__tapvpwrvgnd_1
XFILLER_31_437 VGND VGND VPWR VPWR sky130_fd_sc_hd__decap_4
X_11506_ clknet_leaf_57_clk _01342_ VGND VGND VPWR VPWR net156 sky130_fd_sc_hd__dfxtp_1
XTAP_TAPCELL_ROW_61_1187 VGND VPWR sky130_fd_sc_hd__tapvpwrvgnd_1
X_11437_ clknet_leaf_40_clk _01273_ VGND VGND VPWR VPWR picorv32_core.cpuregs\[1\]\[20\]
+ sky130_fd_sc_hd__dfxtp_1
XFILLER_8_699 VGND VGND VPWR VPWR sky130_fd_sc_hd__fill_1
XTAP_TAPCELL_ROW_117_1998 VGND VPWR sky130_fd_sc_hd__tapvpwrvgnd_1
X_11368_ clknet_leaf_40_clk _01209_ VGND VGND VPWR VPWR picorv32_core.cpuregs\[18\]\[20\]
+ sky130_fd_sc_hd__dfxtp_1
XFILLER_98_83 VGND VGND VPWR VPWR sky130_fd_sc_hd__fill_1
X_10319_ clknet_leaf_91_clk _00238_ VGND VGND VPWR VPWR picorv32_core.reg_next_pc\[9\]
+ sky130_fd_sc_hd__dfxtp_1
X_11299_ clknet_leaf_34_clk _01147_ VGND VGND VPWR VPWR picorv32_core.cpuregs\[3\]\[22\]
+ sky130_fd_sc_hd__dfxtp_1
XFILLER_94_621 VGND VGND VPWR VPWR sky130_fd_sc_hd__decap_4
X_05860_ _02334_ _02335_ VGND VGND VPWR VPWR _02336_ sky130_fd_sc_hd__nand2_1
XFILLER_39_559 VGND VGND VPWR VPWR sky130_fd_sc_hd__fill_1
XTAP_TAPCELL_ROW_1_319 VGND VPWR sky130_fd_sc_hd__tapvpwrvgnd_1
X_05791_ _02139_ net572 net606 VGND VGND VPWR VPWR _02273_ sky130_fd_sc_hd__a21o_1
X_07530_ picorv32_core.reg_out\[30\] picorv32_core.reg_next_pc\[30\] net559 VGND VGND
+ VPWR VPWR _03641_ sky130_fd_sc_hd__mux2_1
XFILLER_34_253 VGND VGND VPWR VPWR sky130_fd_sc_hd__fill_1
X_07461_ picorv32_core.reg_out\[7\] picorv32_core.reg_next_pc\[7\] net556 VGND VGND
+ VPWR VPWR _03595_ sky130_fd_sc_hd__mux2_1
X_07392_ _03403_ _03404_ VGND VGND VPWR VPWR _03532_ sky130_fd_sc_hd__and2b_1
XFILLER_50_757 VGND VGND VPWR VPWR sky130_fd_sc_hd__fill_1
X_06412_ net299 net1948 net422 VGND VGND VPWR VPWR _00080_ sky130_fd_sc_hd__mux2_1
X_09200_ _03459_ _03460_ _03461_ VGND VGND VPWR VPWR _04398_ sky130_fd_sc_hd__a21bo_1
X_06343_ picorv32_core.reg_out\[21\] picorv32_core.alu_out_q\[21\] net952 VGND VGND
+ VPWR VPWR _02748_ sky130_fd_sc_hd__mux2_1
X_09131_ net1563 net289 net329 VGND VGND VPWR VPWR _01297_ sky130_fd_sc_hd__mux2_1
X_09062_ net1567 net301 net336 VGND VGND VPWR VPWR _01230_ sky130_fd_sc_hd__mux2_1
XTAP_TAPCELL_ROW_79_1448 VGND VPWR sky130_fd_sc_hd__tapvpwrvgnd_1
X_06274_ picorv32_core.reg_pc\[7\] picorv32_core.reg_pc\[6\] _02685_ VGND VGND VPWR
+ VPWR _02693_ sky130_fd_sc_hd__and3_1
XFILLER_128_391 VGND VGND VPWR VPWR sky130_fd_sc_hd__decap_4
XFILLER_118_27 VGND VGND VPWR VPWR sky130_fd_sc_hd__fill_1
X_08013_ net192 net512 _04089_ _04090_ VGND VGND VPWR VPWR _00387_ sky130_fd_sc_hd__o22a_1
Xhold600 picorv32_core.cpuregs\[14\]\[24\] VGND VGND VPWR VPWR net1709 sky130_fd_sc_hd__dlygate4sd3_1
Xhold611 picorv32_core.cpuregs\[21\]\[16\] VGND VGND VPWR VPWR net1720 sky130_fd_sc_hd__dlygate4sd3_1
X_05225_ net22 net821 VGND VGND VPWR VPWR _01739_ sky130_fd_sc_hd__nand2b_1
Xhold633 picorv32_core.cpuregs\[12\]\[24\] VGND VGND VPWR VPWR net1742 sky130_fd_sc_hd__dlygate4sd3_1
Xhold622 picorv32_core.cpuregs\[12\]\[20\] VGND VGND VPWR VPWR net1731 sky130_fd_sc_hd__dlygate4sd3_1
Xhold644 picorv32_core.cpuregs\[18\]\[19\] VGND VGND VPWR VPWR net1753 sky130_fd_sc_hd__dlygate4sd3_1
XTAP_TAPCELL_ROW_92_1637 VGND VPWR sky130_fd_sc_hd__tapvpwrvgnd_1
X_05156_ picorv32_core.is_lui_auipc_jal picorv32_core.is_jalr_addi_slti_sltiu_xori_ori_andi
+ VGND VGND VPWR VPWR _01683_ sky130_fd_sc_hd__or2_4
Xmax_cap352 net353 VGND VGND VPWR VPWR net352 sky130_fd_sc_hd__clkbuf_2
Xhold688 picorv32_core.cpuregs\[29\]\[28\] VGND VGND VPWR VPWR net1797 sky130_fd_sc_hd__dlygate4sd3_1
Xhold666 picorv32_core.cpuregs\[14\]\[19\] VGND VGND VPWR VPWR net1775 sky130_fd_sc_hd__dlygate4sd3_1
Xhold677 picorv32_core.cpuregs\[13\]\[17\] VGND VGND VPWR VPWR net1786 sky130_fd_sc_hd__dlygate4sd3_1
Xhold655 picorv32_core.cpuregs\[18\]\[7\] VGND VGND VPWR VPWR net1764 sky130_fd_sc_hd__dlygate4sd3_1
XFILLER_134_15 VPWR VGND VPWR VGND sky130_ef_sc_hd__decap_12
X_09964_ net1339 net233 net318 VGND VGND VPWR VPWR _01442_ sky130_fd_sc_hd__mux2_1
Xhold699 picorv32_core.cpuregs\[5\]\[19\] VGND VGND VPWR VPWR net1808 sky130_fd_sc_hd__dlygate4sd3_1
X_05087_ axi_adapter.mem_instr VGND VGND VPWR VPWR _01622_ sky130_fd_sc_hd__inv_2
X_08915_ net220 net1911 net361 VGND VGND VPWR VPWR _01089_ sky130_fd_sc_hd__mux2_1
XFILLER_112_781 VPWR VGND VPWR VGND sky130_ef_sc_hd__decap_12
X_09895_ picorv32_core.mem_do_rdata picorv32_core.mem_do_rinst picorv32_core.mem_state\[1\]
+ picorv32_core.mem_state\[0\] VGND VGND VPWR VPWR _05031_ sky130_fd_sc_hd__or4b_1
X_08846_ net1538 net231 net368 VGND VGND VPWR VPWR _01022_ sky130_fd_sc_hd__mux2_1
XFILLER_94_19 VGND VGND VPWR VPWR sky130_fd_sc_hd__fill_1
XFILLER_57_356 VGND VGND VPWR VPWR sky130_fd_sc_hd__decap_3
XTAP_TAPCELL_ROW_28_705 VGND VPWR sky130_fd_sc_hd__tapvpwrvgnd_1
X_08777_ net236 net2215 net375 VGND VGND VPWR VPWR _00924_ sky130_fd_sc_hd__mux2_1
X_05989_ _02146_ net571 net609 VGND VGND VPWR VPWR _02455_ sky130_fd_sc_hd__a21o_1
XFILLER_27_57 VGND VGND VPWR VPWR sky130_fd_sc_hd__decap_4
XTAP_TAPCELL_ROW_28_716 VGND VPWR sky130_fd_sc_hd__tapvpwrvgnd_1
X_07728_ net175 net510 _03820_ _03821_ VGND VGND VPWR VPWR _00371_ sky130_fd_sc_hd__o22a_1
X_07659_ picorv32_core.cpuregs\[0\]\[8\] picorv32_core.cpuregs\[1\]\[8\] picorv32_core.cpuregs\[2\]\[8\]
+ picorv32_core.cpuregs\[3\]\[8\] net735 net702 VGND VGND VPWR VPWR _03756_ sky130_fd_sc_hd__mux4_1
XFILLER_41_702 VGND VGND VPWR VPWR sky130_fd_sc_hd__fill_2
XFILLER_43_23 VGND VGND VPWR VPWR sky130_fd_sc_hd__fill_1
X_10670_ clknet_leaf_83_clk _00524_ VGND VGND VPWR VPWR picorv32_core.decoded_imm_j\[16\]
+ sky130_fd_sc_hd__dfxtp_1
XTAP_TAPCELL_ROW_101_1766 VGND VPWR sky130_fd_sc_hd__tapvpwrvgnd_1
X_09329_ picorv32_core.reg_pc\[6\] net536 _04521_ net482 VGND VGND VPWR VPWR _04522_
+ sky130_fd_sc_hd__a211o_1
XFILLER_138_133 VGND VGND VPWR VPWR sky130_fd_sc_hd__decap_6
Xpicorv32_axi_1021 VGND VGND VPWR VPWR picorv32_axi_1021/HI eoi[22] sky130_fd_sc_hd__conb_1
XTAP_TAPCELL_ROW_134_2243 VGND VPWR sky130_fd_sc_hd__tapvpwrvgnd_1
Xpicorv32_axi_1010 VGND VGND VPWR VPWR picorv32_axi_1010/HI eoi[11] sky130_fd_sc_hd__conb_1
XTAP_TAPCELL_ROW_134_2254 VGND VPWR sky130_fd_sc_hd__tapvpwrvgnd_1
Xpicorv32_axi_1032 VGND VGND VPWR VPWR picorv32_axi_1032/HI mem_axi_araddr[1] sky130_fd_sc_hd__conb_1
Xpicorv32_axi_1054 VGND VGND VPWR VPWR picorv32_axi_1054/HI pcpi_insn[14] sky130_fd_sc_hd__conb_1
Xpicorv32_axi_1043 VGND VGND VPWR VPWR picorv32_axi_1043/HI pcpi_insn[3] sky130_fd_sc_hd__conb_1
XFILLER_141_309 VGND VGND VPWR VPWR sky130_fd_sc_hd__decap_3
Xpicorv32_axi_1076 VGND VGND VPWR VPWR picorv32_axi_1076/HI trace_data[3] sky130_fd_sc_hd__conb_1
X_11222_ clknet_leaf_6_clk _01073_ VGND VGND VPWR VPWR picorv32_core.cpuregs\[5\]\[12\]
+ sky130_fd_sc_hd__dfxtp_1
Xpicorv32_axi_1087 VGND VGND VPWR VPWR picorv32_axi_1087/HI trace_data[14] sky130_fd_sc_hd__conb_1
Xpicorv32_axi_1098 VGND VGND VPWR VPWR picorv32_axi_1098/HI trace_data[25] sky130_fd_sc_hd__conb_1
Xpicorv32_axi_1065 VGND VGND VPWR VPWR picorv32_axi_1065/HI pcpi_insn[25] sky130_fd_sc_hd__conb_1
XFILLER_134_361 VGND VGND VPWR VPWR sky130_fd_sc_hd__decap_3
XFILLER_107_575 VGND VGND VPWR VPWR sky130_fd_sc_hd__decap_3
X_11153_ clknet_leaf_140_clk _01004_ VGND VGND VPWR VPWR picorv32_core.cpuregs\[7\]\[7\]
+ sky130_fd_sc_hd__dfxtp_1
XFILLER_122_589 VGND VGND VPWR VPWR sky130_fd_sc_hd__decap_4
X_10104_ net1135 VGND VGND VPWR VPWR _00954_ sky130_fd_sc_hd__clkbuf_1
X_11084_ clknet_leaf_135_clk _00935_ VGND VGND VPWR VPWR picorv32_core.cpuregs\[0\]\[2\]
+ sky130_fd_sc_hd__dfxtp_1
X_10035_ net1418 net214 net311 VGND VGND VPWR VPWR _01511_ sky130_fd_sc_hd__mux2_1
XFILLER_88_492 VPWR VGND VPWR VGND sky130_ef_sc_hd__decap_12
XFILLER_0_385 VGND VGND VPWR VPWR sky130_fd_sc_hd__decap_3
XFILLER_84_41 VGND VGND VPWR VPWR sky130_fd_sc_hd__decap_4
XFILLER_64_805 VGND VGND VPWR VPWR sky130_fd_sc_hd__fill_1
XFILLER_36_518 VPWR VGND VPWR VGND sky130_ef_sc_hd__decap_12
XFILLER_76_698 VGND VGND VPWR VPWR sky130_fd_sc_hd__fill_2
XFILLER_63_337 VGND VGND VPWR VPWR sky130_fd_sc_hd__fill_1
XFILLER_91_679 VGND VGND VPWR VPWR sky130_fd_sc_hd__fill_2
XFILLER_17_765 VPWR VGND VPWR VGND sky130_ef_sc_hd__decap_12
XFILLER_44_551 VGND VGND VPWR VPWR sky130_fd_sc_hd__decap_8
X_10937_ clknet_leaf_19_clk _00788_ VGND VGND VPWR VPWR picorv32_core.cpuregs\[19\]\[15\]
+ sky130_fd_sc_hd__dfxtp_1
XTAP_TAPCELL_ROW_63_1216 VGND VPWR sky130_fd_sc_hd__tapvpwrvgnd_1
XFILLER_16_253 VGND VGND VPWR VPWR sky130_fd_sc_hd__fill_1
XFILLER_44_584 VGND VGND VPWR VPWR sky130_fd_sc_hd__decap_4
XFILLER_32_757 VGND VGND VPWR VPWR sky130_fd_sc_hd__fill_2
X_10868_ clknet_leaf_5_clk _00719_ VGND VGND VPWR VPWR picorv32_core.cpuregs\[16\]\[12\]
+ sky130_fd_sc_hd__dfxtp_1
X_10799_ clknet_leaf_12_clk _00650_ VGND VGND VPWR VPWR picorv32_core.cpuregs\[15\]\[8\]
+ sky130_fd_sc_hd__dfxtp_1
XFILLER_141_832 VGND VGND VPWR VPWR sky130_fd_sc_hd__fill_1
Xfanout409 _04323_ VGND VGND VPWR VPWR net409 sky130_fd_sc_hd__buf_4
XTAP_TAPCELL_ROW_74_1378 VGND VPWR sky130_fd_sc_hd__tapvpwrvgnd_1
XFILLER_100_217 VGND VGND VPWR VPWR sky130_fd_sc_hd__fill_1
X_06961_ net667 picorv32_core.reg_next_pc\[21\] _02933_ net490 VGND VGND VPWR VPWR
+ _03176_ sky130_fd_sc_hd__a22o_1
XFILLER_86_418 VGND VGND VPWR VPWR sky130_fd_sc_hd__fill_2
X_09680_ net657 _04856_ VGND VGND VPWR VPWR _04857_ sky130_fd_sc_hd__or2_1
XFILLER_100_239 VGND VGND VPWR VPWR sky130_fd_sc_hd__decap_4
X_05912_ _02383_ VGND VGND VPWR VPWR _02384_ sky130_fd_sc_hd__inv_2
X_08700_ net1496 net288 net383 VGND VGND VPWR VPWR _00849_ sky130_fd_sc_hd__mux2_1
XFILLER_104_29 VGND VGND VPWR VPWR sky130_fd_sc_hd__decap_6
X_06892_ _02928_ _03102_ VGND VGND VPWR VPWR _03112_ sky130_fd_sc_hd__nor2_1
X_08631_ net1237 net298 net390 VGND VGND VPWR VPWR _00782_ sky130_fd_sc_hd__mux2_1
X_05843_ net962 _02319_ VGND VGND VPWR VPWR _02320_ sky130_fd_sc_hd__xnor2_1
XFILLER_70_808 VGND VGND VPWR VPWR sky130_fd_sc_hd__fill_1
X_08562_ net276 net1774 net398 VGND VGND VPWR VPWR _00687_ sky130_fd_sc_hd__mux2_1
XFILLER_54_348 VGND VGND VPWR VPWR sky130_fd_sc_hd__fill_1
X_05774_ picorv32_core.instr_sub picorv32_core.mem_la_wdata\[0\] VGND VGND VPWR VPWR
+ _02257_ sky130_fd_sc_hd__and2b_1
X_07513_ net774 _03629_ net535 VGND VGND VPWR VPWR _03630_ sky130_fd_sc_hd__mux2_1
X_08493_ net1558 net278 net406 VGND VGND VPWR VPWR _00623_ sky130_fd_sc_hd__mux2_1
XFILLER_22_234 VGND VGND VPWR VPWR sky130_fd_sc_hd__fill_1
X_07444_ net973 net205 VGND VGND VPWR VPWR _03583_ sky130_fd_sc_hd__or2_2
XFILLER_13_15 VPWR VGND VPWR VGND sky130_ef_sc_hd__decap_12
XFILLER_129_15 VPWR VGND VPWR VGND sky130_ef_sc_hd__decap_12
X_07375_ _03419_ _03514_ VGND VGND VPWR VPWR _03515_ sky130_fd_sc_hd__nand2_1
XFILLER_50_598 VGND VGND VPWR VPWR sky130_fd_sc_hd__decap_6
XTAP_TAPCELL_ROW_33_785 VGND VPWR sky130_fd_sc_hd__tapvpwrvgnd_1
X_09114_ net220 net2050 net335 VGND VGND VPWR VPWR _01281_ sky130_fd_sc_hd__mux2_1
X_06326_ _02733_ _02734_ VGND VGND VPWR VPWR _02735_ sky130_fd_sc_hd__nor2_1
X_09045_ net229 net1806 net343 VGND VGND VPWR VPWR _01214_ sky130_fd_sc_hd__mux2_1
X_06257_ picorv32_core.reg_pc\[4\] picorv32_core.reg_pc\[3\] picorv32_core.reg_pc\[2\]
+ VGND VGND VPWR VPWR _02679_ sky130_fd_sc_hd__and3_1
X_05208_ picorv32_core.count_instr\[0\] net939 net943 picorv32_core.count_cycle\[32\]
+ VGND VGND VPWR VPWR _01724_ sky130_fd_sc_hd__a22o_1
Xhold452 picorv32_core.cpuregs\[27\]\[23\] VGND VGND VPWR VPWR net1561 sky130_fd_sc_hd__dlygate4sd3_1
XFILLER_104_512 VGND VGND VPWR VPWR sky130_fd_sc_hd__decap_4
X_06188_ net683 _02615_ _02619_ _02605_ _02609_ VGND VGND VPWR VPWR _02620_ sky130_fd_sc_hd__a32o_1
XFILLER_1_105 VGND VGND VPWR VPWR sky130_fd_sc_hd__decap_6
Xhold430 picorv32_core.cpuregs\[19\]\[6\] VGND VGND VPWR VPWR net1539 sky130_fd_sc_hd__dlygate4sd3_1
Xhold463 picorv32_core.cpuregs\[24\]\[9\] VGND VGND VPWR VPWR net1572 sky130_fd_sc_hd__dlygate4sd3_1
Xhold441 picorv32_core.cpuregs\[23\]\[8\] VGND VGND VPWR VPWR net1550 sky130_fd_sc_hd__dlygate4sd3_1
Xhold474 picorv32_core.cpuregs\[31\]\[25\] VGND VGND VPWR VPWR net1583 sky130_fd_sc_hd__dlygate4sd3_1
XFILLER_89_234 VGND VGND VPWR VPWR sky130_fd_sc_hd__fill_1
XFILLER_1_149 VPWR VGND VPWR VGND sky130_ef_sc_hd__decap_12
Xhold496 picorv32_core.cpuregs\[30\]\[1\] VGND VGND VPWR VPWR net1605 sky130_fd_sc_hd__dlygate4sd3_1
Xhold485 picorv32_core.cpuregs\[30\]\[9\] VGND VGND VPWR VPWR net1594 sky130_fd_sc_hd__dlygate4sd3_1
X_05139_ net925 net824 picorv32_core.mem_wordsize\[0\] VGND VGND VPWR VPWR _01669_
+ sky130_fd_sc_hd__a21o_1
Xfanout932 net933 VGND VGND VPWR VPWR net932 sky130_fd_sc_hd__buf_2
Xfanout910 net912 VGND VGND VPWR VPWR net910 sky130_fd_sc_hd__clkbuf_4
Xfanout943 picorv32_core.instr_rdcycleh VGND VGND VPWR VPWR net943 sky130_fd_sc_hd__buf_2
X_09947_ net1522 net430 net316 VGND VGND VPWR VPWR _01425_ sky130_fd_sc_hd__mux2_1
Xfanout921 picorv32_core.cpu_state\[3\] VGND VGND VPWR VPWR net921 sky130_fd_sc_hd__clkbuf_4
XFILLER_131_397 VGND VGND VPWR VPWR sky130_fd_sc_hd__fill_1
Xfanout954 net194 VGND VGND VPWR VPWR net954 sky130_fd_sc_hd__clkbuf_4
Xfanout976 net978 VGND VGND VPWR VPWR net976 sky130_fd_sc_hd__buf_2
XFILLER_58_643 VGND VGND VPWR VPWR sky130_fd_sc_hd__fill_1
Xfanout965 picorv32_core.mem_la_wdata\[4\] VGND VGND VPWR VPWR net965 sky130_fd_sc_hd__clkbuf_4
Xhold1130 picorv32_core.cpuregs\[16\]\[21\] VGND VGND VPWR VPWR net2239 sky130_fd_sc_hd__dlygate4sd3_1
Xfanout998 net38 VGND VGND VPWR VPWR net998 sky130_fd_sc_hd__clkbuf_2
Xhold1141 picorv32_core.count_instr\[23\] VGND VGND VPWR VPWR net2250 sky130_fd_sc_hd__dlygate4sd3_1
X_09878_ net1376 net265 net326 VGND VGND VPWR VPWR _01366_ sky130_fd_sc_hd__mux2_1
Xfanout987 net988 VGND VGND VPWR VPWR net987 sky130_fd_sc_hd__dlymetal6s2s_1
Xhold1163 picorv32_core.count_instr\[58\] VGND VGND VPWR VPWR net2272 sky130_fd_sc_hd__dlygate4sd3_1
XFILLER_73_624 VPWR VGND VPWR VGND sky130_ef_sc_hd__decap_12
Xhold1152 picorv32_core.count_cycle\[12\] VGND VGND VPWR VPWR net2261 sky130_fd_sc_hd__dlygate4sd3_1
Xhold1185 picorv32_core.instr_rdcycle VGND VGND VPWR VPWR net2294 sky130_fd_sc_hd__dlygate4sd3_1
XFILLER_57_164 VGND VGND VPWR VPWR sky130_fd_sc_hd__decap_4
Xhold1174 picorv32_core.instr_srl VGND VGND VPWR VPWR net2283 sky130_fd_sc_hd__dlygate4sd3_1
X_08829_ net1831 net427 net366 VGND VGND VPWR VPWR _01005_ sky130_fd_sc_hd__mux2_1
XFILLER_45_326 VGND VGND VPWR VPWR sky130_fd_sc_hd__fill_1
Xhold1196 picorv32_core.count_instr\[61\] VGND VGND VPWR VPWR net2305 sky130_fd_sc_hd__dlygate4sd3_1
X_11840_ net43 VGND VGND VPWR VPWR net75 sky130_fd_sc_hd__clkbuf_1
XFILLER_14_713 VPWR VGND VPWR VGND sky130_ef_sc_hd__decap_12
XFILLER_14_757 VPWR VGND VPWR VGND sky130_ef_sc_hd__decap_12
X_10722_ clknet_leaf_108_clk _00573_ VGND VGND VPWR VPWR axi_adapter.mem_instr sky130_fd_sc_hd__dfxtp_1
X_10653_ clknet_leaf_48_clk _00507_ VGND VGND VPWR VPWR picorv32_core.cpuregs\[20\]\[21\]
+ sky130_fd_sc_hd__dfxtp_1
XFILLER_110_72 VGND VGND VPWR VPWR sky130_fd_sc_hd__decap_3
X_10584_ clknet_leaf_98_clk _00438_ VGND VGND VPWR VPWR picorv32_core.instr_jalr sky130_fd_sc_hd__dfxtp_1
XFILLER_126_114 VGND VGND VPWR VPWR sky130_fd_sc_hd__decap_3
XTAP_TAPCELL_ROW_11_468 VGND VPWR sky130_fd_sc_hd__tapvpwrvgnd_1
Xclkload19 clknet_leaf_144_clk VGND VGND VPWR VPWR clkload19/Y sky130_fd_sc_hd__clkinv_4
XFILLER_114_309 VGND VGND VPWR VPWR sky130_fd_sc_hd__fill_1
XTAP_TAPCELL_ROW_114_1957 VGND VPWR sky130_fd_sc_hd__tapvpwrvgnd_1
X_11205_ clknet_leaf_37_clk _01056_ VGND VGND VPWR VPWR picorv32_core.cpuregs\[6\]\[27\]
+ sky130_fd_sc_hd__dfxtp_1
XPHY_EDGE_ROW_79_Left_221 VGND VGND VPWR VPWR sky130_fd_sc_hd__decap_3
X_11136_ clknet_leaf_32_clk _00987_ VGND VGND VPWR VPWR picorv32_core.cpuregs\[8\]\[22\]
+ sky130_fd_sc_hd__dfxtp_1
XFILLER_110_526 VGND VGND VPWR VPWR sky130_fd_sc_hd__decap_3
XFILLER_49_610 VGND VGND VPWR VPWR sky130_fd_sc_hd__decap_6
XFILLER_95_73 VGND VGND VPWR VPWR sky130_fd_sc_hd__fill_1
X_11067_ clknet_leaf_25_clk _00918_ VGND VGND VPWR VPWR picorv32_core.cpuregs\[10\]\[17\]
+ sky130_fd_sc_hd__dfxtp_1
XFILLER_76_462 VGND VGND VPWR VPWR sky130_fd_sc_hd__decap_6
XFILLER_49_665 VGND VGND VPWR VPWR sky130_fd_sc_hd__fill_2
XFILLER_0_193 VGND VGND VPWR VPWR sky130_fd_sc_hd__decap_3
XFILLER_76_473 VGND VGND VPWR VPWR sky130_fd_sc_hd__decap_3
X_10018_ net1243 net288 net308 VGND VGND VPWR VPWR _01494_ sky130_fd_sc_hd__mux2_1
XFILLER_36_337 VGND VGND VPWR VPWR sky130_fd_sc_hd__fill_2
XTAP_TAPCELL_ROW_19_579 VGND VPWR sky130_fd_sc_hd__tapvpwrvgnd_1
XPHY_EDGE_ROW_88_Left_230 VGND VGND VPWR VPWR sky130_fd_sc_hd__decap_3
Xclkbuf_leaf_137_clk clknet_4_2_0_clk VGND VGND VPWR VPWR clknet_leaf_137_clk sky130_fd_sc_hd__clkbuf_8
XFILLER_44_381 VPWR VGND VPWR VGND sky130_ef_sc_hd__decap_12
X_05490_ _01980_ _01984_ VGND VGND VPWR VPWR _01986_ sky130_fd_sc_hd__or2_1
XFILLER_20_738 VPWR VGND VPWR VGND sky130_ef_sc_hd__decap_12
XFILLER_118_604 VGND VGND VPWR VPWR sky130_fd_sc_hd__decap_6
X_07160_ picorv32_core.count_cycle\[31\] _03329_ picorv32_core.count_cycle\[32\] VGND
+ VGND VPWR VPWR _03332_ sky130_fd_sc_hd__a21o_1
XTAP_TAPCELL_ROW_30_733 VGND VPWR sky130_fd_sc_hd__tapvpwrvgnd_1
XTAP_TAPCELL_ROW_30_744 VGND VPWR sky130_fd_sc_hd__tapvpwrvgnd_1
X_06111_ net192 _02550_ net670 VGND VGND VPWR VPWR _02567_ sky130_fd_sc_hd__o21a_1
XTAP_TAPCELL_ROW_76_1407 VGND VPWR sky130_fd_sc_hd__tapvpwrvgnd_1
XFILLER_9_783 VGND VGND VPWR VPWR sky130_fd_sc_hd__fill_1
X_07091_ picorv32_core.count_cycle\[4\] picorv32_core.count_cycle\[5\] picorv32_core.count_cycle\[6\]
+ _03284_ VGND VGND VPWR VPWR _03289_ sky130_fd_sc_hd__and4_1
X_06042_ _02174_ net571 net608 VGND VGND VPWR VPWR _02504_ sky130_fd_sc_hd__a21o_1
XFILLER_99_521 VGND VGND VPWR VPWR sky130_fd_sc_hd__fill_1
Xfanout217 _02781_ VGND VGND VPWR VPWR net217 sky130_fd_sc_hd__clkbuf_2
Xfanout228 _02770_ VGND VGND VPWR VPWR net228 sky130_fd_sc_hd__clkbuf_2
Xfanout206 net209 VGND VGND VPWR VPWR net206 sky130_fd_sc_hd__clkbuf_2
X_09801_ _01599_ net549 VGND VGND VPWR VPWR _04972_ sky130_fd_sc_hd__nand2_1
XFILLER_5_93 VPWR VGND VPWR VGND sky130_ef_sc_hd__decap_12
Xfanout239 _02760_ VGND VGND VPWR VPWR net239 sky130_fd_sc_hd__clkbuf_1
X_07993_ net697 _04067_ _04066_ net622 VGND VGND VPWR VPWR _04072_ sky130_fd_sc_hd__o211a_1
XFILLER_101_526 VGND VGND VPWR VPWR sky130_fd_sc_hd__fill_1
X_09732_ _03528_ _03533_ VGND VGND VPWR VPWR _04906_ sky130_fd_sc_hd__xnor2_1
X_06944_ _03155_ _03156_ _03159_ VGND VGND VPWR VPWR _03160_ sky130_fd_sc_hd__a21bo_1
XFILLER_55_602 VGND VGND VPWR VPWR sky130_fd_sc_hd__decap_4
XFILLER_28_805 VGND VGND VPWR VPWR sky130_fd_sc_hd__decap_6
X_09663_ net833 _04837_ _04840_ net480 VGND VGND VPWR VPWR _04841_ sky130_fd_sc_hd__o211a_1
XFILLER_95_771 VGND VGND VPWR VPWR sky130_fd_sc_hd__decap_4
X_06875_ _03069_ _03081_ _03082_ VGND VGND VPWR VPWR _03096_ sky130_fd_sc_hd__and3_1
XFILLER_39_164 VGND VGND VPWR VPWR sky130_fd_sc_hd__decap_4
X_08614_ net212 net1845 net397 VGND VGND VPWR VPWR _00737_ sky130_fd_sc_hd__mux2_1
XFILLER_131_27 VPWR VGND VPWR VGND sky130_ef_sc_hd__decap_12
XTAP_TAPCELL_ROW_87_1569 VGND VPWR sky130_fd_sc_hd__tapvpwrvgnd_1
X_09594_ net838 _04765_ net828 VGND VGND VPWR VPWR _04775_ sky130_fd_sc_hd__o21a_1
XFILLER_27_337 VGND VGND VPWR VPWR sky130_fd_sc_hd__fill_1
X_05826_ _02299_ _02301_ _02304_ VGND VGND VPWR VPWR picorv32_core.alu_out\[5\] sky130_fd_sc_hd__a21o_1
XTAP_TAPCELL_ROW_38_855 VGND VPWR sky130_fd_sc_hd__tapvpwrvgnd_1
X_08545_ net1397 net210 net405 VGND VGND VPWR VPWR _00672_ sky130_fd_sc_hd__mux2_1
XFILLER_70_616 VGND VGND VPWR VPWR sky130_fd_sc_hd__fill_1
XFILLER_42_307 VGND VGND VPWR VPWR sky130_fd_sc_hd__fill_1
X_05757_ picorv32_core.instr_bne _02240_ _02203_ VGND VGND VPWR VPWR _02241_ sky130_fd_sc_hd__o21ai_1
Xclkbuf_leaf_128_clk clknet_4_3_0_clk VGND VGND VPWR VPWR clknet_leaf_128_clk sky130_fd_sc_hd__clkbuf_8
X_05688_ _02170_ _02171_ VGND VGND VPWR VPWR _02172_ sky130_fd_sc_hd__and2_1
XFILLER_23_554 VGND VGND VPWR VPWR sky130_fd_sc_hd__decap_6
X_08476_ net675 picorv32_core.decoded_imm_j\[1\] _04282_ picorv32_core.mem_rdata_q\[8\]
+ net525 VGND VGND VPWR VPWR _04321_ sky130_fd_sc_hd__a221o_1
X_07427_ net904 picorv32_core.cpuregs\[23\]\[31\] net869 VGND VGND VPWR VPWR _03567_
+ sky130_fd_sc_hd__a21bo_1
XTAP_TAPCELL_ROW_118_2013 VGND VPWR sky130_fd_sc_hd__tapvpwrvgnd_1
XFILLER_23_576 VGND VGND VPWR VPWR sky130_fd_sc_hd__fill_2
X_07358_ _03494_ _03496_ _03497_ VGND VGND VPWR VPWR _03498_ sky130_fd_sc_hd__a21oi_1
X_06309_ picorv32_core.reg_out\[14\] picorv32_core.alu_out_q\[14\] net952 VGND VGND
+ VPWR VPWR _02721_ sky130_fd_sc_hd__mux2_1
XTAP_TAPCELL_ROW_131_2202 VGND VPWR sky130_fd_sc_hd__tapvpwrvgnd_1
X_07289_ net795 picorv32_core.decoded_imm\[13\] VGND VGND VPWR VPWR _03429_ sky130_fd_sc_hd__nand2_1
X_09028_ net427 net1960 net340 VGND VGND VPWR VPWR _01197_ sky130_fd_sc_hd__mux2_1
Xhold260 picorv32_core.cpuregs\[30\]\[29\] VGND VGND VPWR VPWR net1369 sky130_fd_sc_hd__dlygate4sd3_1
Xhold271 picorv32_core.cpuregs\[11\]\[11\] VGND VGND VPWR VPWR net1380 sky130_fd_sc_hd__dlygate4sd3_1
XFILLER_120_813 VPWR VGND VPWR VGND sky130_ef_sc_hd__decap_12
Xhold293 picorv32_core.cpuregs\[24\]\[19\] VGND VGND VPWR VPWR net1402 sky130_fd_sc_hd__dlygate4sd3_1
XFILLER_78_727 VGND VGND VPWR VPWR sky130_fd_sc_hd__fill_1
Xhold282 picorv32_core.cpuregs\[25\]\[15\] VGND VGND VPWR VPWR net1391 sky130_fd_sc_hd__dlygate4sd3_1
XFILLER_49_44 VGND VGND VPWR VPWR sky130_fd_sc_hd__fill_1
Xfanout751 net758 VGND VGND VPWR VPWR net751 sky130_fd_sc_hd__buf_4
Xfanout740 net741 VGND VGND VPWR VPWR net740 sky130_fd_sc_hd__clkbuf_4
XTAP_TAPCELL_ROW_129_2175 VGND VPWR sky130_fd_sc_hd__tapvpwrvgnd_1
Xfanout762 net763 VGND VGND VPWR VPWR net762 sky130_fd_sc_hd__buf_4
Xfanout773 net774 VGND VGND VPWR VPWR net773 sky130_fd_sc_hd__buf_2
Xfanout784 net151 VGND VGND VPWR VPWR net784 sky130_fd_sc_hd__clkbuf_4
XFILLER_92_218 VGND VGND VPWR VPWR sky130_fd_sc_hd__fill_1
Xfanout795 net796 VGND VGND VPWR VPWR net795 sky130_fd_sc_hd__clkbuf_2
XFILLER_45_167 VGND VGND VPWR VPWR sky130_fd_sc_hd__fill_1
XFILLER_60_137 VGND VGND VPWR VPWR sky130_fd_sc_hd__decap_3
XTAP_TAPCELL_ROW_16_538 VGND VPWR sky130_fd_sc_hd__tapvpwrvgnd_1
Xclkbuf_leaf_119_clk clknet_4_8_0_clk VGND VGND VPWR VPWR clknet_leaf_119_clk sky130_fd_sc_hd__clkbuf_8
XFILLER_121_82 VGND VGND VPWR VPWR sky130_fd_sc_hd__fill_1
X_10705_ clknet_leaf_26_clk _00556_ VGND VGND VPWR VPWR net110 sky130_fd_sc_hd__dfxtp_1
X_11685_ clknet_leaf_131_clk _01516_ VGND VGND VPWR VPWR picorv32_core.cpuregs\[27\]\[2\]
+ sky130_fd_sc_hd__dfxtp_1
X_10636_ clknet_leaf_113_clk _00490_ VGND VGND VPWR VPWR picorv32_core.cpuregs\[20\]\[4\]
+ sky130_fd_sc_hd__dfxtp_1
Xclkload119 clknet_leaf_60_clk VGND VGND VPWR VPWR clkload119/Y sky130_fd_sc_hd__clkinv_2
Xclkload108 clknet_leaf_100_clk VGND VGND VPWR VPWR clkload108/Y sky130_fd_sc_hd__clkinv_2
X_10567_ clknet_leaf_46_clk _00421_ VGND VGND VPWR VPWR picorv32_core.cpuregs\[25\]\[23\]
+ sky130_fd_sc_hd__dfxtp_1
XFILLER_10_793 VPWR VGND VPWR VGND sky130_ef_sc_hd__decap_12
XFILLER_108_670 VGND VGND VPWR VPWR sky130_fd_sc_hd__decap_8
X_10498_ clknet_leaf_48_clk _00384_ VGND VGND VPWR VPWR net189 sky130_fd_sc_hd__dfxtp_2
XTAP_TAPCELL_ROW_58_1148 VGND VPWR sky130_fd_sc_hd__tapvpwrvgnd_1
XFILLER_122_150 VGND VGND VPWR VPWR sky130_fd_sc_hd__fill_1
XTAP_TAPCELL_ROW_71_1337 VGND VPWR sky130_fd_sc_hd__tapvpwrvgnd_1
X_11119_ clknet_leaf_138_clk _00970_ VGND VGND VPWR VPWR picorv32_core.cpuregs\[8\]\[5\]
+ sky130_fd_sc_hd__dfxtp_1
XFILLER_64_410 VGND VGND VPWR VPWR sky130_fd_sc_hd__decap_8
XFILLER_49_484 VGND VGND VPWR VPWR sky130_fd_sc_hd__decap_6
Xinput6 mem_axi_rdata[11] VGND VGND VPWR VPWR net6 sky130_fd_sc_hd__dlymetal6s2s_1
XFILLER_37_657 VGND VGND VPWR VPWR sky130_fd_sc_hd__fill_2
X_06660_ picorv32_core.reg_pc\[7\] net551 _02919_ net514 VGND VGND VPWR VPWR _00205_
+ sky130_fd_sc_hd__a22o_1
X_05611_ picorv32_core.count_instr\[29\] net942 net603 _02097_ VGND VGND VPWR VPWR
+ _02098_ sky130_fd_sc_hd__a211o_1
XTAP_TAPCELL_ROW_35_814 VGND VPWR sky130_fd_sc_hd__tapvpwrvgnd_1
X_06591_ picorv32_core.count_instr\[45\] _02874_ net976 VGND VGND VPWR VPWR _02876_
+ sky130_fd_sc_hd__a21oi_1
XTAP_TAPCELL_ROW_69_1299 VGND VPWR sky130_fd_sc_hd__tapvpwrvgnd_1
XFILLER_51_126 VGND VGND VPWR VPWR sky130_fd_sc_hd__decap_4
XFILLER_45_690 VGND VGND VPWR VPWR sky130_fd_sc_hd__decap_8
X_05542_ _02030_ _02033_ VGND VGND VPWR VPWR _02034_ sky130_fd_sc_hd__nand2_1
X_08330_ net963 net1171 net453 VGND VGND VPWR VPWR _00547_ sky130_fd_sc_hd__mux2_1
X_05473_ _01957_ _01958_ _01956_ VGND VGND VPWR VPWR _01970_ sky130_fd_sc_hd__a21o_1
XTAP_TAPCELL_ROW_82_1499 VGND VPWR sky130_fd_sc_hd__tapvpwrvgnd_1
XTAP_TAPCELL_ROW_82_1488 VGND VPWR sky130_fd_sc_hd__tapvpwrvgnd_1
X_08261_ _02664_ _04225_ VGND VGND VPWR VPWR _04226_ sky130_fd_sc_hd__nor2_4
X_07212_ picorv32_core.count_cycle\[49\] picorv32_core.count_cycle\[50\] picorv32_core.count_cycle\[51\]
+ _03359_ VGND VGND VPWR VPWR _03365_ sky130_fd_sc_hd__and4_1
X_08192_ picorv32_core.instr_xori net475 _04186_ _04199_ VGND VGND VPWR VPWR _00447_
+ sky130_fd_sc_hd__a22o_1
XFILLER_118_456 VGND VGND VPWR VPWR sky130_fd_sc_hd__decap_4
X_07143_ net2327 _03319_ _03321_ VGND VGND VPWR VPWR _00286_ sky130_fd_sc_hd__o21a_1
X_07074_ picorv32_core.reg_next_pc\[31\] net666 _02943_ net489 VGND VGND VPWR VPWR
+ _03279_ sky130_fd_sc_hd__a22o_1
XFILLER_106_629 VGND VGND VPWR VPWR sky130_fd_sc_hd__fill_1
XFILLER_126_27 VGND VGND VPWR VPWR sky130_fd_sc_hd__fill_1
X_06025_ _02487_ VGND VGND VPWR VPWR _02488_ sky130_fd_sc_hd__inv_2
XFILLER_87_502 VGND VGND VPWR VPWR sky130_fd_sc_hd__fill_2
X_07976_ _04052_ _04053_ _04055_ _04054_ net690 net686 VGND VGND VPWR VPWR _04056_
+ sky130_fd_sc_hd__mux4_2
X_09715_ net776 net543 _04824_ net470 VGND VGND VPWR VPWR _04890_ sky130_fd_sc_hd__o211a_1
X_06927_ _03120_ _03131_ VGND VGND VPWR VPWR _03144_ sky130_fd_sc_hd__nand2_1
XFILLER_19_69 VPWR VGND VPWR VGND sky130_ef_sc_hd__decap_12
X_09646_ net771 net547 VGND VGND VPWR VPWR _04824_ sky130_fd_sc_hd__or2_1
X_06858_ _03078_ _03080_ net989 VGND VGND VPWR VPWR _00242_ sky130_fd_sc_hd__o21a_1
XFILLER_55_454 VGND VGND VPWR VPWR sky130_fd_sc_hd__decap_8
X_09577_ _03508_ _03503_ _03507_ VGND VGND VPWR VPWR _04758_ sky130_fd_sc_hd__or3b_1
XFILLER_70_413 VGND VGND VPWR VPWR sky130_fd_sc_hd__decap_6
X_06789_ picorv32_core.decoded_imm_j\[8\] _02920_ VGND VGND VPWR VPWR _03017_ sky130_fd_sc_hd__or2_1
X_05809_ net813 _02287_ VGND VGND VPWR VPWR _02289_ sky130_fd_sc_hd__xor2_1
XFILLER_70_446 VGND VGND VPWR VPWR sky130_fd_sc_hd__decap_4
X_08528_ net1323 net278 net402 VGND VGND VPWR VPWR _00655_ sky130_fd_sc_hd__mux2_1
X_08459_ picorv32_core.decoded_imm\[8\] net526 _04310_ VGND VGND VPWR VPWR _00602_
+ sky130_fd_sc_hd__o21a_1
XFILLER_51_12 VGND VGND VPWR VPWR sky130_fd_sc_hd__decap_3
XFILLER_11_557 VGND VGND VPWR VPWR sky130_fd_sc_hd__decap_3
XPHY_EDGE_ROW_14_Right_14 VGND VGND VPWR VPWR sky130_fd_sc_hd__decap_3
XFILLER_137_721 VGND VGND VPWR VPWR sky130_fd_sc_hd__decap_6
XFILLER_129_3 VPWR VGND VPWR VGND sky130_ef_sc_hd__decap_12
X_11470_ clknet_leaf_47_clk _01306_ VGND VGND VPWR VPWR picorv32_core.cpuregs\[24\]\[21\]
+ sky130_fd_sc_hd__dfxtp_1
XFILLER_137_765 VPWR VGND VPWR VGND sky130_ef_sc_hd__decap_12
X_10421_ clknet_leaf_89_clk _01552_ VGND VGND VPWR VPWR picorv32_core.reg_out\[14\]
+ sky130_fd_sc_hd__dfxtp_1
XFILLER_136_275 VGND VGND VPWR VPWR sky130_fd_sc_hd__fill_1
X_10352_ clknet_leaf_99_clk _00271_ VGND VGND VPWR VPWR picorv32_core.count_cycle\[10\]
+ sky130_fd_sc_hd__dfxtp_1
XFILLER_124_437 VGND VGND VPWR VPWR sky130_fd_sc_hd__fill_1
XTAP_TAPCELL_ROW_111_1916 VGND VPWR sky130_fd_sc_hd__tapvpwrvgnd_1
XFILLER_2_233 VPWR VGND VPWR VGND sky130_ef_sc_hd__decap_12
X_10283_ clknet_leaf_123_clk _00202_ VGND VGND VPWR VPWR picorv32_core.reg_pc\[4\]
+ sky130_fd_sc_hd__dfxtp_1
XPHY_EDGE_ROW_23_Right_23 VGND VGND VPWR VPWR sky130_fd_sc_hd__decap_3
XFILLER_120_643 VGND VGND VPWR VPWR sky130_fd_sc_hd__fill_1
XTAP_TAPCELL_ROW_53_1078 VGND VPWR sky130_fd_sc_hd__tapvpwrvgnd_1
XTAP_TAPCELL_ROW_53_1067 VGND VPWR sky130_fd_sc_hd__tapvpwrvgnd_1
XFILLER_120_698 VGND VGND VPWR VPWR sky130_fd_sc_hd__fill_2
Xfanout592 net593 VGND VGND VPWR VPWR net592 sky130_fd_sc_hd__clkbuf_2
Xfanout570 _02252_ VGND VGND VPWR VPWR net570 sky130_fd_sc_hd__clkbuf_2
Xfanout581 net582 VGND VGND VPWR VPWR net581 sky130_fd_sc_hd__clkbuf_4
XTAP_TAPCELL_ROW_109_1889 VGND VPWR sky130_fd_sc_hd__tapvpwrvgnd_1
XFILLER_46_465 VGND VGND VPWR VPWR sky130_fd_sc_hd__decap_3
XFILLER_92_85 VGND VGND VPWR VPWR sky130_fd_sc_hd__fill_1
XPHY_EDGE_ROW_32_Right_32 VGND VGND VPWR VPWR sky130_fd_sc_hd__decap_3
XFILLER_14_362 VGND VGND VPWR VPWR sky130_fd_sc_hd__fill_2
XFILLER_30_811 VGND VGND VPWR VPWR sky130_fd_sc_hd__fill_1
XFILLER_128_710 VGND VGND VPWR VPWR sky130_fd_sc_hd__decap_3
X_11668_ clknet_leaf_24_clk _01499_ VGND VGND VPWR VPWR picorv32_core.cpuregs\[26\]\[17\]
+ sky130_fd_sc_hd__dfxtp_1
X_10619_ clknet_leaf_98_clk _00473_ VGND VGND VPWR VPWR picorv32_core.instr_rdinstrh
+ sky130_fd_sc_hd__dfxtp_2
X_11599_ clknet_leaf_5_clk _01430_ VGND VGND VPWR VPWR picorv32_core.cpuregs\[23\]\[12\]
+ sky130_fd_sc_hd__dfxtp_1
XTAP_TAPCELL_ROW_40_883 VGND VPWR sky130_fd_sc_hd__tapvpwrvgnd_1
XFILLER_127_275 VGND VGND VPWR VPWR sky130_fd_sc_hd__decap_4
XPHY_EDGE_ROW_41_Right_41 VGND VGND VPWR VPWR sky130_fd_sc_hd__decap_3
XFILLER_111_643 VGND VGND VPWR VPWR sky130_fd_sc_hd__fill_1
XFILLER_111_632 VGND VGND VPWR VPWR sky130_fd_sc_hd__decap_4
X_07830_ net696 _03913_ _03912_ net620 VGND VGND VPWR VPWR _03918_ sky130_fd_sc_hd__o211a_1
XFILLER_57_719 VGND VGND VPWR VPWR sky130_fd_sc_hd__fill_1
XFILLER_96_365 VGND VGND VPWR VPWR sky130_fd_sc_hd__decap_8
X_07761_ picorv32_core.decoded_imm\[13\] net590 net457 _03852_ net594 VGND VGND VPWR
+ VPWR _03853_ sky130_fd_sc_hd__a221o_1
XPHY_EDGE_ROW_16_Left_158 VGND VGND VPWR VPWR sky130_fd_sc_hd__decap_3
X_09500_ picorv32_core.cpuregs\[12\]\[14\] picorv32_core.cpuregs\[13\]\[14\] picorv32_core.cpuregs\[14\]\[14\]
+ picorv32_core.cpuregs\[15\]\[14\] net879 net846 VGND VGND VPWR VPWR _04685_ sky130_fd_sc_hd__mux4_1
XFILLER_2_83 VGND VGND VPWR VPWR sky130_fd_sc_hd__fill_1
X_06712_ net515 _02945_ _02946_ net551 net1133 VGND VGND VPWR VPWR _00230_ sky130_fd_sc_hd__a32o_1
XFILLER_37_421 VGND VGND VPWR VPWR sky130_fd_sc_hd__decap_6
XFILLER_112_29 VGND VGND VPWR VPWR sky130_fd_sc_hd__fill_2
XTAP_TAPCELL_ROW_84_1517 VGND VPWR sky130_fd_sc_hd__tapvpwrvgnd_1
XFILLER_65_785 VGND VGND VPWR VPWR sky130_fd_sc_hd__fill_2
X_07692_ picorv32_core.cpuregs\[28\]\[10\] picorv32_core.cpuregs\[29\]\[10\] picorv32_core.cpuregs\[30\]\[10\]
+ picorv32_core.cpuregs\[31\]\[10\] net738 net705 VGND VGND VPWR VPWR _03787_ sky130_fd_sc_hd__mux4_1
X_06643_ _02908_ _02909_ VGND VGND VPWR VPWR _00198_ sky130_fd_sc_hd__nor2_1
XTAP_TAPCELL_ROW_84_1528 VGND VPWR sky130_fd_sc_hd__tapvpwrvgnd_1
XPHY_EDGE_ROW_50_Right_50 VGND VGND VPWR VPWR sky130_fd_sc_hd__decap_3
X_09431_ net654 _04618_ VGND VGND VPWR VPWR _04619_ sky130_fd_sc_hd__or2_1
XFILLER_37_487 VGND VGND VPWR VPWR sky130_fd_sc_hd__decap_3
XTAP_TAPCELL_ROW_48_994 VGND VPWR sky130_fd_sc_hd__tapvpwrvgnd_1
X_09362_ net654 _04552_ VGND VGND VPWR VPWR _04553_ sky130_fd_sc_hd__or2_1
X_06574_ _02864_ _02865_ VGND VGND VPWR VPWR _00173_ sky130_fd_sc_hd__nor2_1
X_05525_ picorv32_core.reg_pc\[23\] picorv32_core.decoded_imm\[23\] VGND VGND VPWR
+ VPWR _02018_ sky130_fd_sc_hd__nand2_1
XFILLER_80_799 VGND VGND VPWR VPWR sky130_fd_sc_hd__fill_2
X_08313_ net2297 _02600_ _04175_ _04230_ VGND VGND VPWR VPWR _00534_ sky130_fd_sc_hd__a22o_1
XANTENNA_11 _02913_ VGND VGND VPWR VPWR sky130_fd_sc_hd__diode_2
X_09293_ picorv32_core.cpuregs\[0\]\[5\] picorv32_core.cpuregs\[1\]\[5\] picorv32_core.cpuregs\[2\]\[5\]
+ picorv32_core.cpuregs\[3\]\[5\] net875 net842 VGND VGND VPWR VPWR _04487_ sky130_fd_sc_hd__mux4_1
XANTENNA_22 _04262_ VGND VGND VPWR VPWR sky130_fd_sc_hd__diode_2
X_05456_ _01949_ _01953_ _01954_ VGND VGND VPWR VPWR _01555_ sky130_fd_sc_hd__or3_1
XANTENNA_66 net794 VGND VGND VPWR VPWR sky130_fd_sc_hd__diode_2
XANTENNA_44 net24 VGND VGND VPWR VPWR sky130_fd_sc_hd__diode_2
XANTENNA_55 net415 VGND VGND VPWR VPWR sky130_fd_sc_hd__diode_2
XPHY_EDGE_ROW_25_Left_167 VGND VGND VPWR VPWR sky130_fd_sc_hd__decap_3
XANTENNA_33 _05033_ VGND VGND VPWR VPWR sky130_fd_sc_hd__diode_2
X_08244_ net2295 _00766_ net438 VGND VGND VPWR VPWR _00475_ sky130_fd_sc_hd__mux2_1
XFILLER_119_765 VPWR VGND VPWR VGND sky130_ef_sc_hd__decap_12
XANTENNA_77 _04339_ VGND VGND VPWR VPWR sky130_fd_sc_hd__diode_2
X_05387_ picorv32_core.reg_pc\[13\] picorv32_core.decoded_imm\[13\] VGND VGND VPWR
+ VPWR _01890_ sky130_fd_sc_hd__nor2_1
X_08175_ _04173_ _04191_ _04192_ _02600_ picorv32_core.instr_jalr VGND VGND VPWR VPWR
+ _00438_ sky130_fd_sc_hd__a32o_1
XFILLER_21_15 VPWR VGND VPWR VGND sky130_ef_sc_hd__decap_12
XANTENNA_88 net631 VGND VGND VPWR VPWR sky130_fd_sc_hd__diode_2
XFILLER_137_15 VPWR VGND VPWR VGND sky130_ef_sc_hd__decap_12
XFILLER_118_253 VGND VGND VPWR VPWR sky130_fd_sc_hd__fill_1
XFILLER_106_404 VGND VGND VPWR VPWR sky130_fd_sc_hd__decap_4
X_07126_ picorv32_core.count_cycle\[19\] _03309_ net976 VGND VGND VPWR VPWR _03311_
+ sky130_fd_sc_hd__a21oi_1
XFILLER_134_757 VPWR VGND VPWR VGND sky130_ef_sc_hd__decap_12
XFILLER_133_234 VGND VGND VPWR VPWR sky130_fd_sc_hd__fill_1
XTAP_TAPCELL_ROW_95_1679 VGND VPWR sky130_fd_sc_hd__tapvpwrvgnd_1
Xoutput151 net784 VGND VGND VPWR VPWR pcpi_rs1[19] sky130_fd_sc_hd__buf_2
X_07057_ _02941_ _02942_ _03248_ VGND VGND VPWR VPWR _03263_ sky130_fd_sc_hd__and3_1
Xoutput140 net140 VGND VGND VPWR VPWR mem_axi_wvalid sky130_fd_sc_hd__buf_2
Xoutput162 net765 VGND VGND VPWR VPWR pcpi_rs1[29] sky130_fd_sc_hd__buf_2
X_06008_ net781 _02471_ VGND VGND VPWR VPWR _02472_ sky130_fd_sc_hd__nand2_1
Xoutput184 net184 VGND VGND VPWR VPWR pcpi_rs2[1] sky130_fd_sc_hd__buf_2
Xoutput173 net173 VGND VGND VPWR VPWR pcpi_rs2[0] sky130_fd_sc_hd__buf_2
Xoutput195 net195 VGND VGND VPWR VPWR pcpi_rs2[2] sky130_fd_sc_hd__buf_2
XFILLER_87_354 VGND VGND VPWR VPWR sky130_fd_sc_hd__fill_2
XPHY_EDGE_ROW_34_Left_176 VGND VGND VPWR VPWR sky130_fd_sc_hd__decap_3
XFILLER_75_505 VGND VGND VPWR VPWR sky130_fd_sc_hd__fill_1
XFILLER_47_207 VGND VGND VPWR VPWR sky130_fd_sc_hd__fill_1
XTAP_TAPCELL_ROW_126_2134 VGND VPWR sky130_fd_sc_hd__tapvpwrvgnd_1
X_07959_ net695 _04035_ _04034_ net621 VGND VGND VPWR VPWR _04040_ sky130_fd_sc_hd__o211a_1
X_10970_ clknet_leaf_19_clk _00821_ VGND VGND VPWR VPWR picorv32_core.cpuregs\[13\]\[16\]
+ sky130_fd_sc_hd__dfxtp_1
XFILLER_56_763 VPWR VGND VPWR VGND sky130_ef_sc_hd__decap_12
X_09629_ picorv32_core.cpuregs\[28\]\[20\] picorv32_core.cpuregs\[29\]\[20\] picorv32_core.cpuregs\[30\]\[20\]
+ picorv32_core.cpuregs\[31\]\[20\] net892 net858 VGND VGND VPWR VPWR _04808_ sky130_fd_sc_hd__mux4_1
XFILLER_102_73 VGND VGND VPWR VPWR sky130_fd_sc_hd__decap_3
XFILLER_71_766 VGND VGND VPWR VPWR sky130_fd_sc_hd__decap_8
XFILLER_12_811 VGND VGND VPWR VPWR sky130_fd_sc_hd__fill_1
XTAP_TAPCELL_ROW_26_677 VGND VPWR sky130_fd_sc_hd__tapvpwrvgnd_1
XTAP_TAPCELL_ROW_26_688 VGND VPWR sky130_fd_sc_hd__tapvpwrvgnd_1
Xclkbuf_leaf_50_clk clknet_4_7_0_clk VGND VGND VPWR VPWR clknet_leaf_50_clk sky130_fd_sc_hd__clkbuf_8
XFILLER_11_310 VGND VGND VPWR VPWR sky130_fd_sc_hd__fill_1
XFILLER_12_833 VGND VGND VPWR VPWR sky130_fd_sc_hd__fill_1
XFILLER_23_192 VGND VGND VPWR VPWR sky130_fd_sc_hd__fill_1
XPHY_EDGE_ROW_43_Left_185 VGND VGND VPWR VPWR sky130_fd_sc_hd__decap_3
XFILLER_11_365 VGND VGND VPWR VPWR sky130_fd_sc_hd__decap_4
X_11522_ clknet_leaf_118_clk _01353_ VGND VGND VPWR VPWR picorv32_core.cpuregs\[30\]\[3\]
+ sky130_fd_sc_hd__dfxtp_1
XTAP_TAPCELL_ROW_137_2285 VGND VPWR sky130_fd_sc_hd__tapvpwrvgnd_1
X_11453_ clknet_leaf_111_clk _01289_ VGND VGND VPWR VPWR picorv32_core.cpuregs\[24\]\[4\]
+ sky130_fd_sc_hd__dfxtp_1
XTAP_TAPCELL_ROW_137_2296 VGND VPWR sky130_fd_sc_hd__tapvpwrvgnd_1
X_10404_ clknet_leaf_74_clk _00323_ VGND VGND VPWR VPWR picorv32_core.count_cycle\[62\]
+ sky130_fd_sc_hd__dfxtp_1
X_11384_ clknet_leaf_84_clk _00029_ VGND VGND VPWR VPWR _00009_ sky130_fd_sc_hd__dfxtp_4
XTAP_TAPCELL_ROW_55_1107 VGND VPWR sky130_fd_sc_hd__tapvpwrvgnd_1
XFILLER_3_520 VGND VGND VPWR VPWR sky130_fd_sc_hd__fill_1
X_10335_ clknet_leaf_59_clk _00254_ VGND VGND VPWR VPWR picorv32_core.reg_next_pc\[25\]
+ sky130_fd_sc_hd__dfxtp_1
XFILLER_11_81 VGND VGND VPWR VPWR sky130_fd_sc_hd__decap_6
XFILLER_140_749 VGND VGND VPWR VPWR sky130_fd_sc_hd__decap_6
XFILLER_127_81 VGND VGND VPWR VPWR sky130_fd_sc_hd__decap_6
X_10266_ clknet_leaf_81_clk net2210 VGND VGND VPWR VPWR picorv32_core.count_instr\[50\]
+ sky130_fd_sc_hd__dfxtp_1
XPHY_EDGE_ROW_52_Left_194 VGND VGND VPWR VPWR sky130_fd_sc_hd__decap_3
XFILLER_120_473 VGND VGND VPWR VPWR sky130_fd_sc_hd__decap_3
XFILLER_94_836 VGND VGND VPWR VPWR sky130_fd_sc_hd__fill_1
X_10197_ clknet_leaf_16_clk _00116_ VGND VGND VPWR VPWR picorv32_core.cpuregs\[9\]\[13\]
+ sky130_fd_sc_hd__dfxtp_1
XFILLER_39_719 VGND VGND VPWR VPWR sky130_fd_sc_hd__decap_8
XTAP_TAPCELL_ROW_6_391 VGND VPWR sky130_fd_sc_hd__tapvpwrvgnd_1
XFILLER_19_410 VGND VGND VPWR VPWR sky130_fd_sc_hd__fill_2
XFILLER_46_251 VGND VGND VPWR VPWR sky130_fd_sc_hd__fill_1
XFILLER_74_582 VGND VGND VPWR VPWR sky130_fd_sc_hd__decap_6
XFILLER_62_711 VGND VGND VPWR VPWR sky130_fd_sc_hd__fill_1
XFILLER_47_785 VGND VGND VPWR VPWR sky130_fd_sc_hd__fill_1
XTAP_TAPCELL_ROW_66_1269 VGND VPWR sky130_fd_sc_hd__tapvpwrvgnd_1
XTAP_TAPCELL_ROW_66_1258 VGND VPWR sky130_fd_sc_hd__tapvpwrvgnd_1
XFILLER_62_777 VPWR VGND VPWR VGND sky130_ef_sc_hd__decap_12
XTAP_TAPCELL_ROW_45_953 VGND VPWR sky130_fd_sc_hd__tapvpwrvgnd_1
XTAP_TAPCELL_ROW_45_964 VGND VPWR sky130_fd_sc_hd__tapvpwrvgnd_1
Xclkbuf_leaf_41_clk clknet_4_7_0_clk VGND VGND VPWR VPWR clknet_leaf_41_clk sky130_fd_sc_hd__clkbuf_8
XFILLER_14_192 VGND VGND VPWR VPWR sky130_fd_sc_hd__decap_4
X_06290_ _02704_ _02705_ net566 VGND VGND VPWR VPWR _02706_ sky130_fd_sc_hd__mux2_2
X_05310_ net821 _01716_ VGND VGND VPWR VPWR _01818_ sky130_fd_sc_hd__and2_1
XFILLER_30_663 VGND VGND VPWR VPWR sky130_fd_sc_hd__decap_6
Xinput31 mem_axi_rdata[5] VGND VGND VPWR VPWR net31 sky130_fd_sc_hd__buf_1
XFILLER_30_685 VGND VGND VPWR VPWR sky130_fd_sc_hd__decap_3
X_05241_ picorv32_core.reg_pc\[3\] picorv32_core.decoded_imm\[3\] VGND VGND VPWR VPWR
+ _01754_ sky130_fd_sc_hd__or2_1
Xinput20 mem_axi_rdata[24] VGND VGND VPWR VPWR net20 sky130_fd_sc_hd__buf_2
X_05172_ picorv32_core.is_lb_lh_lw_lbu_lhu picorv32_core.is_sll_srl_sra picorv32_core.is_sb_sh_sw
+ _01680_ VGND VGND VPWR VPWR _01696_ sky130_fd_sc_hd__or4_1
Xhold804 picorv32_core.cpuregs\[24\]\[30\] VGND VGND VPWR VPWR net1913 sky130_fd_sc_hd__dlygate4sd3_1
Xhold815 picorv32_core.cpuregs\[26\]\[23\] VGND VGND VPWR VPWR net1924 sky130_fd_sc_hd__dlygate4sd3_1
XFILLER_116_757 VPWR VGND VPWR VGND sky130_ef_sc_hd__decap_12
XFILLER_116_735 VPWR VGND VPWR VGND sky130_ef_sc_hd__decap_12
Xhold837 picorv32_core.cpuregs\[6\]\[22\] VGND VGND VPWR VPWR net1946 sky130_fd_sc_hd__dlygate4sd3_1
Xhold826 picorv32_core.cpuregs\[3\]\[16\] VGND VGND VPWR VPWR net1935 sky130_fd_sc_hd__dlygate4sd3_1
Xhold848 picorv32_core.cpuregs\[4\]\[19\] VGND VGND VPWR VPWR net1957 sky130_fd_sc_hd__dlygate4sd3_1
Xhold859 picorv32_core.cpuregs\[25\]\[17\] VGND VGND VPWR VPWR net1968 sky130_fd_sc_hd__dlygate4sd3_1
X_09980_ net1413 net431 net312 VGND VGND VPWR VPWR _01457_ sky130_fd_sc_hd__mux2_1
X_08931_ net291 net1785 net354 VGND VGND VPWR VPWR _01104_ sky130_fd_sc_hd__mux2_1
XFILLER_69_332 VGND VGND VPWR VPWR sky130_fd_sc_hd__decap_4
X_08862_ net427 net2228 net362 VGND VGND VPWR VPWR _01037_ sky130_fd_sc_hd__mux2_1
X_07813_ _03900_ _03901_ net458 _03898_ VGND VGND VPWR VPWR _03902_ sky130_fd_sc_hd__o211a_1
XFILLER_123_39 VPWR VGND VPWR VGND sky130_ef_sc_hd__decap_12
XFILLER_57_549 VGND VGND VPWR VPWR sky130_fd_sc_hd__decap_8
X_08793_ net445 net2147 net370 VGND VGND VPWR VPWR _00971_ sky130_fd_sc_hd__mux2_1
XFILLER_72_508 VGND VGND VPWR VPWR sky130_fd_sc_hd__fill_1
X_07744_ net682 _03835_ net624 VGND VGND VPWR VPWR _03837_ sky130_fd_sc_hd__a21o_1
XFILLER_65_571 VGND VGND VPWR VPWR sky130_fd_sc_hd__fill_1
XFILLER_16_26 VGND VGND VPWR VPWR sky130_fd_sc_hd__fill_2
X_07675_ picorv32_core.cpuregs\[28\]\[9\] picorv32_core.cpuregs\[29\]\[9\] picorv32_core.cpuregs\[30\]\[9\]
+ picorv32_core.cpuregs\[31\]\[9\] net731 net698 VGND VGND VPWR VPWR _03771_ sky130_fd_sc_hd__mux4_1
XTAP_TAPCELL_ROW_121_2053 VGND VPWR sky130_fd_sc_hd__tapvpwrvgnd_1
X_06626_ net2302 _02896_ net997 VGND VGND VPWR VPWR _02899_ sky130_fd_sc_hd__o21ai_1
XFILLER_25_457 VGND VGND VPWR VPWR sky130_fd_sc_hd__decap_3
X_09414_ _04594_ _04595_ _04598_ _04599_ net652 net642 VGND VGND VPWR VPWR _04603_
+ sky130_fd_sc_hd__mux4_1
XTAP_TAPCELL_ROW_121_2064 VGND VPWR sky130_fd_sc_hd__tapvpwrvgnd_1
Xclkbuf_leaf_32_clk clknet_4_5_0_clk VGND VGND VPWR VPWR clknet_leaf_32_clk sky130_fd_sc_hd__clkbuf_8
X_06557_ picorv32_core.count_instr\[32\] _02853_ net996 VGND VGND VPWR VPWR _02855_
+ sky130_fd_sc_hd__o21ai_1
XFILLER_12_129 VGND VGND VPWR VPWR sky130_fd_sc_hd__fill_2
XTAP_TAPCELL_ROW_23_636 VGND VPWR sky130_fd_sc_hd__tapvpwrvgnd_1
X_09345_ net653 _04536_ VGND VGND VPWR VPWR _04537_ sky130_fd_sc_hd__or2_1
X_05508_ net578 _02001_ _02002_ net780 net916 VGND VGND VPWR VPWR _02003_ sky130_fd_sc_hd__a32o_1
X_06488_ net2263 _02809_ net985 VGND VGND VPWR VPWR _02811_ sky130_fd_sc_hd__o21ai_1
X_09276_ _04469_ _04470_ net837 VGND VGND VPWR VPWR _04471_ sky130_fd_sc_hd__mux2_1
XTAP_TAPCELL_ROW_97_1708 VGND VPWR sky130_fd_sc_hd__tapvpwrvgnd_1
X_05439_ net946 picorv32_core.count_cycle\[48\] net604 _01938_ VGND VGND VPWR VPWR
+ _01939_ sky130_fd_sc_hd__a211o_1
X_08227_ picorv32_core.mem_rdata_q\[28\] picorv32_core.mem_rdata_q\[29\] _04212_ _04213_
+ VGND VGND VPWR VPWR _04214_ sky130_fd_sc_hd__or4_1
XFILLER_106_201 VGND VGND VPWR VPWR sky130_fd_sc_hd__fill_1
X_08158_ net929 _04183_ VGND VGND VPWR VPWR _04184_ sky130_fd_sc_hd__nor2_1
X_08089_ net197 net512 _04161_ _04162_ VGND VGND VPWR VPWR _00391_ sky130_fd_sc_hd__o22a_1
X_07109_ _03299_ _03300_ VGND VGND VPWR VPWR _00273_ sky130_fd_sc_hd__nor2_1
XFILLER_134_587 VGND VGND VPWR VPWR sky130_fd_sc_hd__fill_1
X_10120_ clknet_leaf_118_clk _00042_ VGND VGND VPWR VPWR picorv32_core.cpuregs\[22\]\[3\]
+ sky130_fd_sc_hd__dfxtp_1
XFILLER_88_641 VGND VGND VPWR VPWR sky130_fd_sc_hd__decap_3
Xclkbuf_leaf_99_clk clknet_4_11_0_clk VGND VGND VPWR VPWR clknet_leaf_99_clk sky130_fd_sc_hd__clkbuf_8
X_10051_ net1249 net289 net304 VGND VGND VPWR VPWR _01526_ sky130_fd_sc_hd__mux2_1
XFILLER_87_140 VGND VGND VPWR VPWR sky130_fd_sc_hd__fill_1
XFILLER_57_44 VGND VGND VPWR VPWR sky130_fd_sc_hd__decap_4
XTAP_TAPCELL_ROW_50_1037 VGND VPWR sky130_fd_sc_hd__tapvpwrvgnd_1
XTAP_TAPCELL_ROW_50_1026 VGND VPWR sky130_fd_sc_hd__tapvpwrvgnd_1
XFILLER_48_516 VPWR VGND VPWR VGND sky130_ef_sc_hd__decap_12
XFILLER_130_793 VPWR VGND VPWR VGND sky130_ef_sc_hd__decap_12
XFILLER_57_99 VGND VGND VPWR VPWR sky130_fd_sc_hd__decap_4
XTAP_TAPCELL_ROW_3_350 VGND VPWR sky130_fd_sc_hd__tapvpwrvgnd_1
X_10953_ clknet_leaf_65_clk _00804_ VGND VGND VPWR VPWR picorv32_core.cpuregs\[19\]\[31\]
+ sky130_fd_sc_hd__dfxtp_1
XTAP_TAPCELL_ROW_106_1837 VGND VPWR sky130_fd_sc_hd__tapvpwrvgnd_1
XFILLER_29_785 VPWR VGND VPWR VGND sky130_ef_sc_hd__decap_12
XTAP_TAPCELL_ROW_106_1848 VGND VPWR sky130_fd_sc_hd__tapvpwrvgnd_1
X_10884_ clknet_leaf_38_clk _00735_ VGND VGND VPWR VPWR picorv32_core.cpuregs\[16\]\[28\]
+ sky130_fd_sc_hd__dfxtp_1
XTAP_TAPCELL_ROW_42_912 VGND VPWR sky130_fd_sc_hd__tapvpwrvgnd_1
XTAP_TAPCELL_ROW_139_2325 VGND VPWR sky130_fd_sc_hd__tapvpwrvgnd_1
XTAP_TAPCELL_ROW_139_2314 VGND VPWR sky130_fd_sc_hd__tapvpwrvgnd_1
Xclkbuf_leaf_23_clk clknet_4_4_0_clk VGND VGND VPWR VPWR clknet_leaf_23_clk sky130_fd_sc_hd__clkbuf_8
XFILLER_129_315 VGND VGND VPWR VPWR sky130_fd_sc_hd__decap_4
X_11505_ clknet_leaf_53_clk _01341_ VGND VGND VPWR VPWR net155 sky130_fd_sc_hd__dfxtp_1
XTAP_TAPCELL_ROW_61_1188 VGND VPWR sky130_fd_sc_hd__tapvpwrvgnd_1
XFILLER_7_111 VGND VGND VPWR VPWR sky130_fd_sc_hd__fill_1
XFILLER_125_510 VGND VGND VPWR VPWR sky130_fd_sc_hd__fill_1
X_11436_ clknet_leaf_29_clk _01272_ VGND VGND VPWR VPWR picorv32_core.cpuregs\[1\]\[19\]
+ sky130_fd_sc_hd__dfxtp_1
XTAP_TAPCELL_ROW_117_1999 VGND VPWR sky130_fd_sc_hd__tapvpwrvgnd_1
X_11367_ clknet_leaf_30_clk _01208_ VGND VGND VPWR VPWR picorv32_core.cpuregs\[18\]\[19\]
+ sky130_fd_sc_hd__dfxtp_1
XPHY_EDGE_ROW_60_Left_202 VGND VGND VPWR VPWR sky130_fd_sc_hd__decap_3
XFILLER_113_716 VGND VGND VPWR VPWR sky130_fd_sc_hd__fill_1
X_10318_ clknet_leaf_125_clk _00237_ VGND VGND VPWR VPWR picorv32_core.reg_next_pc\[8\]
+ sky130_fd_sc_hd__dfxtp_1
X_11298_ clknet_leaf_41_clk _01146_ VGND VGND VPWR VPWR picorv32_core.cpuregs\[3\]\[21\]
+ sky130_fd_sc_hd__dfxtp_1
XFILLER_140_579 VGND VGND VPWR VPWR sky130_fd_sc_hd__fill_1
XFILLER_39_505 VPWR VGND VPWR VGND sky130_ef_sc_hd__decap_12
X_10249_ clknet_leaf_103_clk _00168_ VGND VGND VPWR VPWR picorv32_core.count_instr\[33\]
+ sky130_fd_sc_hd__dfxtp_1
XFILLER_66_335 VGND VGND VPWR VPWR sky130_fd_sc_hd__fill_1
XFILLER_54_519 VGND VGND VPWR VPWR sky130_fd_sc_hd__fill_1
X_05790_ net817 net967 net567 VGND VGND VPWR VPWR _02272_ sky130_fd_sc_hd__and3_1
XFILLER_94_699 VGND VGND VPWR VPWR sky130_fd_sc_hd__fill_1
XFILLER_62_585 VGND VGND VPWR VPWR sky130_fd_sc_hd__decap_3
X_07460_ net1964 _03594_ net460 VGND VGND VPWR VPWR _00330_ sky130_fd_sc_hd__mux2_1
XFILLER_34_265 VGND VGND VPWR VPWR sky130_fd_sc_hd__fill_2
XFILLER_35_777 VGND VGND VPWR VPWR sky130_fd_sc_hd__decap_6
X_07391_ _03407_ _03408_ _03529_ _03405_ VGND VGND VPWR VPWR _03531_ sky130_fd_sc_hd__o31a_1
X_06411_ net426 net1555 net422 VGND VGND VPWR VPWR _00079_ sky130_fd_sc_hd__mux2_1
X_06342_ net1795 net248 net435 VGND VGND VPWR VPWR _00059_ sky130_fd_sc_hd__mux2_1
Xclkbuf_leaf_14_clk clknet_4_3_0_clk VGND VGND VPWR VPWR clknet_leaf_14_clk sky130_fd_sc_hd__clkbuf_8
X_09130_ net1260 net293 net328 VGND VGND VPWR VPWR _01296_ sky130_fd_sc_hd__mux2_1
X_09061_ net1403 net428 net336 VGND VGND VPWR VPWR _01229_ sky130_fd_sc_hd__mux2_1
X_08012_ picorv32_core.decoded_imm\[27\] net592 net597 VGND VGND VPWR VPWR _04090_
+ sky130_fd_sc_hd__a21o_1
XTAP_TAPCELL_ROW_79_1449 VGND VPWR sky130_fd_sc_hd__tapvpwrvgnd_1
X_06273_ picorv32_core.reg_pc\[6\] _02685_ picorv32_core.reg_pc\[7\] VGND VGND VPWR
+ VPWR _02692_ sky130_fd_sc_hd__a21oi_1
Xhold601 picorv32_core.cpuregs\[17\]\[17\] VGND VGND VPWR VPWR net1710 sky130_fd_sc_hd__dlygate4sd3_1
Xhold612 picorv32_core.cpuregs\[5\]\[12\] VGND VGND VPWR VPWR net1721 sky130_fd_sc_hd__dlygate4sd3_1
X_05224_ net576 _01734_ _01735_ _01738_ VGND VGND VPWR VPWR _01558_ sky130_fd_sc_hd__a31o_1
Xhold623 picorv32_core.cpuregs\[27\]\[29\] VGND VGND VPWR VPWR net1732 sky130_fd_sc_hd__dlygate4sd3_1
Xhold634 picorv32_core.cpuregs\[18\]\[22\] VGND VGND VPWR VPWR net1743 sky130_fd_sc_hd__dlygate4sd3_1
X_05155_ picorv32_core.is_lui_auipc_jal picorv32_core.is_jalr_addi_slti_sltiu_xori_ori_andi
+ VGND VGND VPWR VPWR _01682_ sky130_fd_sc_hd__nor2_4
Xhold645 picorv32_core.cpuregs\[4\]\[13\] VGND VGND VPWR VPWR net1754 sky130_fd_sc_hd__dlygate4sd3_1
Xhold656 picorv32_core.cpuregs\[22\]\[25\] VGND VGND VPWR VPWR net1765 sky130_fd_sc_hd__dlygate4sd3_1
X_09963_ net1445 net239 net319 VGND VGND VPWR VPWR _01441_ sky130_fd_sc_hd__mux2_1
XFILLER_103_204 VGND VGND VPWR VPWR sky130_fd_sc_hd__decap_3
XTAP_TAPCELL_ROW_92_1638 VGND VPWR sky130_fd_sc_hd__tapvpwrvgnd_1
Xhold678 picorv32_core.instr_sltu VGND VGND VPWR VPWR net1787 sky130_fd_sc_hd__dlygate4sd3_1
XPHY_EDGE_ROW_4_Right_4 VGND VGND VPWR VPWR sky130_fd_sc_hd__decap_3
Xhold667 picorv32_core.cpuregs\[16\]\[0\] VGND VGND VPWR VPWR net1776 sky130_fd_sc_hd__dlygate4sd3_1
X_05086_ net681 VGND VGND VPWR VPWR _01621_ sky130_fd_sc_hd__clkinv_4
X_08914_ net222 net2087 net361 VGND VGND VPWR VPWR _01088_ sky130_fd_sc_hd__mux2_1
Xhold689 picorv32_core.cpuregs\[9\]\[21\] VGND VGND VPWR VPWR net1798 sky130_fd_sc_hd__dlygate4sd3_1
XFILLER_89_449 VPWR VGND VPWR VGND sky130_ef_sc_hd__decap_12
XFILLER_134_27 VGND VGND VPWR VPWR sky130_fd_sc_hd__fill_1
X_09894_ net982 net205 _04278_ _01582_ _04280_ VGND VGND VPWR VPWR _05030_ sky130_fd_sc_hd__a221oi_2
X_08845_ net1211 net232 net368 VGND VGND VPWR VPWR _01021_ sky130_fd_sc_hd__mux2_1
XFILLER_112_793 VPWR VGND VPWR VGND sky130_ef_sc_hd__decap_12
XFILLER_84_110 VGND VGND VPWR VPWR sky130_fd_sc_hd__decap_3
XFILLER_58_836 VGND VGND VPWR VPWR sky130_fd_sc_hd__fill_1
XPHY_EDGE_ROW_108_Left_250 VGND VGND VPWR VPWR sky130_fd_sc_hd__decap_3
X_08776_ net242 net1907 net375 VGND VGND VPWR VPWR _00923_ sky130_fd_sc_hd__mux2_1
XTAP_TAPCELL_ROW_28_706 VGND VPWR sky130_fd_sc_hd__tapvpwrvgnd_1
X_05988_ _02452_ _02453_ VGND VGND VPWR VPWR _02454_ sky130_fd_sc_hd__xor2_1
X_07727_ picorv32_core.decoded_imm\[11\] net590 net594 VGND VGND VPWR VPWR _03821_
+ sky130_fd_sc_hd__a21o_1
XTAP_TAPCELL_ROW_28_717 VGND VPWR sky130_fd_sc_hd__tapvpwrvgnd_1
XFILLER_65_390 VGND VGND VPWR VPWR sky130_fd_sc_hd__fill_2
XFILLER_53_541 VPWR VGND VPWR VGND sky130_ef_sc_hd__decap_12
X_07658_ picorv32_core.cpuregs\[4\]\[8\] picorv32_core.cpuregs\[5\]\[8\] picorv32_core.cpuregs\[6\]\[8\]
+ picorv32_core.cpuregs\[7\]\[8\] net739 net706 VGND VGND VPWR VPWR _03755_ sky130_fd_sc_hd__mux4_1
X_06609_ _02887_ net993 _02886_ VGND VGND VPWR VPWR _00186_ sky130_fd_sc_hd__and3b_1
XFILLER_53_596 VGND VGND VPWR VPWR sky130_fd_sc_hd__decap_6
XFILLER_13_449 VGND VGND VPWR VPWR sky130_fd_sc_hd__fill_2
Xclkbuf_4_8_0_clk clknet_0_clk VGND VGND VPWR VPWR clknet_4_8_0_clk sky130_fd_sc_hd__clkbuf_8
X_07589_ picorv32_core.decoded_imm\[2\] _02621_ _01682_ VGND VGND VPWR VPWR _03692_
+ sky130_fd_sc_hd__mux2_1
XTAP_TAPCELL_ROW_101_1767 VGND VPWR sky130_fd_sc_hd__tapvpwrvgnd_1
X_09328_ net830 _04517_ _04520_ net478 VGND VGND VPWR VPWR _04521_ sky130_fd_sc_hd__o211a_1
XFILLER_43_57 VGND VGND VPWR VPWR sky130_fd_sc_hd__decap_3
Xpicorv32_axi_1011 VGND VGND VPWR VPWR picorv32_axi_1011/HI eoi[12] sky130_fd_sc_hd__conb_1
Xpicorv32_axi_1000 VGND VGND VPWR VPWR picorv32_axi_1000/HI eoi[1] sky130_fd_sc_hd__conb_1
XFILLER_138_167 VPWR VGND VPWR VGND sky130_ef_sc_hd__decap_12
X_09259_ _03469_ _04453_ VGND VGND VPWR VPWR _04454_ sky130_fd_sc_hd__nor2_1
Xpicorv32_axi_1044 VGND VGND VPWR VPWR picorv32_axi_1044/HI pcpi_insn[4] sky130_fd_sc_hd__conb_1
XTAP_TAPCELL_ROW_134_2255 VGND VPWR sky130_fd_sc_hd__tapvpwrvgnd_1
XTAP_TAPCELL_ROW_134_2244 VGND VPWR sky130_fd_sc_hd__tapvpwrvgnd_1
XFILLER_111_3 VPWR VGND VPWR VGND sky130_ef_sc_hd__decap_12
Xpicorv32_axi_1022 VGND VGND VPWR VPWR picorv32_axi_1022/HI eoi[23] sky130_fd_sc_hd__conb_1
Xpicorv32_axi_1033 VGND VGND VPWR VPWR picorv32_axi_1033/HI mem_axi_arprot[0] sky130_fd_sc_hd__conb_1
Xpicorv32_axi_1055 VGND VGND VPWR VPWR picorv32_axi_1055/HI pcpi_insn[15] sky130_fd_sc_hd__conb_1
Xpicorv32_axi_1088 VGND VGND VPWR VPWR picorv32_axi_1088/HI trace_data[15] sky130_fd_sc_hd__conb_1
Xpicorv32_axi_1066 VGND VGND VPWR VPWR picorv32_axi_1066/HI pcpi_insn[26] sky130_fd_sc_hd__conb_1
XFILLER_107_565 VGND VGND VPWR VPWR sky130_fd_sc_hd__fill_1
X_11221_ clknet_leaf_5_clk _01072_ VGND VGND VPWR VPWR picorv32_core.cpuregs\[5\]\[11\]
+ sky130_fd_sc_hd__dfxtp_1
Xpicorv32_axi_1077 VGND VGND VPWR VPWR picorv32_axi_1077/HI trace_data[4] sky130_fd_sc_hd__conb_1
Xpicorv32_axi_1099 VGND VGND VPWR VPWR picorv32_axi_1099/HI trace_data[26] sky130_fd_sc_hd__conb_1
XTAP_TAPCELL_ROW_8_420 VGND VPWR sky130_fd_sc_hd__tapvpwrvgnd_1
XFILLER_4_29 VPWR VGND VPWR VGND sky130_ef_sc_hd__decap_12
XFILLER_4_18 VGND VGND VPWR VPWR sky130_fd_sc_hd__decap_8
X_11152_ clknet_leaf_143_clk _01003_ VGND VGND VPWR VPWR picorv32_core.cpuregs\[7\]\[6\]
+ sky130_fd_sc_hd__dfxtp_1
X_10103_ net1116 VGND VGND VPWR VPWR _00953_ sky130_fd_sc_hd__clkbuf_1
XFILLER_1_821 VGND VGND VPWR VPWR sky130_fd_sc_hd__decap_8
X_11083_ clknet_leaf_109_clk _00934_ VGND VGND VPWR VPWR picorv32_core.cpuregs\[0\]\[1\]
+ sky130_fd_sc_hd__dfxtp_1
XFILLER_0_331 VGND VGND VPWR VPWR sky130_fd_sc_hd__fill_1
X_10034_ net1843 net219 net311 VGND VGND VPWR VPWR _01510_ sky130_fd_sc_hd__mux2_1
XFILLER_88_482 VGND VGND VPWR VPWR sky130_fd_sc_hd__decap_6
XFILLER_76_622 VGND VGND VPWR VPWR sky130_fd_sc_hd__fill_1
XFILLER_49_836 VGND VGND VPWR VPWR sky130_fd_sc_hd__fill_1
XFILLER_16_232 VGND VGND VPWR VPWR sky130_fd_sc_hd__decap_4
X_10936_ clknet_leaf_8_clk _00787_ VGND VGND VPWR VPWR picorv32_core.cpuregs\[19\]\[14\]
+ sky130_fd_sc_hd__dfxtp_1
XTAP_TAPCELL_ROW_63_1217 VGND VPWR sky130_fd_sc_hd__tapvpwrvgnd_1
XFILLER_17_777 VGND VGND VPWR VPWR sky130_fd_sc_hd__decap_6
XFILLER_71_393 VGND VGND VPWR VPWR sky130_fd_sc_hd__decap_3
X_10867_ clknet_leaf_4_clk _00718_ VGND VGND VPWR VPWR picorv32_core.cpuregs\[16\]\[11\]
+ sky130_fd_sc_hd__dfxtp_1
X_10798_ clknet_leaf_130_clk _00649_ VGND VGND VPWR VPWR picorv32_core.cpuregs\[15\]\[7\]
+ sky130_fd_sc_hd__dfxtp_1
XFILLER_40_780 VGND VGND VPWR VPWR sky130_fd_sc_hd__decap_6
X_11419_ clknet_leaf_135_clk _01255_ VGND VGND VPWR VPWR picorv32_core.cpuregs\[1\]\[2\]
+ sky130_fd_sc_hd__dfxtp_1
XFILLER_141_811 VGND VGND VPWR VPWR sky130_fd_sc_hd__fill_1
XFILLER_140_343 VGND VGND VPWR VPWR sky130_fd_sc_hd__fill_1
XTAP_TAPCELL_ROW_74_1379 VGND VPWR sky130_fd_sc_hd__tapvpwrvgnd_1
X_06960_ net678 _03174_ _03173_ net589 VGND VGND VPWR VPWR _03175_ sky130_fd_sc_hd__o211a_1
Xclkbuf_leaf_3_clk clknet_4_0_0_clk VGND VGND VPWR VPWR clknet_leaf_3_clk sky130_fd_sc_hd__clkbuf_8
X_06891_ _02927_ _02928_ _03087_ VGND VGND VPWR VPWR _03111_ sky130_fd_sc_hd__and3_1
X_05911_ _02368_ _02371_ _02367_ VGND VGND VPWR VPWR _02383_ sky130_fd_sc_hd__o21ai_1
XFILLER_94_441 VPWR VGND VPWR VGND sky130_ef_sc_hd__decap_12
XFILLER_67_666 VGND VGND VPWR VPWR sky130_fd_sc_hd__decap_6
X_05842_ picorv32_core.mem_la_wdata\[6\] _02285_ _02308_ net669 VGND VGND VPWR VPWR
+ _02319_ sky130_fd_sc_hd__o31a_1
X_08630_ net1433 net427 net390 VGND VGND VPWR VPWR _00781_ sky130_fd_sc_hd__mux2_1
XFILLER_81_113 VGND VGND VPWR VPWR sky130_fd_sc_hd__fill_1
XFILLER_54_305 VGND VGND VPWR VPWR sky130_fd_sc_hd__decap_3
X_08561_ net286 net1273 net398 VGND VGND VPWR VPWR _00686_ sky130_fd_sc_hd__mux2_1
X_05773_ _02133_ _02254_ _02256_ VGND VGND VPWR VPWR picorv32_core.alu_out\[0\] sky130_fd_sc_hd__o21a_1
XFILLER_120_29 VGND VGND VPWR VPWR sky130_fd_sc_hd__fill_2
X_07512_ picorv32_core.reg_out\[24\] picorv32_core.reg_next_pc\[24\] net561 VGND VGND
+ VPWR VPWR _03629_ sky130_fd_sc_hd__mux2_1
X_08492_ net1315 net287 net406 VGND VGND VPWR VPWR _00622_ sky130_fd_sc_hd__mux2_1
X_07443_ _01667_ _03579_ VGND VGND VPWR VPWR _03582_ sky130_fd_sc_hd__nand2_1
XFILLER_10_408 VGND VGND VPWR VPWR sky130_fd_sc_hd__fill_1
X_09113_ net222 net1729 net335 VGND VGND VPWR VPWR _01280_ sky130_fd_sc_hd__mux2_1
X_07374_ _03511_ _03513_ VGND VGND VPWR VPWR _03514_ sky130_fd_sc_hd__nand2_1
XFILLER_13_27 VPWR VGND VPWR VGND sky130_ef_sc_hd__decap_12
XTAP_TAPCELL_ROW_33_786 VGND VPWR sky130_fd_sc_hd__tapvpwrvgnd_1
XFILLER_129_27 VPWR VGND VPWR VGND sky130_ef_sc_hd__decap_12
X_06325_ picorv32_core.reg_pc\[17\] picorv32_core.reg_pc\[16\] _02726_ VGND VGND VPWR
+ VPWR _02734_ sky130_fd_sc_hd__and3_1
XFILLER_30_290 VGND VGND VPWR VPWR sky130_fd_sc_hd__fill_2
X_09044_ net232 net2015 net342 VGND VGND VPWR VPWR _01213_ sky130_fd_sc_hd__mux2_1
X_06256_ picorv32_core.reg_out\[4\] picorv32_core.alu_out_q\[4\] net950 VGND VGND
+ VPWR VPWR _02678_ sky130_fd_sc_hd__mux2_1
XFILLER_135_137 VGND VGND VPWR VPWR sky130_fd_sc_hd__fill_2
Xhold420 picorv32_core.cpuregs\[14\]\[31\] VGND VGND VPWR VPWR net1529 sky130_fd_sc_hd__dlygate4sd3_1
X_05207_ net11 _01717_ _01722_ net4 _01720_ VGND VGND VPWR VPWR _01723_ sky130_fd_sc_hd__a221o_1
XFILLER_132_811 VGND VGND VPWR VPWR sky130_fd_sc_hd__fill_1
XFILLER_104_502 VGND VGND VPWR VPWR sky130_fd_sc_hd__decap_3
Xhold453 picorv32_core.cpuregs\[20\]\[17\] VGND VGND VPWR VPWR net1562 sky130_fd_sc_hd__dlygate4sd3_1
Xhold442 picorv32_core.cpuregs\[9\]\[14\] VGND VGND VPWR VPWR net1551 sky130_fd_sc_hd__dlygate4sd3_1
X_06187_ net688 _02618_ VGND VGND VPWR VPWR _02619_ sky130_fd_sc_hd__nand2_1
Xhold431 picorv32_core.cpuregs\[30\]\[6\] VGND VGND VPWR VPWR net1540 sky130_fd_sc_hd__dlygate4sd3_1
Xhold464 picorv32_core.cpuregs\[19\]\[19\] VGND VGND VPWR VPWR net1573 sky130_fd_sc_hd__dlygate4sd3_1
Xfanout900 net907 VGND VGND VPWR VPWR net900 sky130_fd_sc_hd__buf_2
Xhold486 picorv32_core.instr_slt VGND VGND VPWR VPWR net1595 sky130_fd_sc_hd__dlygate4sd3_1
Xhold475 picorv32_core.cpuregs\[31\]\[6\] VGND VGND VPWR VPWR net1584 sky130_fd_sc_hd__dlygate4sd3_1
X_05138_ picorv32_core.mem_do_wdata picorv32_core.mem_do_rdata VGND VGND VPWR VPWR
+ _01668_ sky130_fd_sc_hd__or2_1
Xfanout933 net934 VGND VGND VPWR VPWR net933 sky130_fd_sc_hd__clkbuf_2
Xfanout922 net923 VGND VGND VPWR VPWR net922 sky130_fd_sc_hd__clkbuf_4
Xfanout911 net912 VGND VGND VPWR VPWR net911 sky130_fd_sc_hd__clkbuf_2
X_09946_ net1707 net444 net316 VGND VGND VPWR VPWR _01424_ sky130_fd_sc_hd__mux2_1
Xhold497 picorv32_core.cpuregs\[15\]\[0\] VGND VGND VPWR VPWR net1606 sky130_fd_sc_hd__dlygate4sd3_1
X_05069_ net966 VGND VGND VPWR VPWR _01604_ sky130_fd_sc_hd__inv_2
Xfanout977 net978 VGND VGND VPWR VPWR net977 sky130_fd_sc_hd__buf_2
Xfanout955 net185 VGND VGND VPWR VPWR net955 sky130_fd_sc_hd__clkbuf_4
Xfanout944 picorv32_core.instr_rdcycleh VGND VGND VPWR VPWR net944 sky130_fd_sc_hd__clkbuf_2
Xfanout966 picorv32_core.mem_la_wdata\[3\] VGND VGND VPWR VPWR net966 sky130_fd_sc_hd__buf_4
Xhold1120 picorv32_core.cpuregs\[6\]\[30\] VGND VGND VPWR VPWR net2229 sky130_fd_sc_hd__dlygate4sd3_1
XFILLER_97_290 VGND VGND VPWR VPWR sky130_fd_sc_hd__decap_8
Xhold1131 picorv32_core.cpuregs\[6\]\[16\] VGND VGND VPWR VPWR net2240 sky130_fd_sc_hd__dlygate4sd3_1
XFILLER_85_441 VGND VGND VPWR VPWR sky130_fd_sc_hd__decap_6
X_09877_ net1679 net268 net325 VGND VGND VPWR VPWR _01365_ sky130_fd_sc_hd__mux2_1
Xfanout988 net38 VGND VGND VPWR VPWR net988 sky130_fd_sc_hd__buf_2
Xhold1142 picorv32_core.instr_lh VGND VGND VPWR VPWR net2251 sky130_fd_sc_hd__dlygate4sd3_1
XPHY_EDGE_ROW_79_Right_79 VGND VGND VPWR VPWR sky130_fd_sc_hd__decap_3
XFILLER_73_636 VGND VGND VPWR VPWR sky130_fd_sc_hd__decap_3
XFILLER_73_614 VGND VGND VPWR VPWR sky130_fd_sc_hd__fill_2
Xhold1153 picorv32_core.count_cycle\[42\] VGND VGND VPWR VPWR net2262 sky130_fd_sc_hd__dlygate4sd3_1
XFILLER_18_519 VGND VGND VPWR VPWR sky130_fd_sc_hd__fill_1
Xhold1175 picorv32_core.reg_sh\[4\] VGND VGND VPWR VPWR net2284 sky130_fd_sc_hd__dlygate4sd3_1
X_08828_ net1789 net429 net366 VGND VGND VPWR VPWR _01004_ sky130_fd_sc_hd__mux2_1
Xhold1164 picorv32_core.count_instr\[35\] VGND VGND VPWR VPWR net2273 sky130_fd_sc_hd__dlygate4sd3_1
XFILLER_73_669 VGND VGND VPWR VPWR sky130_fd_sc_hd__decap_3
XFILLER_73_647 VGND VGND VPWR VPWR sky130_fd_sc_hd__decap_8
X_08759_ net447 net1975 net374 VGND VGND VPWR VPWR _00906_ sky130_fd_sc_hd__mux2_1
Xhold1197 axi_adapter.ack_arvalid VGND VGND VPWR VPWR net2306 sky130_fd_sc_hd__dlygate4sd3_1
Xhold1186 picorv32_core.decoded_imm_j\[5\] VGND VGND VPWR VPWR net2295 sky130_fd_sc_hd__dlygate4sd3_1
X_10721_ clknet_leaf_52_clk _00572_ VGND VGND VPWR VPWR net128 sky130_fd_sc_hd__dfxtp_1
XFILLER_14_725 VPWR VGND VPWR VGND sky130_ef_sc_hd__decap_12
XFILLER_14_769 VPWR VGND VPWR VGND sky130_ef_sc_hd__decap_12
X_10652_ clknet_leaf_41_clk _00506_ VGND VGND VPWR VPWR picorv32_core.cpuregs\[20\]\[20\]
+ sky130_fd_sc_hd__dfxtp_1
X_10583_ clknet_leaf_92_clk _00437_ VGND VGND VPWR VPWR picorv32_core.instr_bgeu sky130_fd_sc_hd__dfxtp_1
XPHY_EDGE_ROW_88_Right_88 VGND VGND VPWR VPWR sky130_fd_sc_hd__decap_3
XTAP_TAPCELL_ROW_11_469 VGND VPWR sky130_fd_sc_hd__tapvpwrvgnd_1
XTAP_TAPCELL_ROW_11_458 VGND VPWR sky130_fd_sc_hd__tapvpwrvgnd_1
X_11204_ clknet_leaf_63_clk _01055_ VGND VGND VPWR VPWR picorv32_core.cpuregs\[6\]\[26\]
+ sky130_fd_sc_hd__dfxtp_1
XTAP_TAPCELL_ROW_114_1958 VGND VPWR sky130_fd_sc_hd__tapvpwrvgnd_1
X_11135_ clknet_leaf_52_clk _00986_ VGND VGND VPWR VPWR picorv32_core.cpuregs\[8\]\[21\]
+ sky130_fd_sc_hd__dfxtp_1
XFILLER_68_419 VGND VGND VPWR VPWR sky130_fd_sc_hd__fill_1
XFILLER_135_81 VPWR VGND VPWR VGND sky130_ef_sc_hd__decap_12
X_11066_ clknet_leaf_23_clk _00917_ VGND VGND VPWR VPWR picorv32_core.cpuregs\[10\]\[16\]
+ sky130_fd_sc_hd__dfxtp_1
XFILLER_49_633 VGND VGND VPWR VPWR sky130_fd_sc_hd__decap_4
XFILLER_1_673 VPWR VGND VPWR VGND sky130_ef_sc_hd__decap_12
XPHY_EDGE_ROW_97_Right_97 VGND VGND VPWR VPWR sky130_fd_sc_hd__decap_3
X_10017_ net1437 net292 net308 VGND VGND VPWR VPWR _01493_ sky130_fd_sc_hd__mux2_1
XFILLER_49_655 VGND VGND VPWR VPWR sky130_fd_sc_hd__decap_3
XFILLER_64_636 VGND VGND VPWR VPWR sky130_fd_sc_hd__fill_1
XFILLER_36_305 VGND VGND VPWR VPWR sky130_fd_sc_hd__decap_3
XFILLER_91_422 VGND VGND VPWR VPWR sky130_fd_sc_hd__fill_1
XFILLER_44_393 VPWR VGND VPWR VGND sky130_ef_sc_hd__decap_12
X_10919_ clknet_leaf_84_clk _00770_ VGND VGND VPWR VPWR picorv32_core.mem_rdata_q\[29\]
+ sky130_fd_sc_hd__dfxtp_1
XFILLER_32_566 VGND VGND VPWR VPWR sky130_fd_sc_hd__fill_1
XTAP_TAPCELL_ROW_30_734 VGND VPWR sky130_fd_sc_hd__tapvpwrvgnd_1
XTAP_TAPCELL_ROW_30_745 VGND VPWR sky130_fd_sc_hd__tapvpwrvgnd_1
X_06110_ _02522_ _02532_ _02563_ _02565_ VGND VGND VPWR VPWR _02566_ sky130_fd_sc_hd__o31a_1
X_07090_ _03288_ net985 _03287_ VGND VGND VPWR VPWR _00266_ sky130_fd_sc_hd__and3b_1
X_06041_ _02501_ _02502_ VGND VGND VPWR VPWR _02503_ sky130_fd_sc_hd__and2_1
XTAP_TAPCELL_ROW_76_1408 VGND VPWR sky130_fd_sc_hd__tapvpwrvgnd_1
XFILLER_114_811 VGND VGND VPWR VPWR sky130_fd_sc_hd__fill_1
Xfanout229 _02770_ VGND VGND VPWR VPWR net229 sky130_fd_sc_hd__buf_1
Xfanout218 _02781_ VGND VGND VPWR VPWR net218 sky130_fd_sc_hd__buf_1
X_07992_ _04061_ _04062_ net640 VGND VGND VPWR VPWR _04071_ sky130_fd_sc_hd__mux2_1
Xfanout207 net209 VGND VGND VPWR VPWR net207 sky130_fd_sc_hd__clkbuf_2
X_09800_ net774 net543 _04970_ VGND VGND VPWR VPWR _04971_ sky130_fd_sc_hd__o21ba_1
X_09731_ net772 net280 VGND VGND VPWR VPWR _04905_ sky130_fd_sc_hd__and2_1
X_06943_ net677 _03157_ _03158_ VGND VGND VPWR VPWR _03159_ sky130_fd_sc_hd__or3b_1
XFILLER_140_195 VGND VGND VPWR VPWR sky130_fd_sc_hd__fill_1
X_09662_ _04835_ _04838_ _04839_ net828 net650 VGND VGND VPWR VPWR _04840_ sky130_fd_sc_hd__a221o_1
XFILLER_95_783 VGND VGND VPWR VPWR sky130_fd_sc_hd__fill_1
XFILLER_82_411 VGND VGND VPWR VPWR sky130_fd_sc_hd__decap_3
X_06874_ _03068_ _03082_ VGND VGND VPWR VPWR _03095_ sky130_fd_sc_hd__nand2_1
XFILLER_131_39 VPWR VGND VPWR VGND sky130_ef_sc_hd__decap_12
X_08613_ net213 net1763 net397 VGND VGND VPWR VPWR _00736_ sky130_fd_sc_hd__mux2_1
X_09593_ _04768_ _04769_ _04770_ _04771_ net659 net646 VGND VGND VPWR VPWR _04774_
+ sky130_fd_sc_hd__mux4_1
XTAP_TAPCELL_ROW_38_856 VGND VPWR sky130_fd_sc_hd__tapvpwrvgnd_1
X_05825_ net811 net964 net567 _02303_ VGND VGND VPWR VPWR _02304_ sky130_fd_sc_hd__a31o_1
X_08544_ net2163 net213 net405 VGND VGND VPWR VPWR _00671_ sky130_fd_sc_hd__mux2_1
X_05756_ net971 _01615_ _02234_ _02236_ _02239_ VGND VGND VPWR VPWR _02240_ sky130_fd_sc_hd__o2111ai_4
XFILLER_24_15 VPWR VGND VPWR VGND sky130_ef_sc_hd__decap_12
XFILLER_35_371 VPWR VGND VPWR VGND sky130_ef_sc_hd__decap_12
X_05687_ net775 net188 VGND VGND VPWR VPWR _02171_ sky130_fd_sc_hd__or2_1
XFILLER_24_37 VGND VGND VPWR VPWR sky130_fd_sc_hd__decap_3
X_08475_ picorv32_core.mem_rdata_q\[21\] _04227_ VGND VGND VPWR VPWR _04320_ sky130_fd_sc_hd__and2_1
XFILLER_35_393 VGND VGND VPWR VPWR sky130_fd_sc_hd__decap_4
X_07426_ net904 picorv32_core.cpuregs\[22\]\[31\] VGND VGND VPWR VPWR _03566_ sky130_fd_sc_hd__and2b_1
XFILLER_50_363 VGND VGND VPWR VPWR sky130_fd_sc_hd__fill_1
XTAP_TAPCELL_ROW_118_2014 VGND VPWR sky130_fd_sc_hd__tapvpwrvgnd_1
X_07357_ net789 picorv32_core.decoded_imm\[16\] VGND VGND VPWR VPWR _03497_ sky130_fd_sc_hd__xnor2_1
X_06308_ net2040 net276 net433 VGND VGND VPWR VPWR _00052_ sky130_fd_sc_hd__mux2_1
XFILLER_6_209 VGND VGND VPWR VPWR sky130_fd_sc_hd__decap_6
XTAP_TAPCELL_ROW_131_2203 VGND VPWR sky130_fd_sc_hd__tapvpwrvgnd_1
XFILLER_108_137 VGND VGND VPWR VPWR sky130_fd_sc_hd__decap_3
X_07288_ net795 picorv32_core.decoded_imm\[13\] VGND VGND VPWR VPWR _03428_ sky130_fd_sc_hd__or2_1
X_09027_ net430 net1764 net340 VGND VGND VPWR VPWR _01196_ sky130_fd_sc_hd__mux2_1
X_06239_ picorv32_core.latched_branch picorv32_core.latched_store net515 VGND VGND
+ VPWR VPWR _02665_ sky130_fd_sc_hd__o21ai_2
Xhold250 picorv32_core.cpuregs\[22\]\[31\] VGND VGND VPWR VPWR net1359 sky130_fd_sc_hd__dlygate4sd3_1
Xhold261 picorv32_core.cpuregs\[21\]\[18\] VGND VGND VPWR VPWR net1370 sky130_fd_sc_hd__dlygate4sd3_1
XFILLER_6_6 VPWR VGND VPWR VGND sky130_ef_sc_hd__decap_12
Xhold283 picorv32_core.cpuregs\[13\]\[24\] VGND VGND VPWR VPWR net1392 sky130_fd_sc_hd__dlygate4sd3_1
Xhold272 picorv32_core.cpuregs\[26\]\[5\] VGND VGND VPWR VPWR net1381 sky130_fd_sc_hd__dlygate4sd3_1
Xhold294 picorv32_core.cpuregs\[31\]\[8\] VGND VGND VPWR VPWR net1403 sky130_fd_sc_hd__dlygate4sd3_1
XFILLER_120_825 VGND VGND VPWR VPWR sky130_fd_sc_hd__decap_8
Xfanout730 _00001_ VGND VGND VPWR VPWR net730 sky130_fd_sc_hd__clkbuf_2
XFILLER_104_376 VGND VGND VPWR VPWR sky130_fd_sc_hd__fill_1
Xfanout741 net746 VGND VGND VPWR VPWR net741 sky130_fd_sc_hd__clkbuf_4
X_09929_ net215 net1440 net323 VGND VGND VPWR VPWR _01413_ sky130_fd_sc_hd__mux2_1
XPHY_EDGE_ROW_130_Right_130 VGND VGND VPWR VPWR sky130_fd_sc_hd__decap_3
XTAP_TAPCELL_ROW_129_2176 VGND VPWR sky130_fd_sc_hd__tapvpwrvgnd_1
Xfanout763 _00000_ VGND VGND VPWR VPWR net763 sky130_fd_sc_hd__buf_2
Xfanout774 net157 VGND VGND VPWR VPWR net774 sky130_fd_sc_hd__clkbuf_2
Xfanout752 net754 VGND VGND VPWR VPWR net752 sky130_fd_sc_hd__buf_4
Xfanout785 net786 VGND VGND VPWR VPWR net785 sky130_fd_sc_hd__clkbuf_2
Xfanout796 net145 VGND VGND VPWR VPWR net796 sky130_fd_sc_hd__clkbuf_4
XFILLER_73_499 VGND VGND VPWR VPWR sky130_fd_sc_hd__fill_2
XTAP_TAPCELL_ROW_16_539 VGND VPWR sky130_fd_sc_hd__tapvpwrvgnd_1
X_10704_ clknet_leaf_29_clk _00555_ VGND VGND VPWR VPWR net109 sky130_fd_sc_hd__dfxtp_1
X_11684_ clknet_leaf_111_clk _01515_ VGND VGND VPWR VPWR picorv32_core.cpuregs\[27\]\[1\]
+ sky130_fd_sc_hd__dfxtp_1
X_10635_ clknet_leaf_118_clk _00489_ VGND VGND VPWR VPWR picorv32_core.cpuregs\[20\]\[3\]
+ sky130_fd_sc_hd__dfxtp_1
Xclkload109 clknet_leaf_101_clk VGND VGND VPWR VPWR clkload109/Y sky130_fd_sc_hd__bufinv_16
XFILLER_10_750 VGND VGND VPWR VPWR sky130_fd_sc_hd__decap_6
X_10566_ clknet_leaf_32_clk _00420_ VGND VGND VPWR VPWR picorv32_core.cpuregs\[25\]\[22\]
+ sky130_fd_sc_hd__dfxtp_1
X_10497_ clknet_leaf_47_clk _00383_ VGND VGND VPWR VPWR net188 sky130_fd_sc_hd__dfxtp_2
XTAP_TAPCELL_ROW_58_1149 VGND VPWR sky130_fd_sc_hd__tapvpwrvgnd_1
XFILLER_96_514 VPWR VGND VPWR VGND sky130_ef_sc_hd__decap_12
XTAP_TAPCELL_ROW_71_1338 VGND VPWR sky130_fd_sc_hd__tapvpwrvgnd_1
X_11118_ clknet_leaf_114_clk _00969_ VGND VGND VPWR VPWR picorv32_core.cpuregs\[8\]\[4\]
+ sky130_fd_sc_hd__dfxtp_1
X_11049_ clknet_leaf_62_clk _00900_ VGND VGND VPWR VPWR picorv32_core.cpuregs\[11\]\[31\]
+ sky130_fd_sc_hd__dfxtp_1
Xinput7 mem_axi_rdata[12] VGND VGND VPWR VPWR net7 sky130_fd_sc_hd__buf_1
XFILLER_37_603 VGND VGND VPWR VPWR sky130_fd_sc_hd__fill_2
XFILLER_37_614 VGND VGND VPWR VPWR sky130_fd_sc_hd__fill_2
X_05610_ picorv32_core.count_instr\[61\] net938 net946 picorv32_core.count_cycle\[61\]
+ VGND VGND VPWR VPWR _02097_ sky130_fd_sc_hd__a22o_1
XFILLER_64_477 VPWR VGND VPWR VGND sky130_ef_sc_hd__decap_12
X_06590_ _02874_ _02875_ VGND VGND VPWR VPWR _00179_ sky130_fd_sc_hd__nor2_1
XTAP_TAPCELL_ROW_35_815 VGND VPWR sky130_fd_sc_hd__tapvpwrvgnd_1
X_05541_ _02031_ _02032_ VGND VGND VPWR VPWR _02033_ sky130_fd_sc_hd__nand2_1
XFILLER_32_341 VGND VGND VPWR VPWR sky130_fd_sc_hd__fill_1
X_05472_ _01966_ _01968_ VGND VGND VPWR VPWR _01969_ sky130_fd_sc_hd__nor2_1
XTAP_TAPCELL_ROW_82_1489 VGND VPWR sky130_fd_sc_hd__tapvpwrvgnd_1
X_08260_ picorv32_core.latched_rd\[0\] picorv32_core.latched_rd\[1\] _02665_ VGND
+ VGND VPWR VPWR _04225_ sky130_fd_sc_hd__or3_4
X_07211_ _03363_ _03364_ VGND VGND VPWR VPWR _00311_ sky130_fd_sc_hd__nor2_1
X_08191_ net1166 net476 _04199_ _04200_ VGND VGND VPWR VPWR _00446_ sky130_fd_sc_hd__a22o_1
X_07142_ picorv32_core.count_cycle\[25\] _03319_ net979 VGND VGND VPWR VPWR _03321_
+ sky130_fd_sc_hd__a21oi_1
XFILLER_133_405 VGND VGND VPWR VPWR sky130_fd_sc_hd__fill_1
X_07073_ _03272_ _03273_ _03277_ net677 VGND VGND VPWR VPWR _03278_ sky130_fd_sc_hd__a22o_1
X_06024_ net779 _02485_ VGND VGND VPWR VPWR _02487_ sky130_fd_sc_hd__nor2_1
X_07975_ _04050_ _04051_ net639 VGND VGND VPWR VPWR _04055_ sky130_fd_sc_hd__mux2_1
X_09714_ net782 net542 _04888_ net472 VGND VGND VPWR VPWR _04889_ sky130_fd_sc_hd__o211a_1
X_06926_ _03141_ _03142_ VGND VGND VPWR VPWR _03143_ sky130_fd_sc_hd__nor2_1
X_09645_ _03515_ _03522_ VGND VGND VPWR VPWR _04823_ sky130_fd_sc_hd__xor2_1
X_06857_ net676 net588 _03075_ _03076_ _03079_ VGND VGND VPWR VPWR _03080_ sky130_fd_sc_hd__a41o_1
XFILLER_55_422 VPWR VGND VPWR VGND sky130_ef_sc_hd__decap_12
XFILLER_27_113 VGND VGND VPWR VPWR sky130_fd_sc_hd__fill_2
X_05808_ net813 _02287_ VGND VGND VPWR VPWR _02288_ sky130_fd_sc_hd__nand2_1
X_09576_ net786 net280 VGND VGND VPWR VPWR _04757_ sky130_fd_sc_hd__and2_1
X_06788_ _03015_ VGND VGND VPWR VPWR _03016_ sky130_fd_sc_hd__inv_2
XFILLER_36_691 VGND VGND VPWR VPWR sky130_fd_sc_hd__fill_1
X_08527_ net1293 net287 net403 VGND VGND VPWR VPWR _00654_ sky130_fd_sc_hd__mux2_1
X_05739_ net805 _02222_ _01598_ net959 VGND VGND VPWR VPWR _02223_ sky130_fd_sc_hd__a2bb2o_1
XFILLER_35_190 VGND VGND VPWR VPWR sky130_fd_sc_hd__fill_2
X_08458_ net680 picorv32_core.decoded_imm_j\[8\] _04283_ picorv32_core.mem_rdata_q\[28\]
+ net524 VGND VGND VPWR VPWR _04310_ sky130_fd_sc_hd__a221o_1
X_07409_ net868 _03546_ _03547_ _03548_ net660 VGND VGND VPWR VPWR _03549_ sky130_fd_sc_hd__o221a_1
X_10420_ clknet_leaf_90_clk _01551_ VGND VGND VPWR VPWR picorv32_core.reg_out\[13\]
+ sky130_fd_sc_hd__dfxtp_1
XFILLER_51_57 VGND VGND VPWR VPWR sky130_fd_sc_hd__fill_2
X_08389_ _01622_ net460 _04269_ net532 VGND VGND VPWR VPWR _00573_ sky130_fd_sc_hd__a2bb2o_1
XFILLER_137_777 VGND VGND VPWR VPWR sky130_fd_sc_hd__decap_6
X_10351_ clknet_leaf_101_clk _00270_ VGND VGND VPWR VPWR picorv32_core.count_cycle\[9\]
+ sky130_fd_sc_hd__dfxtp_1
XFILLER_3_702 VPWR VGND VPWR VGND sky130_ef_sc_hd__decap_12
X_10282_ clknet_leaf_120_clk _00201_ VGND VGND VPWR VPWR picorv32_core.reg_pc\[3\]
+ sky130_fd_sc_hd__dfxtp_1
XTAP_TAPCELL_ROW_111_1917 VGND VPWR sky130_fd_sc_hd__tapvpwrvgnd_1
XFILLER_2_245 VGND VGND VPWR VPWR sky130_fd_sc_hd__decap_6
XFILLER_78_514 VGND VGND VPWR VPWR sky130_fd_sc_hd__fill_1
Xfanout560 net561 VGND VGND VPWR VPWR net560 sky130_fd_sc_hd__clkbuf_2
XTAP_TAPCELL_ROW_53_1079 VGND VPWR sky130_fd_sc_hd__tapvpwrvgnd_1
XTAP_TAPCELL_ROW_53_1068 VGND VPWR sky130_fd_sc_hd__tapvpwrvgnd_1
Xfanout582 _01715_ VGND VGND VPWR VPWR net582 sky130_fd_sc_hd__clkbuf_4
Xfanout571 net572 VGND VGND VPWR VPWR net571 sky130_fd_sc_hd__buf_2
Xfanout593 _01683_ VGND VGND VPWR VPWR net593 sky130_fd_sc_hd__buf_2
XFILLER_65_208 VGND VGND VPWR VPWR sky130_fd_sc_hd__decap_6
XFILLER_19_614 VGND VGND VPWR VPWR sky130_fd_sc_hd__fill_2
XTAP_TAPCELL_ROW_109_1879 VGND VPWR sky130_fd_sc_hd__tapvpwrvgnd_1
XFILLER_73_241 VGND VGND VPWR VPWR sky130_fd_sc_hd__decap_4
XFILLER_61_447 VGND VGND VPWR VPWR sky130_fd_sc_hd__fill_1
X_11667_ clknet_leaf_19_clk _01498_ VGND VGND VPWR VPWR picorv32_core.cpuregs\[26\]\[16\]
+ sky130_fd_sc_hd__dfxtp_1
X_10618_ clknet_leaf_97_clk _00472_ VGND VGND VPWR VPWR picorv32_core.instr_fence
+ sky130_fd_sc_hd__dfxtp_1
XTAP_TAPCELL_ROW_40_884 VGND VPWR sky130_fd_sc_hd__tapvpwrvgnd_1
X_11598_ clknet_leaf_2_clk _01429_ VGND VGND VPWR VPWR picorv32_core.cpuregs\[23\]\[11\]
+ sky130_fd_sc_hd__dfxtp_1
X_10549_ clknet_leaf_139_clk _00403_ VGND VGND VPWR VPWR picorv32_core.cpuregs\[25\]\[5\]
+ sky130_fd_sc_hd__dfxtp_1
XFILLER_123_482 VGND VGND VPWR VPWR sky130_fd_sc_hd__fill_1
XFILLER_37_3 VPWR VGND VPWR VGND sky130_ef_sc_hd__decap_12
XFILLER_96_377 VGND VGND VPWR VPWR sky130_fd_sc_hd__fill_1
XFILLER_84_506 VGND VGND VPWR VPWR sky130_fd_sc_hd__decap_8
X_07760_ _03848_ _03849_ _03851_ _03850_ net688 net682 VGND VGND VPWR VPWR _03852_
+ sky130_fd_sc_hd__mux4_1
XFILLER_37_400 VGND VGND VPWR VPWR sky130_fd_sc_hd__fill_1
X_06711_ _02911_ _02944_ VGND VGND VPWR VPWR _02946_ sky130_fd_sc_hd__or2_1
X_09430_ picorv32_core.cpuregs\[12\]\[11\] picorv32_core.cpuregs\[13\]\[11\] picorv32_core.cpuregs\[14\]\[11\]
+ picorv32_core.cpuregs\[15\]\[11\] net880 net847 VGND VGND VPWR VPWR _04618_ sky130_fd_sc_hd__mux4_1
X_07691_ picorv32_core.cpuregs\[24\]\[10\] picorv32_core.cpuregs\[25\]\[10\] picorv32_core.cpuregs\[26\]\[10\]
+ picorv32_core.cpuregs\[27\]\[10\] net732 net699 VGND VGND VPWR VPWR _03786_ sky130_fd_sc_hd__mux4_1
X_06642_ picorv32_core.count_instr\[63\] picorv32_core.count_instr\[62\] _02905_ net978
+ VGND VGND VPWR VPWR _02909_ sky130_fd_sc_hd__a31o_1
XTAP_TAPCELL_ROW_84_1529 VGND VPWR sky130_fd_sc_hd__tapvpwrvgnd_1
XTAP_TAPCELL_ROW_84_1518 VGND VPWR sky130_fd_sc_hd__tapvpwrvgnd_1
XTAP_TAPCELL_ROW_48_995 VGND VPWR sky130_fd_sc_hd__tapvpwrvgnd_1
XFILLER_52_458 VPWR VGND VPWR VGND sky130_ef_sc_hd__decap_12
X_09361_ picorv32_core.cpuregs\[12\]\[8\] picorv32_core.cpuregs\[13\]\[8\] picorv32_core.cpuregs\[14\]\[8\]
+ picorv32_core.cpuregs\[15\]\[8\] net881 net848 VGND VGND VPWR VPWR _04552_ sky130_fd_sc_hd__mux4_1
X_06573_ net2271 _02863_ net986 VGND VGND VPWR VPWR _02865_ sky130_fd_sc_hd__o21ai_1
X_05524_ picorv32_core.reg_pc\[23\] picorv32_core.decoded_imm\[23\] VGND VGND VPWR
+ VPWR _02017_ sky130_fd_sc_hd__nor2_1
X_08312_ picorv32_core.is_slli_srli_srai net522 _04198_ _04232_ VGND VGND VPWR VPWR
+ _00533_ sky130_fd_sc_hd__a22o_1
X_09292_ picorv32_core.cpuregs\[4\]\[5\] picorv32_core.cpuregs\[5\]\[5\] picorv32_core.cpuregs\[6\]\[5\]
+ picorv32_core.cpuregs\[7\]\[5\] net875 net843 VGND VGND VPWR VPWR _04486_ sky130_fd_sc_hd__mux4_1
XANTENNA_23 _04328_ VGND VGND VPWR VPWR sky130_fd_sc_hd__diode_2
XANTENNA_12 _03391_ VGND VGND VPWR VPWR sky130_fd_sc_hd__diode_2
X_08243_ picorv32_core.mem_rdata_q\[25\] net21 net518 VGND VGND VPWR VPWR _00766_
+ sky130_fd_sc_hd__mux2_1
XANTENNA_45 net159 VGND VGND VPWR VPWR sky130_fd_sc_hd__diode_2
XANTENNA_34 _05039_ VGND VGND VPWR VPWR sky130_fd_sc_hd__diode_2
XANTENNA_56 net459 VGND VGND VPWR VPWR sky130_fd_sc_hd__diode_2
X_05455_ net910 net303 _01950_ net788 net917 VGND VGND VPWR VPWR _01954_ sky130_fd_sc_hd__a32o_1
XANTENNA_89 net647 VGND VGND VPWR VPWR sky130_fd_sc_hd__diode_2
XANTENNA_78 _04348_ VGND VGND VPWR VPWR sky130_fd_sc_hd__diode_2
X_08174_ _00753_ _00754_ _00755_ VGND VGND VPWR VPWR _04192_ sky130_fd_sc_hd__nor3_1
XANTENNA_67 net794 VGND VGND VPWR VPWR sky130_fd_sc_hd__diode_2
X_05386_ _01875_ _01878_ _01888_ _01889_ VGND VGND VPWR VPWR _01550_ sky130_fd_sc_hd__a22o_1
XFILLER_21_27 VPWR VGND VPWR VGND sky130_ef_sc_hd__decap_12
XFILLER_137_27 VPWR VGND VPWR VGND sky130_ef_sc_hd__decap_12
XFILLER_119_777 VGND VGND VPWR VPWR sky130_fd_sc_hd__decap_6
X_07125_ net1206 _03308_ _03310_ VGND VGND VPWR VPWR _00279_ sky130_fd_sc_hd__o21a_1
X_07056_ _03261_ _03262_ net994 VGND VGND VPWR VPWR _00258_ sky130_fd_sc_hd__o21a_1
XFILLER_134_769 VPWR VGND VPWR VGND sky130_ef_sc_hd__decap_12
XFILLER_133_246 VGND VGND VPWR VPWR sky130_fd_sc_hd__decap_4
X_06007_ net955 _02470_ VGND VGND VPWR VPWR _02471_ sky130_fd_sc_hd__xnor2_1
Xoutput130 net130 VGND VGND VPWR VPWR mem_axi_wdata[4] sky130_fd_sc_hd__buf_2
Xoutput141 net823 VGND VGND VPWR VPWR pcpi_rs1[0] sky130_fd_sc_hd__buf_2
Xoutput152 net822 VGND VGND VPWR VPWR pcpi_rs1[1] sky130_fd_sc_hd__buf_2
Xoutput185 net955 VGND VGND VPWR VPWR pcpi_rs2[20] sky130_fd_sc_hd__buf_2
Xoutput174 net958 VGND VGND VPWR VPWR pcpi_rs2[10] sky130_fd_sc_hd__buf_2
Xoutput163 net818 VGND VGND VPWR VPWR pcpi_rs1[2] sky130_fd_sc_hd__buf_2
XFILLER_0_727 VGND VGND VPWR VPWR sky130_fd_sc_hd__fill_1
Xoutput196 net196 VGND VGND VPWR VPWR pcpi_rs2[30] sky130_fd_sc_hd__buf_2
XFILLER_0_749 VGND VGND VPWR VPWR sky130_fd_sc_hd__decap_3
XTAP_TAPCELL_ROW_126_2135 VGND VPWR sky130_fd_sc_hd__tapvpwrvgnd_1
X_07958_ _04029_ _04030_ net637 VGND VGND VPWR VPWR _04039_ sky130_fd_sc_hd__mux2_1
XFILLER_102_699 VGND VGND VPWR VPWR sky130_fd_sc_hd__fill_1
X_07889_ _03971_ _03973_ net458 _03970_ VGND VGND VPWR VPWR _03974_ sky130_fd_sc_hd__o211a_1
X_06909_ net667 picorv32_core.reg_next_pc\[17\] _02929_ net490 VGND VGND VPWR VPWR
+ _03128_ sky130_fd_sc_hd__a22o_1
XFILLER_56_775 VPWR VGND VPWR VGND sky130_ef_sc_hd__decap_12
XFILLER_28_444 VGND VGND VPWR VPWR sky130_fd_sc_hd__fill_2
X_09628_ picorv32_core.cpuregs\[16\]\[20\] picorv32_core.cpuregs\[17\]\[20\] picorv32_core.cpuregs\[18\]\[20\]
+ picorv32_core.cpuregs\[19\]\[20\] net897 net863 VGND VGND VPWR VPWR _04807_ sky130_fd_sc_hd__mux4_1
XFILLER_28_477 VPWR VGND VPWR VGND sky130_ef_sc_hd__decap_12
X_09559_ picorv32_core.cpuregs\[12\]\[17\] picorv32_core.cpuregs\[13\]\[17\] picorv32_core.cpuregs\[14\]\[17\]
+ picorv32_core.cpuregs\[15\]\[17\] net889 net855 VGND VGND VPWR VPWR _04741_ sky130_fd_sc_hd__mux4_1
XFILLER_102_85 VGND VGND VPWR VPWR sky130_fd_sc_hd__decap_4
XFILLER_24_672 VGND VGND VPWR VPWR sky130_fd_sc_hd__decap_3
XTAP_TAPCELL_ROW_26_678 VGND VPWR sky130_fd_sc_hd__tapvpwrvgnd_1
XTAP_TAPCELL_ROW_26_689 VGND VPWR sky130_fd_sc_hd__tapvpwrvgnd_1
XFILLER_141_3 VPWR VGND VPWR VGND sky130_ef_sc_hd__decap_12
XFILLER_8_805 VGND VGND VPWR VPWR sky130_fd_sc_hd__decap_6
Xpicorv32_axi_999 VGND VGND VPWR VPWR picorv32_axi_999/HI eoi[0] sky130_fd_sc_hd__conb_1
XFILLER_11_355 VGND VGND VPWR VPWR sky130_fd_sc_hd__fill_1
XFILLER_7_18 VPWR VGND VPWR VGND sky130_ef_sc_hd__decap_12
X_11521_ clknet_leaf_139_clk _01352_ VGND VGND VPWR VPWR picorv32_core.cpuregs\[30\]\[2\]
+ sky130_fd_sc_hd__dfxtp_1
XTAP_TAPCELL_ROW_137_2286 VGND VPWR sky130_fd_sc_hd__tapvpwrvgnd_1
X_11452_ clknet_leaf_121_clk _01288_ VGND VGND VPWR VPWR picorv32_core.cpuregs\[24\]\[3\]
+ sky130_fd_sc_hd__dfxtp_1
XTAP_TAPCELL_ROW_137_2297 VGND VPWR sky130_fd_sc_hd__tapvpwrvgnd_1
XFILLER_125_714 VPWR VGND VPWR VGND sky130_ef_sc_hd__decap_12
X_10403_ clknet_leaf_75_clk _00322_ VGND VGND VPWR VPWR picorv32_core.count_cycle\[61\]
+ sky130_fd_sc_hd__dfxtp_1
X_11383_ clknet_leaf_84_clk _00028_ VGND VGND VPWR VPWR _00008_ sky130_fd_sc_hd__dfxtp_1
XFILLER_109_298 VGND VGND VPWR VPWR sky130_fd_sc_hd__fill_2
X_10334_ clknet_leaf_59_clk _00253_ VGND VGND VPWR VPWR picorv32_core.reg_next_pc\[24\]
+ sky130_fd_sc_hd__dfxtp_1
XFILLER_98_609 VGND VGND VPWR VPWR sky130_fd_sc_hd__decap_6
XTAP_TAPCELL_ROW_55_1108 VGND VPWR sky130_fd_sc_hd__tapvpwrvgnd_1
XFILLER_112_419 VGND VGND VPWR VPWR sky130_fd_sc_hd__fill_1
X_10265_ clknet_leaf_81_clk _00184_ VGND VGND VPWR VPWR picorv32_core.count_instr\[49\]
+ sky130_fd_sc_hd__dfxtp_1
X_10196_ clknet_leaf_8_clk _00115_ VGND VGND VPWR VPWR picorv32_core.cpuregs\[9\]\[12\]
+ sky130_fd_sc_hd__dfxtp_1
XTAP_TAPCELL_ROW_6_392 VGND VPWR sky130_fd_sc_hd__tapvpwrvgnd_1
Xfanout390 net391 VGND VGND VPWR VPWR net390 sky130_fd_sc_hd__clkbuf_8
XTAP_TAPCELL_ROW_66_1259 VGND VPWR sky130_fd_sc_hd__tapvpwrvgnd_1
XTAP_TAPCELL_ROW_45_954 VGND VPWR sky130_fd_sc_hd__tapvpwrvgnd_1
XFILLER_62_789 VPWR VGND VPWR VGND sky130_ef_sc_hd__decap_12
XFILLER_61_255 VGND VGND VPWR VPWR sky130_fd_sc_hd__fill_1
Xinput10 mem_axi_rdata[15] VGND VGND VPWR VPWR net10 sky130_fd_sc_hd__buf_1
Xinput21 mem_axi_rdata[25] VGND VGND VPWR VPWR net21 sky130_fd_sc_hd__clkbuf_2
X_05240_ picorv32_core.reg_pc\[3\] picorv32_core.decoded_imm\[3\] VGND VGND VPWR VPWR
+ _01753_ sky130_fd_sc_hd__nand2_1
Xinput32 mem_axi_rdata[6] VGND VGND VPWR VPWR net32 sky130_fd_sc_hd__buf_1
X_05171_ _01674_ _01693_ _01695_ _01678_ VGND VGND VPWR VPWR _00014_ sky130_fd_sc_hd__a2bb2o_1
Xhold827 picorv32_core.cpuregs\[7\]\[21\] VGND VGND VPWR VPWR net1936 sky130_fd_sc_hd__dlygate4sd3_1
XFILLER_116_747 VGND VGND VPWR VPWR sky130_fd_sc_hd__decap_8
Xhold816 picorv32_core.cpuregs\[29\]\[6\] VGND VGND VPWR VPWR net1925 sky130_fd_sc_hd__dlygate4sd3_1
Xhold805 picorv32_core.cpuregs\[29\]\[1\] VGND VGND VPWR VPWR net1914 sky130_fd_sc_hd__dlygate4sd3_1
Xhold838 picorv32_core.cpuregs\[30\]\[27\] VGND VGND VPWR VPWR net1947 sky130_fd_sc_hd__dlygate4sd3_1
XFILLER_116_769 VPWR VGND VPWR VGND sky130_ef_sc_hd__decap_12
Xhold849 net66 VGND VGND VPWR VPWR net1958 sky130_fd_sc_hd__dlygate4sd3_1
X_08930_ net294 net1810 net354 VGND VGND VPWR VPWR _01103_ sky130_fd_sc_hd__mux2_1
X_08861_ net429 net2152 net362 VGND VGND VPWR VPWR _01036_ sky130_fd_sc_hd__mux2_1
XFILLER_96_141 VGND VGND VPWR VPWR sky130_fd_sc_hd__fill_2
X_07812_ net685 _03899_ net625 VGND VGND VPWR VPWR _03901_ sky130_fd_sc_hd__a21o_1
XFILLER_111_485 VGND VGND VPWR VPWR sky130_fd_sc_hd__fill_1
X_08792_ net447 net2112 net370 VGND VGND VPWR VPWR _00970_ sky130_fd_sc_hd__mux2_1
X_07743_ net692 _03831_ _03830_ net618 VGND VGND VPWR VPWR _03836_ sky130_fd_sc_hd__o211a_1
XFILLER_65_561 VGND VGND VPWR VPWR sky130_fd_sc_hd__fill_1
XFILLER_53_712 VGND VGND VPWR VPWR sky130_fd_sc_hd__decap_3
X_07674_ net693 _03769_ VGND VGND VPWR VPWR _03770_ sky130_fd_sc_hd__or2_1
X_06625_ picorv32_core.count_instr\[57\] picorv32_core.count_instr\[56\] _02894_ VGND
+ VGND VPWR VPWR _02898_ sky130_fd_sc_hd__and3_1
XFILLER_52_211 VGND VGND VPWR VPWR sky130_fd_sc_hd__decap_4
XFILLER_25_447 VGND VGND VPWR VPWR sky130_fd_sc_hd__fill_1
X_09413_ picorv32_core.cpuregs\[8\]\[10\] picorv32_core.cpuregs\[9\]\[10\] picorv32_core.cpuregs\[10\]\[10\]
+ picorv32_core.cpuregs\[11\]\[10\] net878 net845 VGND VGND VPWR VPWR _04602_ sky130_fd_sc_hd__mux4_1
XTAP_TAPCELL_ROW_121_2065 VGND VPWR sky130_fd_sc_hd__tapvpwrvgnd_1
XTAP_TAPCELL_ROW_121_2054 VGND VPWR sky130_fd_sc_hd__tapvpwrvgnd_1
XFILLER_40_417 VGND VGND VPWR VPWR sky130_fd_sc_hd__decap_3
X_06556_ picorv32_core.count_instr\[32\] picorv32_core.count_instr\[31\] picorv32_core.count_instr\[30\]
+ _02849_ VGND VGND VPWR VPWR _02854_ sky130_fd_sc_hd__and4_2
XTAP_TAPCELL_ROW_23_637 VGND VPWR sky130_fd_sc_hd__tapvpwrvgnd_1
X_09344_ picorv32_core.cpuregs\[12\]\[7\] picorv32_core.cpuregs\[13\]\[7\] picorv32_core.cpuregs\[14\]\[7\]
+ picorv32_core.cpuregs\[15\]\[7\] net881 net848 VGND VGND VPWR VPWR _04536_ sky130_fd_sc_hd__mux4_1
X_05507_ picorv32_core.count_cycle\[21\] net600 VGND VGND VPWR VPWR _02002_ sky130_fd_sc_hd__or2_1
X_06487_ picorv32_core.count_instr\[7\] picorv32_core.count_instr\[6\] picorv32_core.count_instr\[5\]
+ _02805_ VGND VGND VPWR VPWR _02810_ sky130_fd_sc_hd__and4_1
X_09275_ picorv32_core.cpuregs\[12\]\[4\] picorv32_core.cpuregs\[13\]\[4\] picorv32_core.cpuregs\[14\]\[4\]
+ picorv32_core.cpuregs\[15\]\[4\] net886 net853 VGND VGND VPWR VPWR _04470_ sky130_fd_sc_hd__mux4_1
XFILLER_20_130 VGND VGND VPWR VPWR sky130_fd_sc_hd__fill_2
XFILLER_32_15 VPWR VGND VPWR VGND sky130_ef_sc_hd__decap_12
XTAP_TAPCELL_ROW_97_1709 VGND VPWR sky130_fd_sc_hd__tapvpwrvgnd_1
X_05438_ picorv32_core.count_instr\[48\] net938 net942 picorv32_core.count_instr\[16\]
+ VGND VGND VPWR VPWR _01938_ sky130_fd_sc_hd__a22o_1
X_08226_ picorv32_core.mem_rdata_q\[0\] picorv32_core.mem_rdata_q\[1\] VGND VGND VPWR
+ VPWR _04213_ sky130_fd_sc_hd__nand2_1
X_08157_ net930 _01594_ VGND VGND VPWR VPWR _04183_ sky130_fd_sc_hd__nand2_1
XFILLER_134_533 VGND VGND VPWR VPWR sky130_fd_sc_hd__decap_4
X_07108_ net2261 _03298_ net992 VGND VGND VPWR VPWR _03300_ sky130_fd_sc_hd__o21ai_1
X_05369_ net926 _01770_ net585 VGND VGND VPWR VPWR _01873_ sky130_fd_sc_hd__a21o_1
X_08088_ picorv32_core.decoded_imm\[31\] net593 net596 VGND VGND VPWR VPWR _04162_
+ sky130_fd_sc_hd__a21o_1
XFILLER_122_717 VPWR VGND VPWR VGND sky130_ef_sc_hd__decap_12
X_07039_ _03245_ _03246_ VGND VGND VPWR VPWR _03247_ sky130_fd_sc_hd__or2_1
X_10050_ net1287 net292 net304 VGND VGND VPWR VPWR _01525_ sky130_fd_sc_hd__mux2_1
XFILLER_0_546 VGND VGND VPWR VPWR sky130_fd_sc_hd__fill_1
XTAP_TAPCELL_ROW_50_1027 VGND VPWR sky130_fd_sc_hd__tapvpwrvgnd_1
XFILLER_87_174 VGND VGND VPWR VPWR sky130_fd_sc_hd__fill_2
XFILLER_29_720 VGND VGND VPWR VPWR sky130_fd_sc_hd__fill_2
XFILLER_48_528 VGND VGND VPWR VPWR sky130_fd_sc_hd__decap_4
XTAP_TAPCELL_ROW_3_351 VGND VPWR sky130_fd_sc_hd__tapvpwrvgnd_1
XFILLER_29_742 VPWR VGND VPWR VGND sky130_ef_sc_hd__decap_12
X_10952_ clknet_leaf_65_clk _00803_ VGND VGND VPWR VPWR picorv32_core.cpuregs\[19\]\[30\]
+ sky130_fd_sc_hd__dfxtp_1
XFILLER_29_797 VPWR VGND VPWR VGND sky130_ef_sc_hd__decap_12
XTAP_TAPCELL_ROW_106_1849 VGND VPWR sky130_fd_sc_hd__tapvpwrvgnd_1
XTAP_TAPCELL_ROW_106_1838 VGND VPWR sky130_fd_sc_hd__tapvpwrvgnd_1
XFILLER_71_542 VGND VGND VPWR VPWR sky130_fd_sc_hd__fill_1
XFILLER_16_447 VGND VGND VPWR VPWR sky130_fd_sc_hd__decap_4
X_10883_ clknet_leaf_43_clk _00734_ VGND VGND VPWR VPWR picorv32_core.cpuregs\[16\]\[27\]
+ sky130_fd_sc_hd__dfxtp_1
XTAP_TAPCELL_ROW_42_913 VGND VPWR sky130_fd_sc_hd__tapvpwrvgnd_1
XTAP_TAPCELL_ROW_139_2326 VGND VPWR sky130_fd_sc_hd__tapvpwrvgnd_1
XTAP_TAPCELL_ROW_139_2315 VGND VPWR sky130_fd_sc_hd__tapvpwrvgnd_1
X_11504_ clknet_leaf_53_clk _01340_ VGND VGND VPWR VPWR net154 sky130_fd_sc_hd__dfxtp_1
XTAP_TAPCELL_ROW_61_1189 VGND VPWR sky130_fd_sc_hd__tapvpwrvgnd_1
XFILLER_137_382 VGND VGND VPWR VPWR sky130_fd_sc_hd__fill_1
XFILLER_137_360 VGND VGND VPWR VPWR sky130_fd_sc_hd__fill_1
X_11435_ clknet_leaf_50_clk _01271_ VGND VGND VPWR VPWR picorv32_core.cpuregs\[1\]\[18\]
+ sky130_fd_sc_hd__dfxtp_1
XFILLER_7_167 VGND VGND VPWR VPWR sky130_fd_sc_hd__fill_1
XFILLER_125_544 VGND VGND VPWR VPWR sky130_fd_sc_hd__fill_1
X_11366_ clknet_leaf_51_clk _01207_ VGND VGND VPWR VPWR picorv32_core.cpuregs\[18\]\[18\]
+ sky130_fd_sc_hd__dfxtp_1
X_11297_ clknet_leaf_40_clk _01145_ VGND VGND VPWR VPWR picorv32_core.cpuregs\[3\]\[20\]
+ sky130_fd_sc_hd__dfxtp_1
X_10317_ clknet_leaf_123_clk _00236_ VGND VGND VPWR VPWR picorv32_core.reg_next_pc\[7\]
+ sky130_fd_sc_hd__dfxtp_1
X_10248_ clknet_leaf_79_clk _00167_ VGND VGND VPWR VPWR picorv32_core.count_instr\[32\]
+ sky130_fd_sc_hd__dfxtp_1
XFILLER_39_517 VGND VGND VPWR VPWR sky130_fd_sc_hd__fill_1
X_10179_ clknet_leaf_43_clk _00098_ VGND VGND VPWR VPWR picorv32_core.cpuregs\[21\]\[27\]
+ sky130_fd_sc_hd__dfxtp_1
XFILLER_121_783 VGND VGND VPWR VPWR sky130_fd_sc_hd__fill_1
XFILLER_93_122 VGND VGND VPWR VPWR sky130_fd_sc_hd__fill_2
XFILLER_93_166 VGND VGND VPWR VPWR sky130_fd_sc_hd__fill_2
XFILLER_62_531 VGND VGND VPWR VPWR sky130_fd_sc_hd__fill_1
XFILLER_35_734 VGND VGND VPWR VPWR sky130_fd_sc_hd__fill_1
X_06410_ net430 net2127 net422 VGND VGND VPWR VPWR _00078_ sky130_fd_sc_hd__mux2_1
X_07390_ _03407_ _03408_ _03529_ VGND VGND VPWR VPWR _03530_ sky130_fd_sc_hd__or3_1
X_06341_ _02745_ _02746_ net565 VGND VGND VPWR VPWR _02747_ sky130_fd_sc_hd__mux2_1
XFILLER_15_491 VGND VGND VPWR VPWR sky130_fd_sc_hd__fill_2
X_09060_ net1256 net429 net336 VGND VGND VPWR VPWR _01228_ sky130_fd_sc_hd__mux2_1
XFILLER_30_461 VGND VGND VPWR VPWR sky130_fd_sc_hd__decap_6
X_06272_ picorv32_core.reg_out\[7\] picorv32_core.alu_out_q\[7\] net950 VGND VGND
+ VPWR VPWR _02691_ sky130_fd_sc_hd__mux2_1
X_08011_ net685 _04088_ _04087_ net458 VGND VGND VPWR VPWR _04089_ sky130_fd_sc_hd__o211a_1
XFILLER_8_83 VGND VGND VPWR VPWR sky130_fd_sc_hd__fill_1
X_05223_ net915 net822 _01732_ net908 _01737_ VGND VGND VPWR VPWR _01738_ sky130_fd_sc_hd__a221o_1
XFILLER_118_29 VGND VGND VPWR VPWR sky130_fd_sc_hd__fill_1
Xhold602 picorv32_core.cpuregs\[26\]\[20\] VGND VGND VPWR VPWR net1711 sky130_fd_sc_hd__dlygate4sd3_1
XFILLER_116_533 VGND VGND VPWR VPWR sky130_fd_sc_hd__fill_1
Xhold613 picorv32_core.cpuregs\[12\]\[14\] VGND VGND VPWR VPWR net1722 sky130_fd_sc_hd__dlygate4sd3_1
Xhold635 net39 VGND VGND VPWR VPWR net1744 sky130_fd_sc_hd__dlygate4sd3_1
Xhold624 picorv32_core.cpuregs\[29\]\[4\] VGND VGND VPWR VPWR net1733 sky130_fd_sc_hd__dlygate4sd3_1
X_05154_ picorv32_core.is_lb_lh_lw_lbu_lhu _01680_ VGND VGND VPWR VPWR _01681_ sky130_fd_sc_hd__nor2_1
Xhold679 picorv32_core.cpuregs\[1\]\[20\] VGND VGND VPWR VPWR net1788 sky130_fd_sc_hd__dlygate4sd3_1
X_09962_ net1297 net241 net318 VGND VGND VPWR VPWR _01440_ sky130_fd_sc_hd__mux2_1
XTAP_TAPCELL_ROW_92_1639 VGND VPWR sky130_fd_sc_hd__tapvpwrvgnd_1
Xhold668 picorv32_core.cpuregs\[3\]\[11\] VGND VGND VPWR VPWR net1777 sky130_fd_sc_hd__dlygate4sd3_1
Xhold657 picorv32_core.cpuregs\[14\]\[6\] VGND VGND VPWR VPWR net1766 sky130_fd_sc_hd__dlygate4sd3_1
X_05085_ net687 VGND VGND VPWR VPWR _01620_ sky130_fd_sc_hd__inv_2
Xhold646 picorv32_core.cpuregs\[20\]\[10\] VGND VGND VPWR VPWR net1755 sky130_fd_sc_hd__dlygate4sd3_1
X_08913_ net227 net1627 net361 VGND VGND VPWR VPWR _01087_ sky130_fd_sc_hd__mux2_1
XFILLER_131_569 VGND VGND VPWR VPWR sky130_fd_sc_hd__decap_4
X_09893_ net1334 net206 net327 VGND VGND VPWR VPWR _01381_ sky130_fd_sc_hd__mux2_1
X_08844_ net1566 net238 net367 VGND VGND VPWR VPWR _01020_ sky130_fd_sc_hd__mux2_1
XFILLER_85_634 VGND VGND VPWR VPWR sky130_fd_sc_hd__fill_1
X_08775_ net244 net2109 net375 VGND VGND VPWR VPWR _00922_ sky130_fd_sc_hd__mux2_1
X_05987_ _02432_ _02435_ _02439_ _02441_ VGND VGND VPWR VPWR _02453_ sky130_fd_sc_hd__a31o_1
XFILLER_27_15 VPWR VGND VPWR VGND sky130_ef_sc_hd__decap_12
XFILLER_85_689 VPWR VGND VPWR VGND sky130_ef_sc_hd__decap_12
XTAP_TAPCELL_ROW_0_310 VGND VPWR sky130_fd_sc_hd__tapvpwrvgnd_1
XTAP_TAPCELL_ROW_28_707 VGND VPWR sky130_fd_sc_hd__tapvpwrvgnd_1
XTAP_TAPCELL_ROW_28_718 VGND VPWR sky130_fd_sc_hd__tapvpwrvgnd_1
X_07726_ _03818_ _03819_ net457 _03816_ VGND VGND VPWR VPWR _03820_ sky130_fd_sc_hd__o211a_1
XFILLER_53_553 VGND VGND VPWR VPWR sky130_fd_sc_hd__fill_1
X_07657_ picorv32_core.cpuregs\[16\]\[8\] picorv32_core.cpuregs\[17\]\[8\] picorv32_core.cpuregs\[18\]\[8\]
+ picorv32_core.cpuregs\[19\]\[8\] net739 net706 VGND VGND VPWR VPWR _03754_ sky130_fd_sc_hd__mux4_1
X_06608_ picorv32_core.count_instr\[51\] picorv32_core.count_instr\[48\] _02879_ _02885_
+ VGND VGND VPWR VPWR _02887_ sky130_fd_sc_hd__and4_1
XFILLER_80_372 VGND VGND VPWR VPWR sky130_fd_sc_hd__decap_8
XFILLER_53_586 VGND VGND VPWR VPWR sky130_fd_sc_hd__decap_3
X_07588_ _01603_ net510 _03691_ VGND VGND VPWR VPWR _00361_ sky130_fd_sc_hd__o21ai_1
XFILLER_40_203 VGND VGND VPWR VPWR sky130_fd_sc_hd__fill_1
XFILLER_139_614 VGND VGND VPWR VPWR sky130_fd_sc_hd__fill_2
X_06539_ _02843_ net997 _02842_ VGND VGND VPWR VPWR _00160_ sky130_fd_sc_hd__and3b_1
X_09327_ _04512_ _04518_ _04519_ net642 net648 VGND VGND VPWR VPWR _04520_ sky130_fd_sc_hd__a221o_1
XTAP_TAPCELL_ROW_101_1768 VGND VPWR sky130_fd_sc_hd__tapvpwrvgnd_1
XFILLER_21_472 VGND VGND VPWR VPWR sky130_fd_sc_hd__fill_1
Xpicorv32_axi_1012 VGND VGND VPWR VPWR picorv32_axi_1012/HI eoi[13] sky130_fd_sc_hd__conb_1
Xpicorv32_axi_1001 VGND VGND VPWR VPWR picorv32_axi_1001/HI eoi[2] sky130_fd_sc_hd__conb_1
XFILLER_127_809 VPWR VGND VPWR VGND sky130_ef_sc_hd__decap_12
X_09258_ _03456_ _03467_ _03468_ _01637_ VGND VGND VPWR VPWR _04453_ sky130_fd_sc_hd__a31o_1
Xpicorv32_axi_1023 VGND VGND VPWR VPWR picorv32_axi_1023/HI eoi[24] sky130_fd_sc_hd__conb_1
XFILLER_138_179 VGND VGND VPWR VPWR sky130_fd_sc_hd__fill_1
XTAP_TAPCELL_ROW_134_2245 VGND VPWR sky130_fd_sc_hd__tapvpwrvgnd_1
X_08209_ net981 picorv32_core.is_alu_reg_reg net531 VGND VGND VPWR VPWR _04207_ sky130_fd_sc_hd__and3_1
X_09189_ picorv32_core.cpuregs\[8\]\[1\] picorv32_core.cpuregs\[9\]\[1\] net887 VGND
+ VGND VPWR VPWR _04387_ sky130_fd_sc_hd__mux2_1
Xpicorv32_axi_1034 VGND VGND VPWR VPWR picorv32_axi_1034/HI mem_axi_arprot[1] sky130_fd_sc_hd__conb_1
Xpicorv32_axi_1045 VGND VGND VPWR VPWR picorv32_axi_1045/HI pcpi_insn[5] sky130_fd_sc_hd__conb_1
Xpicorv32_axi_1078 VGND VGND VPWR VPWR picorv32_axi_1078/HI trace_data[5] sky130_fd_sc_hd__conb_1
XFILLER_119_393 VGND VGND VPWR VPWR sky130_fd_sc_hd__decap_6
XFILLER_104_3 VPWR VGND VPWR VGND sky130_ef_sc_hd__decap_12
Xpicorv32_axi_1089 VGND VGND VPWR VPWR picorv32_axi_1089/HI trace_data[16] sky130_fd_sc_hd__conb_1
Xpicorv32_axi_1056 VGND VGND VPWR VPWR picorv32_axi_1056/HI pcpi_insn[16] sky130_fd_sc_hd__conb_1
Xpicorv32_axi_1067 VGND VGND VPWR VPWR picorv32_axi_1067/HI pcpi_insn[27] sky130_fd_sc_hd__conb_1
X_11220_ clknet_leaf_144_clk _01071_ VGND VGND VPWR VPWR picorv32_core.cpuregs\[5\]\[10\]
+ sky130_fd_sc_hd__dfxtp_1
XTAP_TAPCELL_ROW_8_421 VGND VPWR sky130_fd_sc_hd__tapvpwrvgnd_1
X_11151_ clknet_leaf_137_clk _01002_ VGND VGND VPWR VPWR picorv32_core.cpuregs\[7\]\[5\]
+ sky130_fd_sc_hd__dfxtp_1
XFILLER_108_73 VGND VGND VPWR VPWR sky130_fd_sc_hd__fill_2
X_10102_ net1150 VGND VGND VPWR VPWR _00952_ sky130_fd_sc_hd__clkbuf_1
XFILLER_95_409 VGND VGND VPWR VPWR sky130_fd_sc_hd__fill_1
X_11082_ clknet_leaf_133_clk _00933_ VGND VGND VPWR VPWR picorv32_core.cpuregs\[0\]\[0\]
+ sky130_fd_sc_hd__dfxtp_1
X_10033_ net1902 net224 net310 VGND VGND VPWR VPWR _01509_ sky130_fd_sc_hd__mux2_1
XFILLER_0_365 VGND VGND VPWR VPWR sky130_fd_sc_hd__fill_2
XFILLER_124_61 VGND VGND VPWR VPWR sky130_fd_sc_hd__fill_2
XFILLER_36_509 VGND VGND VPWR VPWR sky130_fd_sc_hd__fill_2
XFILLER_91_637 VGND VGND VPWR VPWR sky130_fd_sc_hd__fill_1
XFILLER_91_615 VGND VGND VPWR VPWR sky130_fd_sc_hd__fill_1
XFILLER_64_829 VGND VGND VPWR VPWR sky130_fd_sc_hd__fill_2
XFILLER_16_222 VGND VGND VPWR VPWR sky130_fd_sc_hd__fill_1
XFILLER_44_542 VGND VGND VPWR VPWR sky130_fd_sc_hd__decap_3
X_10935_ clknet_leaf_9_clk _00786_ VGND VGND VPWR VPWR picorv32_core.cpuregs\[19\]\[13\]
+ sky130_fd_sc_hd__dfxtp_1
XFILLER_44_575 VGND VGND VPWR VPWR sky130_fd_sc_hd__fill_1
XTAP_TAPCELL_ROW_63_1218 VGND VPWR sky130_fd_sc_hd__tapvpwrvgnd_1
XFILLER_31_225 VGND VGND VPWR VPWR sky130_fd_sc_hd__fill_1
XFILLER_32_737 VGND VGND VPWR VPWR sky130_fd_sc_hd__decap_3
X_10866_ clknet_leaf_2_clk _00717_ VGND VGND VPWR VPWR picorv32_core.cpuregs\[16\]\[10\]
+ sky130_fd_sc_hd__dfxtp_1
XFILLER_129_113 VGND VGND VPWR VPWR sky130_fd_sc_hd__decap_4
X_10797_ clknet_leaf_142_clk _00648_ VGND VGND VPWR VPWR picorv32_core.cpuregs\[15\]\[6\]
+ sky130_fd_sc_hd__dfxtp_1
XFILLER_8_421 VGND VGND VPWR VPWR sky130_fd_sc_hd__fill_2
XFILLER_8_432 VGND VGND VPWR VPWR sky130_fd_sc_hd__decap_4
X_11418_ clknet_leaf_109_clk _01254_ VGND VGND VPWR VPWR picorv32_core.cpuregs\[1\]\[1\]
+ sky130_fd_sc_hd__dfxtp_1
XFILLER_3_181 VPWR VGND VPWR VGND sky130_ef_sc_hd__decap_12
X_11349_ clknet_leaf_113_clk _01190_ VGND VGND VPWR VPWR picorv32_core.cpuregs\[18\]\[1\]
+ sky130_fd_sc_hd__dfxtp_1
XFILLER_140_399 VGND VGND VPWR VPWR sky130_fd_sc_hd__fill_1
X_06890_ _03092_ _03100_ _03108_ net664 VGND VGND VPWR VPWR _03110_ sky130_fd_sc_hd__a31o_1
X_05910_ _02334_ _02344_ _02381_ _02343_ VGND VGND VPWR VPWR _02382_ sky130_fd_sc_hd__a211o_1
XFILLER_94_453 VGND VGND VPWR VPWR sky130_fd_sc_hd__decap_3
X_05841_ _02317_ _02318_ _02307_ VGND VGND VPWR VPWR picorv32_core.alu_out\[6\] sky130_fd_sc_hd__a21o_1
XFILLER_94_475 VGND VGND VPWR VPWR sky130_fd_sc_hd__fill_1
XFILLER_81_103 VGND VGND VPWR VPWR sky130_fd_sc_hd__fill_1
XTAP_TAPCELL_ROW_89_1590 VGND VPWR sky130_fd_sc_hd__tapvpwrvgnd_1
X_08560_ net290 net1796 net398 VGND VGND VPWR VPWR _00685_ sky130_fd_sc_hd__mux2_1
X_05772_ net2338 _02247_ _02251_ _02255_ VGND VGND VPWR VPWR _02256_ sky130_fd_sc_hd__a211o_1
X_07511_ net2175 _03628_ net463 VGND VGND VPWR VPWR _00347_ sky130_fd_sc_hd__mux2_1
XFILLER_81_158 VGND VGND VPWR VPWR sky130_fd_sc_hd__fill_2
X_08491_ net1499 net291 net407 VGND VGND VPWR VPWR _00621_ sky130_fd_sc_hd__mux2_1
XFILLER_62_394 VGND VGND VPWR VPWR sky130_fd_sc_hd__fill_2
XFILLER_22_203 VGND VGND VPWR VPWR sky130_fd_sc_hd__fill_1
X_07442_ picorv32_core.reg_out\[2\] picorv32_core.reg_next_pc\[2\] net555 VGND VGND
+ VPWR VPWR _03581_ sky130_fd_sc_hd__mux2_1
X_07373_ _03419_ _03512_ VGND VGND VPWR VPWR _03513_ sky130_fd_sc_hd__and2_1
X_09112_ net227 net1692 net335 VGND VGND VPWR VPWR _01279_ sky130_fd_sc_hd__mux2_1
X_06324_ picorv32_core.reg_pc\[16\] _02726_ picorv32_core.reg_pc\[17\] VGND VGND VPWR
+ VPWR _02733_ sky130_fd_sc_hd__a21oi_1
XFILLER_13_39 VPWR VGND VPWR VGND sky130_ef_sc_hd__decap_12
XTAP_TAPCELL_ROW_33_787 VGND VPWR sky130_fd_sc_hd__tapvpwrvgnd_1
XFILLER_136_617 VGND VGND VPWR VPWR sky130_fd_sc_hd__decap_6
XFILLER_129_39 VPWR VGND VPWR VGND sky130_ef_sc_hd__decap_12
XFILLER_109_809 VGND VGND VPWR VPWR sky130_fd_sc_hd__decap_8
XFILLER_135_105 VGND VGND VPWR VPWR sky130_fd_sc_hd__decap_6
X_09043_ net238 net1927 net343 VGND VGND VPWR VPWR _01212_ sky130_fd_sc_hd__mux2_1
X_06255_ net1305 net494 net434 VGND VGND VPWR VPWR _00042_ sky130_fd_sc_hd__mux2_1
Xhold410 picorv32_core.cpuregs\[31\]\[30\] VGND VGND VPWR VPWR net1519 sky130_fd_sc_hd__dlygate4sd3_1
XFILLER_116_330 VGND VGND VPWR VPWR sky130_fd_sc_hd__fill_2
XPHY_EDGE_ROW_111_Right_111 VGND VGND VPWR VPWR sky130_fd_sc_hd__decap_3
X_05206_ _01716_ _01721_ VGND VGND VPWR VPWR _01722_ sky130_fd_sc_hd__nand2_2
X_06186_ _02616_ _02617_ net628 VGND VGND VPWR VPWR _02618_ sky130_fd_sc_hd__mux2_1
Xhold443 picorv32_core.cpuregs\[6\]\[15\] VGND VGND VPWR VPWR net1552 sky130_fd_sc_hd__dlygate4sd3_1
Xhold454 picorv32_core.cpuregs\[24\]\[12\] VGND VGND VPWR VPWR net1563 sky130_fd_sc_hd__dlygate4sd3_1
XFILLER_2_608 VGND VGND VPWR VPWR sky130_fd_sc_hd__fill_1
Xhold421 picorv32_core.cpuregs\[20\]\[9\] VGND VGND VPWR VPWR net1530 sky130_fd_sc_hd__dlygate4sd3_1
Xhold432 picorv32_core.cpuregs\[24\]\[4\] VGND VGND VPWR VPWR net1541 sky130_fd_sc_hd__dlygate4sd3_1
X_05137_ picorv32_core.mem_do_wdata picorv32_core.mem_do_rdata VGND VGND VPWR VPWR
+ _01667_ sky130_fd_sc_hd__nor2_1
Xhold465 picorv32_core.cpuregs\[11\]\[17\] VGND VGND VPWR VPWR net1574 sky130_fd_sc_hd__dlygate4sd3_1
Xhold476 picorv32_core.cpuregs\[19\]\[12\] VGND VGND VPWR VPWR net1585 sky130_fd_sc_hd__dlygate4sd3_1
Xhold487 picorv32_core.cpuregs\[1\]\[4\] VGND VGND VPWR VPWR net1596 sky130_fd_sc_hd__dlygate4sd3_1
Xhold498 picorv32_core.cpuregs\[17\]\[30\] VGND VGND VPWR VPWR net1607 sky130_fd_sc_hd__dlygate4sd3_1
Xfanout901 net902 VGND VGND VPWR VPWR net901 sky130_fd_sc_hd__buf_4
Xfanout934 picorv32_core.decoded_imm_j\[20\] VGND VGND VPWR VPWR net934 sky130_fd_sc_hd__buf_2
XFILLER_77_409 VGND VGND VPWR VPWR sky130_fd_sc_hd__decap_6
Xfanout923 picorv32_core.cpu_state\[3\] VGND VGND VPWR VPWR net923 sky130_fd_sc_hd__clkbuf_4
Xfanout912 picorv32_core.cpu_state\[6\] VGND VGND VPWR VPWR net912 sky130_fd_sc_hd__clkbuf_2
XFILLER_58_601 VGND VGND VPWR VPWR sky130_fd_sc_hd__fill_2
X_09945_ net1407 net449 net316 VGND VGND VPWR VPWR _01423_ sky130_fd_sc_hd__mux2_1
X_05068_ net968 VGND VGND VPWR VPWR _01603_ sky130_fd_sc_hd__inv_2
Xfanout945 net946 VGND VGND VPWR VPWR net945 sky130_fd_sc_hd__buf_2
Xfanout956 net180 VGND VGND VPWR VPWR net956 sky130_fd_sc_hd__buf_2
X_09876_ net1360 net274 net325 VGND VGND VPWR VPWR _01364_ sky130_fd_sc_hd__mux2_1
XFILLER_58_634 VGND VGND VPWR VPWR sky130_fd_sc_hd__fill_2
Xfanout967 picorv32_core.mem_la_wdata\[2\] VGND VGND VPWR VPWR net967 sky130_fd_sc_hd__clkbuf_4
Xhold1121 picorv32_core.cpuregs\[4\]\[23\] VGND VGND VPWR VPWR net2230 sky130_fd_sc_hd__dlygate4sd3_1
Xfanout978 net979 VGND VGND VPWR VPWR net978 sky130_fd_sc_hd__clkbuf_2
Xhold1110 picorv32_core.cpuregs\[2\]\[18\] VGND VGND VPWR VPWR net2219 sky130_fd_sc_hd__dlygate4sd3_1
Xfanout989 net38 VGND VGND VPWR VPWR net989 sky130_fd_sc_hd__clkbuf_4
XFILLER_85_431 VGND VGND VPWR VPWR sky130_fd_sc_hd__decap_3
Xhold1132 picorv32_core.cpuregs\[29\]\[17\] VGND VGND VPWR VPWR net2241 sky130_fd_sc_hd__dlygate4sd3_1
XFILLER_58_645 VGND VGND VPWR VPWR sky130_fd_sc_hd__decap_8
X_08827_ net1372 net443 net366 VGND VGND VPWR VPWR _01003_ sky130_fd_sc_hd__mux2_1
Xhold1176 net55 VGND VGND VPWR VPWR net2285 sky130_fd_sc_hd__dlygate4sd3_1
XFILLER_100_764 VGND VGND VPWR VPWR sky130_fd_sc_hd__decap_4
Xhold1143 picorv32_core.count_instr\[20\] VGND VGND VPWR VPWR net2252 sky130_fd_sc_hd__dlygate4sd3_1
Xhold1154 picorv32_core.count_instr\[7\] VGND VGND VPWR VPWR net2263 sky130_fd_sc_hd__dlygate4sd3_1
Xhold1165 picorv32_core.count_cycle\[6\] VGND VGND VPWR VPWR net2274 sky130_fd_sc_hd__dlygate4sd3_1
Xhold1198 net49 VGND VGND VPWR VPWR net2307 sky130_fd_sc_hd__dlygate4sd3_1
Xhold1187 picorv32_core.instr_bne VGND VGND VPWR VPWR net2296 sky130_fd_sc_hd__dlygate4sd3_1
X_08758_ net465 net2032 net377 VGND VGND VPWR VPWR _00905_ sky130_fd_sc_hd__mux2_1
XFILLER_26_531 VGND VGND VPWR VPWR sky130_fd_sc_hd__fill_1
XFILLER_60_309 VGND VGND VPWR VPWR sky130_fd_sc_hd__fill_2
X_07709_ net958 net513 _03802_ _03803_ VGND VGND VPWR VPWR _00370_ sky130_fd_sc_hd__o22a_1
X_08689_ net1222 net498 net383 VGND VGND VPWR VPWR _00838_ sky130_fd_sc_hd__mux2_1
X_10720_ clknet_leaf_27_clk _00571_ VGND VGND VPWR VPWR net127 sky130_fd_sc_hd__dfxtp_1
XFILLER_13_225 VGND VGND VPWR VPWR sky130_fd_sc_hd__decap_3
XFILLER_14_737 VPWR VGND VPWR VGND sky130_ef_sc_hd__decap_12
XFILLER_41_556 VGND VGND VPWR VPWR sky130_fd_sc_hd__fill_1
X_10651_ clknet_leaf_31_clk _00505_ VGND VGND VPWR VPWR picorv32_core.cpuregs\[20\]\[19\]
+ sky130_fd_sc_hd__dfxtp_1
XFILLER_22_781 VPWR VGND VPWR VGND sky130_ef_sc_hd__decap_12
X_10582_ clknet_leaf_92_clk _00436_ VGND VGND VPWR VPWR picorv32_core.instr_bltu sky130_fd_sc_hd__dfxtp_1
XTAP_TAPCELL_ROW_11_459 VGND VPWR sky130_fd_sc_hd__tapvpwrvgnd_1
XFILLER_5_413 VGND VGND VPWR VPWR sky130_fd_sc_hd__decap_3
X_11203_ clknet_leaf_71_clk _01054_ VGND VGND VPWR VPWR picorv32_core.cpuregs\[6\]\[25\]
+ sky130_fd_sc_hd__dfxtp_1
XTAP_TAPCELL_ROW_114_1959 VGND VPWR sky130_fd_sc_hd__tapvpwrvgnd_1
X_11134_ clknet_leaf_50_clk _00985_ VGND VGND VPWR VPWR picorv32_core.cpuregs\[8\]\[20\]
+ sky130_fd_sc_hd__dfxtp_1
XFILLER_96_729 VGND VGND VPWR VPWR sky130_fd_sc_hd__fill_1
XFILLER_1_641 VPWR VGND VPWR VGND sky130_ef_sc_hd__decap_12
X_11065_ clknet_leaf_9_clk _00916_ VGND VGND VPWR VPWR picorv32_core.cpuregs\[10\]\[15\]
+ sky130_fd_sc_hd__dfxtp_1
XFILLER_1_685 VPWR VGND VPWR VGND sky130_ef_sc_hd__decap_12
XFILLER_135_93 VPWR VGND VPWR VGND sky130_ef_sc_hd__decap_12
X_10016_ net1416 net297 net308 VGND VGND VPWR VPWR _01492_ sky130_fd_sc_hd__mux2_1
XFILLER_36_317 VGND VGND VPWR VPWR sky130_fd_sc_hd__decap_4
XFILLER_29_391 VGND VGND VPWR VPWR sky130_fd_sc_hd__fill_1
XFILLER_63_169 VGND VGND VPWR VPWR sky130_fd_sc_hd__decap_3
XPHY_EDGE_ROW_127_Left_269 VGND VGND VPWR VPWR sky130_fd_sc_hd__decap_3
X_10918_ clknet_leaf_97_clk _00769_ VGND VGND VPWR VPWR picorv32_core.mem_rdata_q\[28\]
+ sky130_fd_sc_hd__dfxtp_1
X_10849_ clknet_leaf_45_clk _00700_ VGND VGND VPWR VPWR picorv32_core.cpuregs\[17\]\[26\]
+ sky130_fd_sc_hd__dfxtp_1
XFILLER_9_741 VPWR VGND VPWR VGND sky130_ef_sc_hd__decap_12
XTAP_TAPCELL_ROW_30_735 VGND VPWR sky130_fd_sc_hd__tapvpwrvgnd_1
XTAP_TAPCELL_ROW_30_746 VGND VPWR sky130_fd_sc_hd__tapvpwrvgnd_1
XFILLER_12_291 VGND VGND VPWR VPWR sky130_fd_sc_hd__fill_1
XFILLER_9_785 VPWR VGND VPWR VGND sky130_ef_sc_hd__decap_12
X_06040_ _02472_ _02480_ _02486_ _02487_ _02499_ VGND VGND VPWR VPWR _02502_ sky130_fd_sc_hd__a311o_1
XTAP_TAPCELL_ROW_76_1409 VGND VPWR sky130_fd_sc_hd__tapvpwrvgnd_1
XFILLER_126_661 VGND VGND VPWR VPWR sky130_fd_sc_hd__decap_3
XPHY_EDGE_ROW_136_Left_278 VGND VGND VPWR VPWR sky130_fd_sc_hd__decap_3
XFILLER_140_141 VPWR VGND VPWR VGND sky130_ef_sc_hd__decap_12
X_07991_ _04059_ _04068_ _04069_ net622 net690 VGND VGND VPWR VPWR _04070_ sky130_fd_sc_hd__a221o_1
Xfanout208 net209 VGND VGND VPWR VPWR net208 sky130_fd_sc_hd__clkbuf_2
Xfanout219 _02781_ VGND VGND VPWR VPWR net219 sky130_fd_sc_hd__clkbuf_2
Xclkbuf_4_7_0_clk clknet_0_clk VGND VGND VPWR VPWR clknet_4_7_0_clk sky130_fd_sc_hd__clkbuf_8
X_09730_ net284 _04891_ _04904_ _04885_ VGND VGND VPWR VPWR _01343_ sky130_fd_sc_hd__a31o_1
X_06942_ _02931_ _03135_ _02932_ VGND VGND VPWR VPWR _03158_ sky130_fd_sc_hd__a21o_1
X_09661_ _04830_ _04831_ net660 VGND VGND VPWR VPWR _04839_ sky130_fd_sc_hd__mux2_1
X_06873_ _03092_ _03093_ VGND VGND VPWR VPWR _03094_ sky130_fd_sc_hd__nand2_1
X_08612_ net220 net2150 net397 VGND VGND VPWR VPWR _00735_ sky130_fd_sc_hd__mux2_1
XFILLER_94_283 VGND VGND VPWR VPWR sky130_fd_sc_hd__fill_1
X_09592_ picorv32_core.cpuregs\[8\]\[18\] picorv32_core.cpuregs\[9\]\[18\] picorv32_core.cpuregs\[10\]\[18\]
+ picorv32_core.cpuregs\[11\]\[18\] net892 net858 VGND VGND VPWR VPWR _04773_ sky130_fd_sc_hd__mux4_1
X_05824_ net811 net964 net606 _02302_ VGND VGND VPWR VPWR _02303_ sky130_fd_sc_hd__o22a_1
X_08543_ net1447 net217 net405 VGND VGND VPWR VPWR _00670_ sky130_fd_sc_hd__mux2_1
X_05755_ _02168_ _02209_ _02238_ _02169_ VGND VGND VPWR VPWR _02239_ sky130_fd_sc_hd__o2bb2a_1
XTAP_TAPCELL_ROW_38_857 VGND VPWR sky130_fd_sc_hd__tapvpwrvgnd_1
XTAP_TAPCELL_ROW_18_570 VGND VPWR sky130_fd_sc_hd__tapvpwrvgnd_1
XFILLER_35_383 VGND VGND VPWR VPWR sky130_fd_sc_hd__fill_1
X_05686_ net775 net188 VGND VGND VPWR VPWR _02170_ sky130_fd_sc_hd__nand2_1
XFILLER_24_27 VGND VGND VPWR VPWR sky130_fd_sc_hd__fill_1
X_08474_ picorv32_core.decoded_imm\[2\] net527 _04318_ _04319_ VGND VGND VPWR VPWR
+ _00608_ sky130_fd_sc_hd__o22a_1
X_07425_ picorv32_core.cpuregs\[20\]\[31\] picorv32_core.cpuregs\[21\]\[31\] net904
+ VGND VGND VPWR VPWR _03565_ sky130_fd_sc_hd__mux2_1
XFILLER_11_729 VPWR VGND VPWR VGND sky130_ef_sc_hd__decap_12
XFILLER_11_718 VGND VGND VPWR VPWR sky130_fd_sc_hd__decap_8
XTAP_TAPCELL_ROW_118_2015 VGND VPWR sky130_fd_sc_hd__tapvpwrvgnd_1
X_07356_ _03432_ _03495_ _03486_ _03490_ VGND VGND VPWR VPWR _03496_ sky130_fd_sc_hd__or4b_1
XFILLER_10_239 VGND VGND VPWR VPWR sky130_fd_sc_hd__decap_4
XFILLER_109_617 VGND VGND VPWR VPWR sky130_fd_sc_hd__fill_2
X_07287_ _03425_ _03426_ VGND VGND VPWR VPWR _03427_ sky130_fd_sc_hd__nand2_1
X_06307_ _02716_ _02719_ net566 VGND VGND VPWR VPWR _02720_ sky130_fd_sc_hd__mux2_1
XFILLER_136_458 VGND VGND VPWR VPWR sky130_fd_sc_hd__decap_6
XTAP_TAPCELL_ROW_131_2204 VGND VPWR sky130_fd_sc_hd__tapvpwrvgnd_1
X_09026_ net444 net2084 net340 VGND VGND VPWR VPWR _01195_ sky130_fd_sc_hd__mux2_1
X_06238_ net948 net949 net947 VGND VGND VPWR VPWR _02664_ sky130_fd_sc_hd__nand3b_4
XFILLER_136_469 VGND VGND VPWR VPWR sky130_fd_sc_hd__decap_6
XFILLER_124_609 VGND VGND VPWR VPWR sky130_fd_sc_hd__fill_1
Xhold262 picorv32_core.cpuregs\[11\]\[16\] VGND VGND VPWR VPWR net1371 sky130_fd_sc_hd__dlygate4sd3_1
Xhold251 picorv32_core.cpuregs\[30\]\[14\] VGND VGND VPWR VPWR net1360 sky130_fd_sc_hd__dlygate4sd3_1
Xhold240 picorv32_core.cpuregs\[22\]\[12\] VGND VGND VPWR VPWR net1349 sky130_fd_sc_hd__dlygate4sd3_1
X_06169_ _01688_ _01692_ net2314 VGND VGND VPWR VPWR _02601_ sky130_fd_sc_hd__a21oi_1
Xhold295 picorv32_core.cpuregs\[26\]\[1\] VGND VGND VPWR VPWR net1404 sky130_fd_sc_hd__dlygate4sd3_1
Xhold284 picorv32_core.cpuregs\[23\]\[9\] VGND VGND VPWR VPWR net1393 sky130_fd_sc_hd__dlygate4sd3_1
Xhold273 picorv32_core.cpuregs\[20\]\[8\] VGND VGND VPWR VPWR net1382 sky130_fd_sc_hd__dlygate4sd3_1
X_09928_ net218 net2145 net323 VGND VGND VPWR VPWR _01412_ sky130_fd_sc_hd__mux2_1
Xfanout720 net721 VGND VGND VPWR VPWR net720 sky130_fd_sc_hd__clkbuf_2
Xfanout742 net743 VGND VGND VPWR VPWR net742 sky130_fd_sc_hd__buf_4
Xfanout731 net732 VGND VGND VPWR VPWR net731 sky130_fd_sc_hd__buf_4
Xfanout753 net754 VGND VGND VPWR VPWR net753 sky130_fd_sc_hd__clkbuf_2
Xfanout764 net164 VGND VGND VPWR VPWR net764 sky130_fd_sc_hd__buf_2
Xfanout775 net776 VGND VGND VPWR VPWR net775 sky130_fd_sc_hd__clkbuf_2
XFILLER_58_431 VGND VGND VPWR VPWR sky130_fd_sc_hd__fill_2
XTAP_TAPCELL_ROW_129_2177 VGND VPWR sky130_fd_sc_hd__tapvpwrvgnd_1
X_09859_ net488 _05010_ _05011_ _05012_ _05027_ VGND VGND VPWR VPWR _05028_ sky130_fd_sc_hd__o41a_1
Xfanout786 net150 VGND VGND VPWR VPWR net786 sky130_fd_sc_hd__clkbuf_4
Xfanout797 net798 VGND VGND VPWR VPWR net797 sky130_fd_sc_hd__buf_2
XFILLER_58_475 VGND VGND VPWR VPWR sky130_fd_sc_hd__fill_1
XFILLER_58_486 VGND VGND VPWR VPWR sky130_fd_sc_hd__decap_3
XFILLER_73_478 VGND VGND VPWR VPWR sky130_fd_sc_hd__decap_4
XFILLER_54_670 VGND VGND VPWR VPWR sky130_fd_sc_hd__fill_1
X_10703_ clknet_leaf_6_clk _00554_ VGND VGND VPWR VPWR net108 sky130_fd_sc_hd__dfxtp_1
XFILLER_14_578 VGND VGND VPWR VPWR sky130_fd_sc_hd__fill_1
X_11683_ clknet_leaf_133_clk _01514_ VGND VGND VPWR VPWR picorv32_core.cpuregs\[27\]\[0\]
+ sky130_fd_sc_hd__dfxtp_1
X_10634_ clknet_leaf_134_clk _00488_ VGND VGND VPWR VPWR picorv32_core.cpuregs\[20\]\[2\]
+ sky130_fd_sc_hd__dfxtp_1
XFILLER_127_447 VGND VGND VPWR VPWR sky130_fd_sc_hd__fill_1
X_10565_ clknet_leaf_46_clk _00419_ VGND VGND VPWR VPWR picorv32_core.cpuregs\[25\]\[21\]
+ sky130_fd_sc_hd__dfxtp_1
X_10496_ clknet_leaf_51_clk _00382_ VGND VGND VPWR VPWR net187 sky130_fd_sc_hd__dfxtp_2
XTAP_TAPCELL_ROW_58_1139 VGND VPWR sky130_fd_sc_hd__tapvpwrvgnd_1
XFILLER_6_755 VGND VGND VPWR VPWR sky130_fd_sc_hd__fill_1
XTAP_TAPCELL_ROW_71_1328 VGND VPWR sky130_fd_sc_hd__tapvpwrvgnd_1
XFILLER_96_526 VGND VGND VPWR VPWR sky130_fd_sc_hd__decap_6
XTAP_TAPCELL_ROW_71_1339 VGND VPWR sky130_fd_sc_hd__tapvpwrvgnd_1
XFILLER_69_729 VGND VGND VPWR VPWR sky130_fd_sc_hd__decap_3
XFILLER_68_206 VGND VGND VPWR VPWR sky130_fd_sc_hd__decap_4
X_11117_ clknet_leaf_117_clk _00968_ VGND VGND VPWR VPWR picorv32_core.cpuregs\[8\]\[3\]
+ sky130_fd_sc_hd__dfxtp_1
XFILLER_39_7 VGND VGND VPWR VPWR sky130_fd_sc_hd__decap_8
XFILLER_122_185 VGND VGND VPWR VPWR sky130_fd_sc_hd__decap_3
X_11048_ clknet_leaf_65_clk _00899_ VGND VGND VPWR VPWR picorv32_core.cpuregs\[11\]\[30\]
+ sky130_fd_sc_hd__dfxtp_1
XFILLER_77_773 VGND VGND VPWR VPWR sky130_fd_sc_hd__decap_8
Xinput8 mem_axi_rdata[13] VGND VGND VPWR VPWR net8 sky130_fd_sc_hd__clkbuf_1
XFILLER_49_464 VGND VGND VPWR VPWR sky130_fd_sc_hd__decap_4
XFILLER_92_754 VGND VGND VPWR VPWR sky130_fd_sc_hd__fill_2
XFILLER_24_309 VGND VGND VPWR VPWR sky130_fd_sc_hd__fill_2
X_05540_ picorv32_core.reg_pc\[24\] picorv32_core.decoded_imm\[24\] VGND VGND VPWR
+ VPWR _02032_ sky130_fd_sc_hd__nand2_1
XFILLER_64_489 VPWR VGND VPWR VGND sky130_ef_sc_hd__decap_12
XTAP_TAPCELL_ROW_35_816 VGND VPWR sky130_fd_sc_hd__tapvpwrvgnd_1
XFILLER_32_320 VGND VGND VPWR VPWR sky130_fd_sc_hd__decap_4
X_05471_ picorv32_core.reg_pc\[19\] picorv32_core.decoded_imm\[19\] VGND VGND VPWR
+ VPWR _01968_ sky130_fd_sc_hd__and2_1
X_07210_ net2311 _03362_ net991 VGND VGND VPWR VPWR _03364_ sky130_fd_sc_hd__o21ai_1
X_08190_ net929 picorv32_core.mem_rdata_q\[13\] net930 VGND VGND VPWR VPWR _04200_
+ sky130_fd_sc_hd__and3b_1
XFILLER_60_695 VGND VGND VPWR VPWR sky130_fd_sc_hd__decap_4
X_07141_ _03319_ _03320_ VGND VGND VPWR VPWR _00285_ sky130_fd_sc_hd__nor2_1
X_07072_ _03275_ _03276_ VGND VGND VPWR VPWR _03277_ sky130_fd_sc_hd__xnor2_1
XFILLER_106_609 VGND VGND VPWR VPWR sky130_fd_sc_hd__fill_1
XFILLER_10_18 VGND VGND VPWR VPWR sky130_fd_sc_hd__decap_8
X_06023_ net779 _02485_ VGND VGND VPWR VPWR _02486_ sky130_fd_sc_hd__nand2_1
XFILLER_10_29 VPWR VGND VPWR VGND sky130_ef_sc_hd__decap_12
XFILLER_126_29 VPWR VGND VPWR VGND sky130_ef_sc_hd__decap_12
XFILLER_114_664 VGND VGND VPWR VPWR sky130_fd_sc_hd__fill_1
X_07974_ _04046_ _04047_ net639 VGND VGND VPWR VPWR _04054_ sky130_fd_sc_hd__mux2_1
XFILLER_68_751 VGND VGND VPWR VPWR sky130_fd_sc_hd__fill_2
X_09713_ net766 net549 VGND VGND VPWR VPWR _04888_ sky130_fd_sc_hd__or2_1
X_06925_ picorv32_core.decoded_imm_j\[19\] _02931_ VGND VGND VPWR VPWR _03142_ sky130_fd_sc_hd__nor2_1
X_09644_ net779 net280 VGND VGND VPWR VPWR _04822_ sky130_fd_sc_hd__and2_1
X_06856_ net668 picorv32_core.reg_next_pc\[13\] _02925_ net491 VGND VGND VPWR VPWR
+ _03079_ sky130_fd_sc_hd__a22o_1
XFILLER_55_434 VGND VGND VPWR VPWR sky130_fd_sc_hd__decap_6
XFILLER_35_15 VGND VGND VPWR VPWR sky130_fd_sc_hd__decap_4
X_05807_ net965 _02286_ VGND VGND VPWR VPWR _02287_ sky130_fd_sc_hd__xor2_1
XTAP_TAPCELL_ROW_124_2096 VGND VPWR sky130_fd_sc_hd__tapvpwrvgnd_1
X_09575_ net788 _04756_ net285 VGND VGND VPWR VPWR _01336_ sky130_fd_sc_hd__mux2_1
X_06787_ picorv32_core.decoded_imm_j\[8\] _02920_ VGND VGND VPWR VPWR _03015_ sky130_fd_sc_hd__nand2_1
XFILLER_27_169 VGND VGND VPWR VPWR sky130_fd_sc_hd__decap_3
X_05738_ net960 _02200_ VGND VGND VPWR VPWR _02222_ sky130_fd_sc_hd__nand2_1
X_08526_ net2080 net290 net403 VGND VGND VPWR VPWR _00653_ sky130_fd_sc_hd__mux2_1
X_05669_ net766 net193 VGND VGND VPWR VPWR _02153_ sky130_fd_sc_hd__or2_1
X_08457_ picorv32_core.decoded_imm\[9\] net526 _04309_ VGND VGND VPWR VPWR _00601_
+ sky130_fd_sc_hd__o21a_1
XFILLER_51_673 VGND VGND VPWR VPWR sky130_fd_sc_hd__decap_4
XFILLER_23_353 VGND VGND VPWR VPWR sky130_fd_sc_hd__fill_2
X_07408_ net902 picorv32_core.cpuregs\[11\]\[31\] net868 VGND VGND VPWR VPWR _03548_
+ sky130_fd_sc_hd__a21bo_1
XFILLER_50_194 VGND VGND VPWR VPWR sky130_fd_sc_hd__fill_2
X_08388_ picorv32_core.mem_do_wdata _03584_ VGND VGND VPWR VPWR _04269_ sky130_fd_sc_hd__and2b_1
X_07339_ _03449_ _03475_ _03447_ VGND VGND VPWR VPWR _03479_ sky130_fd_sc_hd__o21ai_1
X_10350_ clknet_leaf_102_clk _00269_ VGND VGND VPWR VPWR picorv32_core.count_cycle\[8\]
+ sky130_fd_sc_hd__dfxtp_1
X_09009_ net243 net2226 net346 VGND VGND VPWR VPWR _01179_ sky130_fd_sc_hd__mux2_1
XFILLER_3_714 VPWR VGND VPWR VGND sky130_ef_sc_hd__decap_12
X_10281_ clknet_leaf_122_clk _00200_ VGND VGND VPWR VPWR picorv32_core.reg_pc\[2\]
+ sky130_fd_sc_hd__dfxtp_2
XTAP_TAPCELL_ROW_111_1918 VGND VPWR sky130_fd_sc_hd__tapvpwrvgnd_1
XFILLER_76_33 VGND VGND VPWR VPWR sky130_fd_sc_hd__fill_1
XTAP_TAPCELL_ROW_53_1069 VGND VPWR sky130_fd_sc_hd__tapvpwrvgnd_1
XFILLER_120_678 VGND VGND VPWR VPWR sky130_fd_sc_hd__decap_4
Xfanout561 net562 VGND VGND VPWR VPWR net561 sky130_fd_sc_hd__clkbuf_4
Xfanout583 net586 VGND VGND VPWR VPWR net583 sky130_fd_sc_hd__clkbuf_4
Xfanout572 _02249_ VGND VGND VPWR VPWR net572 sky130_fd_sc_hd__clkbuf_4
XFILLER_58_294 VGND VGND VPWR VPWR sky130_fd_sc_hd__decap_3
XFILLER_18_114 VGND VGND VPWR VPWR sky130_fd_sc_hd__fill_1
Xfanout594 net595 VGND VGND VPWR VPWR net594 sky130_fd_sc_hd__clkbuf_4
XFILLER_74_765 VGND VGND VPWR VPWR sky130_fd_sc_hd__fill_1
XFILLER_132_83 VGND VGND VPWR VPWR sky130_fd_sc_hd__fill_1
XFILLER_61_415 VGND VGND VPWR VPWR sky130_fd_sc_hd__fill_1
XFILLER_15_821 VGND VGND VPWR VPWR sky130_fd_sc_hd__decap_3
XTAP_TAPCELL_ROW_68_1290 VGND VPWR sky130_fd_sc_hd__tapvpwrvgnd_1
XFILLER_14_320 VGND VGND VPWR VPWR sky130_fd_sc_hd__fill_1
XFILLER_30_813 VPWR VGND VPWR VGND sky130_ef_sc_hd__decap_12
X_11666_ clknet_leaf_14_clk _01497_ VGND VGND VPWR VPWR picorv32_core.cpuregs\[26\]\[15\]
+ sky130_fd_sc_hd__dfxtp_1
X_10617_ clknet_leaf_97_clk _00471_ VGND VGND VPWR VPWR picorv32_core.instr_rdinstr
+ sky130_fd_sc_hd__dfxtp_2
X_11597_ clknet_leaf_144_clk _01428_ VGND VGND VPWR VPWR picorv32_core.cpuregs\[23\]\[10\]
+ sky130_fd_sc_hd__dfxtp_1
XTAP_TAPCELL_ROW_40_885 VGND VPWR sky130_fd_sc_hd__tapvpwrvgnd_1
XFILLER_6_530 VGND VGND VPWR VPWR sky130_fd_sc_hd__fill_2
X_10548_ clknet_leaf_112_clk _00402_ VGND VGND VPWR VPWR picorv32_core.cpuregs\[25\]\[4\]
+ sky130_fd_sc_hd__dfxtp_1
XFILLER_130_409 VGND VGND VPWR VPWR sky130_fd_sc_hd__fill_2
X_10479_ clknet_leaf_131_clk _00365_ VGND VGND VPWR VPWR picorv32_core.mem_la_wdata\[5\]
+ sky130_fd_sc_hd__dfxtp_1
XFILLER_96_389 VPWR VGND VPWR VGND sky130_ef_sc_hd__decap_12
XFILLER_2_41 VPWR VGND VPWR VGND sky130_ef_sc_hd__decap_12
XFILLER_65_721 VGND VGND VPWR VPWR sky130_fd_sc_hd__fill_1
XFILLER_2_85 VPWR VGND VPWR VGND sky130_ef_sc_hd__decap_12
X_06710_ _02911_ _02944_ VGND VGND VPWR VPWR _02945_ sky130_fd_sc_hd__nand2_1
X_07690_ net959 net510 _03784_ _03785_ VGND VGND VPWR VPWR _00369_ sky130_fd_sc_hd__o22a_1
XFILLER_37_456 VGND VGND VPWR VPWR sky130_fd_sc_hd__decap_6
X_06641_ picorv32_core.count_instr\[62\] _02905_ net2286 VGND VGND VPWR VPWR _02908_
+ sky130_fd_sc_hd__a21oi_1
XTAP_TAPCELL_ROW_84_1519 VGND VPWR sky130_fd_sc_hd__tapvpwrvgnd_1
XFILLER_80_724 VGND VGND VPWR VPWR sky130_fd_sc_hd__decap_4
XTAP_TAPCELL_ROW_48_996 VGND VPWR sky130_fd_sc_hd__tapvpwrvgnd_1
XFILLER_80_757 VGND VGND VPWR VPWR sky130_fd_sc_hd__fill_2
XFILLER_24_128 VGND VGND VPWR VPWR sky130_fd_sc_hd__decap_3
X_09360_ picorv32_core.cpuregs\[8\]\[8\] picorv32_core.cpuregs\[9\]\[8\] picorv32_core.cpuregs\[10\]\[8\]
+ picorv32_core.cpuregs\[11\]\[8\] net881 net848 VGND VGND VPWR VPWR _04551_ sky130_fd_sc_hd__mux4_1
X_06572_ picorv32_core.count_instr\[38\] picorv32_core.count_instr\[37\] picorv32_core.count_instr\[36\]
+ _02859_ VGND VGND VPWR VPWR _02864_ sky130_fd_sc_hd__and4_1
X_05523_ net922 _02009_ _02010_ _02016_ VGND VGND VPWR VPWR _01561_ sky130_fd_sc_hd__a31o_1
X_08311_ net930 _01594_ _04204_ _04210_ VGND VGND VPWR VPWR _04232_ sky130_fd_sc_hd__a31o_1
X_09291_ net610 _04480_ _04481_ _04484_ net485 VGND VGND VPWR VPWR _04485_ sky130_fd_sc_hd__a311o_1
XFILLER_33_673 VGND VGND VPWR VPWR sky130_fd_sc_hd__decap_3
X_05454_ picorv32_core.count_cycle\[17\] net601 net578 _01952_ VGND VGND VPWR VPWR
+ _01953_ sky130_fd_sc_hd__o211a_1
X_08242_ _04219_ _04221_ net936 net523 VGND VGND VPWR VPWR _00473_ sky130_fd_sc_hd__a2bb2o_1
XFILLER_60_492 VGND VGND VPWR VPWR sky130_fd_sc_hd__fill_2
XANTENNA_13 _03574_ VGND VGND VPWR VPWR sky130_fd_sc_hd__diode_2
XFILLER_32_161 VGND VGND VPWR VPWR sky130_fd_sc_hd__fill_2
XANTENNA_24 _04330_ VGND VGND VPWR VPWR sky130_fd_sc_hd__diode_2
XANTENNA_57 net481 VGND VGND VPWR VPWR sky130_fd_sc_hd__diode_2
XANTENNA_35 _05041_ VGND VGND VPWR VPWR sky130_fd_sc_hd__diode_2
XANTENNA_46 net165 VGND VGND VPWR VPWR sky130_fd_sc_hd__diode_2
XFILLER_20_334 VGND VGND VPWR VPWR sky130_fd_sc_hd__fill_1
XTAP_TAPCELL_ROW_99_1740 VGND VPWR sky130_fd_sc_hd__tapvpwrvgnd_1
XANTENNA_79 _04754_ VGND VGND VPWR VPWR sky130_fd_sc_hd__diode_2
X_08173_ net929 net9 net520 VGND VGND VPWR VPWR _00755_ sky130_fd_sc_hd__mux2_1
X_05385_ _01881_ _01886_ _01887_ _01580_ VGND VGND VPWR VPWR _01889_ sky130_fd_sc_hd__a31oi_1
XANTENNA_68 net966 VGND VGND VPWR VPWR sky130_fd_sc_hd__diode_2
XFILLER_118_233 VGND VGND VPWR VPWR sky130_fd_sc_hd__decap_3
X_07124_ net976 _03309_ VGND VGND VPWR VPWR _03310_ sky130_fd_sc_hd__nor2_1
XFILLER_21_39 VPWR VGND VPWR VGND sky130_ef_sc_hd__decap_12
XFILLER_137_39 VPWR VGND VPWR VGND sky130_ef_sc_hd__decap_12
X_07055_ net666 picorv32_core.reg_next_pc\[29\] _02941_ net489 VGND VGND VPWR VPWR
+ _03262_ sky130_fd_sc_hd__a22o_1
XFILLER_106_428 VGND VGND VPWR VPWR sky130_fd_sc_hd__fill_1
X_06006_ net671 _02469_ VGND VGND VPWR VPWR _02470_ sky130_fd_sc_hd__and2_1
Xoutput120 net120 VGND VGND VPWR VPWR mem_axi_wdata[24] sky130_fd_sc_hd__buf_2
Xoutput131 net131 VGND VGND VPWR VPWR mem_axi_wdata[5] sky130_fd_sc_hd__buf_2
Xoutput142 net802 VGND VGND VPWR VPWR pcpi_rs1[10] sky130_fd_sc_hd__buf_2
Xoutput186 net186 VGND VGND VPWR VPWR pcpi_rs2[21] sky130_fd_sc_hd__buf_2
Xoutput164 net164 VGND VGND VPWR VPWR pcpi_rs1[30] sky130_fd_sc_hd__buf_2
Xoutput153 net782 VGND VGND VPWR VPWR pcpi_rs1[20] sky130_fd_sc_hd__buf_2
XFILLER_102_612 VPWR VGND VPWR VGND sky130_ef_sc_hd__decap_12
Xoutput175 net175 VGND VGND VPWR VPWR pcpi_rs2[11] sky130_fd_sc_hd__buf_2
XFILLER_0_706 VGND VGND VPWR VPWR sky130_fd_sc_hd__decap_4
Xoutput197 net197 VGND VGND VPWR VPWR pcpi_rs2[31] sky130_fd_sc_hd__buf_2
XFILLER_102_645 VGND VGND VPWR VPWR sky130_fd_sc_hd__decap_8
X_07957_ _04027_ _04036_ _04037_ net621 net689 VGND VGND VPWR VPWR _04038_ sky130_fd_sc_hd__a221o_1
XTAP_TAPCELL_ROW_126_2136 VGND VPWR sky130_fd_sc_hd__tapvpwrvgnd_1
XTAP_TAPCELL_ROW_126_2125 VGND VPWR sky130_fd_sc_hd__tapvpwrvgnd_1
X_06908_ net676 _03122_ _03124_ _03125_ _03126_ VGND VGND VPWR VPWR _03127_ sky130_fd_sc_hd__a32o_1
X_07888_ net684 _03972_ net625 VGND VGND VPWR VPWR _03973_ sky130_fd_sc_hd__a21o_1
X_09627_ picorv32_core.cpuregs\[20\]\[20\] picorv32_core.cpuregs\[21\]\[20\] picorv32_core.cpuregs\[22\]\[20\]
+ picorv32_core.cpuregs\[23\]\[20\] net897 net863 VGND VGND VPWR VPWR _04806_ sky130_fd_sc_hd__mux4_1
X_06839_ _02924_ _03052_ VGND VGND VPWR VPWR _03063_ sky130_fd_sc_hd__xnor2_1
XFILLER_56_787 VGND VGND VPWR VPWR sky130_fd_sc_hd__fill_2
XFILLER_28_489 VGND VGND VPWR VPWR sky130_fd_sc_hd__fill_2
X_09558_ net790 net546 _04675_ net471 VGND VGND VPWR VPWR _04740_ sky130_fd_sc_hd__o211a_1
X_08509_ net1348 net213 net409 VGND VGND VPWR VPWR _00639_ sky130_fd_sc_hd__mux2_1
XFILLER_12_813 VPWR VGND VPWR VGND sky130_ef_sc_hd__decap_12
XTAP_TAPCELL_ROW_26_679 VGND VPWR sky130_fd_sc_hd__tapvpwrvgnd_1
X_09489_ _03427_ _03429_ _03488_ VGND VGND VPWR VPWR _04674_ sky130_fd_sc_hd__nand3_1
X_11520_ clknet_leaf_110_clk _01351_ VGND VGND VPWR VPWR picorv32_core.cpuregs\[30\]\[1\]
+ sky130_fd_sc_hd__dfxtp_1
XFILLER_134_3 VPWR VGND VPWR VGND sky130_ef_sc_hd__decap_12
XFILLER_109_200 VGND VGND VPWR VPWR sky130_fd_sc_hd__decap_3
X_11451_ clknet_leaf_131_clk _01287_ VGND VGND VPWR VPWR picorv32_core.cpuregs\[24\]\[2\]
+ sky130_fd_sc_hd__dfxtp_1
XTAP_TAPCELL_ROW_137_2298 VGND VPWR sky130_fd_sc_hd__tapvpwrvgnd_1
XTAP_TAPCELL_ROW_137_2287 VGND VPWR sky130_fd_sc_hd__tapvpwrvgnd_1
X_10402_ clknet_leaf_77_clk _00321_ VGND VGND VPWR VPWR picorv32_core.count_cycle\[60\]
+ sky130_fd_sc_hd__dfxtp_1
X_11382_ clknet_leaf_85_clk _00027_ VGND VGND VPWR VPWR _00007_ sky130_fd_sc_hd__dfxtp_4
XFILLER_125_726 VGND VGND VPWR VPWR sky130_fd_sc_hd__fill_2
X_10333_ clknet_leaf_58_clk _00252_ VGND VGND VPWR VPWR picorv32_core.reg_next_pc\[23\]
+ sky130_fd_sc_hd__dfxtp_1
XTAP_TAPCELL_ROW_55_1109 VGND VPWR sky130_fd_sc_hd__tapvpwrvgnd_1
XFILLER_3_533 VGND VGND VPWR VPWR sky130_fd_sc_hd__fill_1
XFILLER_79_824 VGND VGND VPWR VPWR sky130_fd_sc_hd__fill_1
X_10264_ clknet_leaf_81_clk _00183_ VGND VGND VPWR VPWR picorv32_core.count_instr\[48\]
+ sky130_fd_sc_hd__dfxtp_1
X_10195_ clknet_leaf_2_clk _00114_ VGND VGND VPWR VPWR picorv32_core.cpuregs\[9\]\[11\]
+ sky130_fd_sc_hd__dfxtp_1
Xfanout380 net381 VGND VGND VPWR VPWR net380 sky130_fd_sc_hd__buf_4
XFILLER_66_529 VGND VGND VPWR VPWR sky130_fd_sc_hd__decap_3
XTAP_TAPCELL_ROW_6_393 VGND VPWR sky130_fd_sc_hd__tapvpwrvgnd_1
Xfanout391 _04334_ VGND VGND VPWR VPWR net391 sky130_fd_sc_hd__clkbuf_4
XFILLER_47_710 VGND VGND VPWR VPWR sky130_fd_sc_hd__fill_1
XFILLER_61_234 VGND VGND VPWR VPWR sky130_fd_sc_hd__decap_4
XTAP_TAPCELL_ROW_45_955 VGND VPWR sky130_fd_sc_hd__tapvpwrvgnd_1
XFILLER_15_673 VGND VGND VPWR VPWR sky130_fd_sc_hd__decap_4
XFILLER_14_150 VGND VGND VPWR VPWR sky130_fd_sc_hd__fill_1
X_11649_ clknet_leaf_63_clk _01480_ VGND VGND VPWR VPWR picorv32_core.cpuregs\[28\]\[30\]
+ sky130_fd_sc_hd__dfxtp_1
Xinput11 mem_axi_rdata[16] VGND VGND VPWR VPWR net11 sky130_fd_sc_hd__clkbuf_2
Xinput22 mem_axi_rdata[26] VGND VGND VPWR VPWR net22 sky130_fd_sc_hd__clkbuf_2
Xinput33 mem_axi_rdata[7] VGND VGND VPWR VPWR net33 sky130_fd_sc_hd__buf_1
X_05170_ _01663_ _01679_ _01694_ picorv32_core.is_slli_srli_srai VGND VGND VPWR VPWR
+ _01695_ sky130_fd_sc_hd__a31o_1
Xhold817 picorv32_core.cpuregs\[27\]\[20\] VGND VGND VPWR VPWR net1926 sky130_fd_sc_hd__dlygate4sd3_1
Xhold806 picorv32_core.cpuregs\[24\]\[20\] VGND VGND VPWR VPWR net1915 sky130_fd_sc_hd__dlygate4sd3_1
Xhold828 picorv32_core.cpuregs\[22\]\[7\] VGND VGND VPWR VPWR net1937 sky130_fd_sc_hd__dlygate4sd3_1
Xhold839 picorv32_core.cpuregs\[21\]\[9\] VGND VGND VPWR VPWR net1948 sky130_fd_sc_hd__dlygate4sd3_1
XFILLER_131_729 VPWR VGND VPWR VGND sky130_ef_sc_hd__decap_12
XFILLER_124_781 VPWR VGND VPWR VGND sky130_ef_sc_hd__decap_12
XTAP_TAPCELL_ROW_94_1670 VGND VPWR sky130_fd_sc_hd__tapvpwrvgnd_1
XFILLER_97_632 VGND VGND VPWR VPWR sky130_fd_sc_hd__fill_2
X_08860_ net443 net2135 net362 VGND VGND VPWR VPWR _01035_ sky130_fd_sc_hd__mux2_1
X_07811_ net696 _03895_ _03894_ net620 VGND VGND VPWR VPWR _03900_ sky130_fd_sc_hd__o211a_1
X_08791_ net465 net1429 net371 VGND VGND VPWR VPWR _00969_ sky130_fd_sc_hd__mux2_1
X_07742_ _03824_ _03825_ net630 VGND VGND VPWR VPWR _03835_ sky130_fd_sc_hd__mux2_1
XFILLER_52_201 VGND VGND VPWR VPWR sky130_fd_sc_hd__fill_1
X_07673_ picorv32_core.cpuregs\[16\]\[9\] picorv32_core.cpuregs\[17\]\[9\] picorv32_core.cpuregs\[18\]\[9\]
+ picorv32_core.cpuregs\[19\]\[9\] net731 net698 VGND VGND VPWR VPWR _03769_ sky130_fd_sc_hd__mux4_1
X_06624_ _02896_ _02897_ VGND VGND VPWR VPWR _00191_ sky130_fd_sc_hd__nor2_1
X_09412_ net652 _04600_ VGND VGND VPWR VPWR _04601_ sky130_fd_sc_hd__or2_1
XTAP_TAPCELL_ROW_121_2066 VGND VPWR sky130_fd_sc_hd__tapvpwrvgnd_1
XTAP_TAPCELL_ROW_121_2055 VGND VPWR sky130_fd_sc_hd__tapvpwrvgnd_1
X_09343_ picorv32_core.cpuregs\[0\]\[7\] picorv32_core.cpuregs\[1\]\[7\] picorv32_core.cpuregs\[2\]\[7\]
+ picorv32_core.cpuregs\[3\]\[7\] net877 net844 VGND VGND VPWR VPWR _04535_ sky130_fd_sc_hd__mux4_1
X_06555_ _02853_ net996 _02852_ VGND VGND VPWR VPWR _00166_ sky130_fd_sc_hd__and3b_1
XFILLER_80_587 VGND VGND VPWR VPWR sky130_fd_sc_hd__fill_1
XTAP_TAPCELL_ROW_23_638 VGND VPWR sky130_fd_sc_hd__tapvpwrvgnd_1
XFILLER_139_829 VGND VGND VPWR VPWR sky130_fd_sc_hd__fill_1
X_05506_ net945 picorv32_core.count_cycle\[53\] net603 _02000_ VGND VGND VPWR VPWR
+ _02001_ sky130_fd_sc_hd__a211o_1
X_06486_ _02809_ net985 _02808_ VGND VGND VPWR VPWR _00141_ sky130_fd_sc_hd__and3b_1
X_09274_ picorv32_core.cpuregs\[8\]\[4\] picorv32_core.cpuregs\[9\]\[4\] picorv32_core.cpuregs\[10\]\[4\]
+ picorv32_core.cpuregs\[11\]\[4\] net886 net853 VGND VGND VPWR VPWR _04469_ sky130_fd_sc_hd__mux4_1
XFILLER_32_27 VGND VGND VPWR VPWR sky130_fd_sc_hd__fill_1
XFILLER_119_531 VGND VGND VPWR VPWR sky130_fd_sc_hd__fill_2
X_05437_ net11 net584 net575 VGND VGND VPWR VPWR _01937_ sky130_fd_sc_hd__a21o_1
X_08225_ picorv32_core.mem_rdata_q\[15\] picorv32_core.mem_rdata_q\[16\] picorv32_core.mem_rdata_q\[30\]
+ picorv32_core.mem_rdata_q\[31\] VGND VGND VPWR VPWR _04212_ sky130_fd_sc_hd__or4bb_1
X_05368_ net7 _01818_ VGND VGND VPWR VPWR _01872_ sky130_fd_sc_hd__or2_1
X_08156_ net1149 net475 _04182_ net931 VGND VGND VPWR VPWR _00432_ sky130_fd_sc_hd__a22o_1
XFILLER_5_809 VPWR VGND VPWR VGND sky130_ef_sc_hd__decap_12
XFILLER_20_197 VGND VGND VPWR VPWR sky130_fd_sc_hd__decap_4
X_07107_ picorv32_core.count_cycle\[10\] picorv32_core.count_cycle\[11\] picorv32_core.count_cycle\[12\]
+ _03294_ VGND VGND VPWR VPWR _03299_ sky130_fd_sc_hd__and4_1
X_08087_ _04158_ _04160_ net459 _04157_ VGND VGND VPWR VPWR _04161_ sky130_fd_sc_hd__o211a_1
X_05299_ _01806_ _01807_ VGND VGND VPWR VPWR _01808_ sky130_fd_sc_hd__nand2_1
XFILLER_134_589 VGND VGND VPWR VPWR sky130_fd_sc_hd__decap_4
XFILLER_122_729 VPWR VGND VPWR VGND sky130_ef_sc_hd__decap_12
X_07038_ _03231_ _03235_ _03243_ _01592_ VGND VGND VPWR VPWR _03246_ sky130_fd_sc_hd__a31o_1
XFILLER_0_503 VGND VGND VPWR VPWR sky130_fd_sc_hd__fill_1
XFILLER_102_464 VGND VGND VPWR VPWR sky130_fd_sc_hd__decap_4
XFILLER_88_676 VGND VGND VPWR VPWR sky130_fd_sc_hd__decap_4
XTAP_TAPCELL_ROW_50_1028 VGND VPWR sky130_fd_sc_hd__tapvpwrvgnd_1
XFILLER_57_57 VGND VGND VPWR VPWR sky130_fd_sc_hd__decap_3
X_08989_ net497 net1390 net344 VGND VGND VPWR VPWR _01159_ sky130_fd_sc_hd__mux2_1
XFILLER_91_819 VGND VGND VPWR VPWR sky130_fd_sc_hd__fill_1
XTAP_TAPCELL_ROW_3_352 VGND VPWR sky130_fd_sc_hd__tapvpwrvgnd_1
XFILLER_29_754 VPWR VGND VPWR VGND sky130_ef_sc_hd__decap_12
X_10951_ clknet_leaf_66_clk _00802_ VGND VGND VPWR VPWR picorv32_core.cpuregs\[19\]\[29\]
+ sky130_fd_sc_hd__dfxtp_1
XFILLER_90_318 VGND VGND VPWR VPWR sky130_fd_sc_hd__fill_2
XFILLER_90_307 VGND VGND VPWR VPWR sky130_fd_sc_hd__fill_1
XFILLER_56_562 VGND VGND VPWR VPWR sky130_fd_sc_hd__fill_1
XFILLER_56_551 VGND VGND VPWR VPWR sky130_fd_sc_hd__decap_4
XTAP_TAPCELL_ROW_106_1839 VGND VPWR sky130_fd_sc_hd__tapvpwrvgnd_1
XFILLER_73_45 VGND VGND VPWR VPWR sky130_fd_sc_hd__fill_2
X_10882_ clknet_leaf_64_clk _00733_ VGND VGND VPWR VPWR picorv32_core.cpuregs\[16\]\[26\]
+ sky130_fd_sc_hd__dfxtp_1
XTAP_TAPCELL_ROW_42_914 VGND VPWR sky130_fd_sc_hd__tapvpwrvgnd_1
XTAP_TAPCELL_ROW_139_2327 VGND VPWR sky130_fd_sc_hd__tapvpwrvgnd_1
XTAP_TAPCELL_ROW_139_2316 VGND VPWR sky130_fd_sc_hd__tapvpwrvgnd_1
XPHY_EDGE_ROW_125_Right_125 VGND VGND VPWR VPWR sky130_fd_sc_hd__decap_3
XFILLER_12_643 VGND VGND VPWR VPWR sky130_fd_sc_hd__fill_1
X_11503_ clknet_leaf_56_clk _01339_ VGND VGND VPWR VPWR net153 sky130_fd_sc_hd__dfxtp_1
XFILLER_11_153 VGND VGND VPWR VPWR sky130_fd_sc_hd__fill_2
XFILLER_7_113 VPWR VGND VPWR VGND sky130_ef_sc_hd__decap_12
X_11434_ clknet_leaf_27_clk _01270_ VGND VGND VPWR VPWR picorv32_core.cpuregs\[1\]\[17\]
+ sky130_fd_sc_hd__dfxtp_1
X_11365_ clknet_leaf_26_clk _01206_ VGND VGND VPWR VPWR picorv32_core.cpuregs\[18\]\[17\]
+ sky130_fd_sc_hd__dfxtp_1
Xclkbuf_leaf_100_clk clknet_4_11_0_clk VGND VGND VPWR VPWR clknet_leaf_100_clk sky130_fd_sc_hd__clkbuf_8
XFILLER_125_567 VGND VGND VPWR VPWR sky130_fd_sc_hd__fill_1
XFILLER_113_729 VPWR VGND VPWR VGND sky130_ef_sc_hd__decap_12
X_11296_ clknet_leaf_29_clk _01144_ VGND VGND VPWR VPWR picorv32_core.cpuregs\[3\]\[19\]
+ sky130_fd_sc_hd__dfxtp_1
X_10316_ clknet_leaf_123_clk _00235_ VGND VGND VPWR VPWR picorv32_core.reg_next_pc\[6\]
+ sky130_fd_sc_hd__dfxtp_1
X_10247_ clknet_leaf_77_clk _00166_ VGND VGND VPWR VPWR picorv32_core.count_instr\[31\]
+ sky130_fd_sc_hd__dfxtp_1
XFILLER_79_621 VGND VGND VPWR VPWR sky130_fd_sc_hd__fill_1
XFILLER_3_374 VGND VGND VPWR VPWR sky130_fd_sc_hd__decap_6
X_10178_ clknet_leaf_45_clk _00097_ VGND VGND VPWR VPWR picorv32_core.cpuregs\[21\]\[26\]
+ sky130_fd_sc_hd__dfxtp_1
XFILLER_93_101 VGND VGND VPWR VPWR sky130_fd_sc_hd__fill_2
XFILLER_78_197 VGND VGND VPWR VPWR sky130_fd_sc_hd__fill_1
XFILLER_14_6 VPWR VGND VPWR VGND sky130_ef_sc_hd__decap_12
XFILLER_47_90 VGND VGND VPWR VPWR sky130_fd_sc_hd__fill_1
XFILLER_47_551 VGND VGND VPWR VPWR sky130_fd_sc_hd__decap_8
XFILLER_62_576 VGND VGND VPWR VPWR sky130_fd_sc_hd__decap_6
XFILLER_62_565 VGND VGND VPWR VPWR sky130_fd_sc_hd__fill_2
XFILLER_97_3 VPWR VGND VPWR VGND sky130_ef_sc_hd__decap_12
XFILLER_50_749 VGND VGND VPWR VPWR sky130_fd_sc_hd__decap_3
X_06340_ picorv32_core.reg_pc\[20\] _02742_ VGND VGND VPWR VPWR _02746_ sky130_fd_sc_hd__xor2_1
X_06271_ net1331 net443 net433 VGND VGND VPWR VPWR _00045_ sky130_fd_sc_hd__mux2_1
X_08010_ _04076_ _04077_ _04081_ _04082_ net636 net626 VGND VGND VPWR VPWR _04088_
+ sky130_fd_sc_hd__mux4_1
X_05222_ picorv32_core.reg_pc\[1\] picorv32_core.decoded_imm\[1\] _01736_ VGND VGND
+ VPWR VPWR _01737_ sky130_fd_sc_hd__a21oi_1
Xhold603 picorv32_core.cpuregs\[3\]\[13\] VGND VGND VPWR VPWR net1712 sky130_fd_sc_hd__dlygate4sd3_1
Xhold625 picorv32_core.cpuregs\[17\]\[28\] VGND VGND VPWR VPWR net1734 sky130_fd_sc_hd__dlygate4sd3_1
Xhold614 net58 VGND VGND VPWR VPWR net1723 sky130_fd_sc_hd__dlygate4sd3_1
Xhold636 picorv32_core.cpuregs\[24\]\[14\] VGND VGND VPWR VPWR net1745 sky130_fd_sc_hd__dlygate4sd3_1
X_05153_ picorv32_core.instr_rdcycle picorv32_core.is_slli_srli_srai net599 _01663_
+ VGND VGND VPWR VPWR _01680_ sky130_fd_sc_hd__or4b_1
X_09961_ net1757 net245 net318 VGND VGND VPWR VPWR _01439_ sky130_fd_sc_hd__mux2_1
XFILLER_104_718 VGND VGND VPWR VPWR sky130_fd_sc_hd__decap_8
Xhold658 picorv32_core.cpuregs\[14\]\[15\] VGND VGND VPWR VPWR net1767 sky130_fd_sc_hd__dlygate4sd3_1
Xhold647 picorv32_core.cpuregs\[19\]\[0\] VGND VGND VPWR VPWR net1756 sky130_fd_sc_hd__dlygate4sd3_1
Xhold669 picorv32_core.cpuregs\[9\]\[1\] VGND VGND VPWR VPWR net1778 sky130_fd_sc_hd__dlygate4sd3_1
X_05084_ net693 VGND VGND VPWR VPWR _01619_ sky130_fd_sc_hd__inv_2
X_08912_ net231 net1811 net361 VGND VGND VPWR VPWR _01086_ sky130_fd_sc_hd__mux2_1
XFILLER_134_29 VPWR VGND VPWR VGND sky130_ef_sc_hd__decap_12
XFILLER_131_559 VGND VGND VPWR VPWR sky130_fd_sc_hd__fill_1
X_09892_ net1502 net210 net327 VGND VGND VPWR VPWR _01380_ sky130_fd_sc_hd__mux2_1
X_08843_ net2007 net240 net367 VGND VGND VPWR VPWR _01019_ sky130_fd_sc_hd__mux2_1
X_08774_ net247 net2133 net376 VGND VGND VPWR VPWR _00921_ sky130_fd_sc_hd__mux2_1
X_05986_ _02450_ _02451_ VGND VGND VPWR VPWR _02452_ sky130_fd_sc_hd__nand2_1
XFILLER_27_27 VGND VGND VPWR VPWR sky130_fd_sc_hd__decap_4
XFILLER_72_307 VGND VGND VPWR VPWR sky130_fd_sc_hd__fill_1
X_07725_ net682 _03817_ net623 VGND VGND VPWR VPWR _03819_ sky130_fd_sc_hd__a21o_1
XTAP_TAPCELL_ROW_0_300 VGND VPWR sky130_fd_sc_hd__tapvpwrvgnd_1
XTAP_TAPCELL_ROW_0_311 VGND VPWR sky130_fd_sc_hd__tapvpwrvgnd_1
XTAP_TAPCELL_ROW_28_708 VGND VPWR sky130_fd_sc_hd__tapvpwrvgnd_1
XFILLER_26_757 VPWR VGND VPWR VGND sky130_ef_sc_hd__decap_12
X_07656_ net631 _03752_ VGND VGND VPWR VPWR _03753_ sky130_fd_sc_hd__or2_1
X_06607_ picorv32_core.count_instr\[48\] _02879_ _02885_ picorv32_core.count_instr\[51\]
+ VGND VGND VPWR VPWR _02886_ sky130_fd_sc_hd__a31o_1
XFILLER_80_395 VGND VGND VPWR VPWR sky130_fd_sc_hd__fill_1
X_07587_ _01682_ _03689_ _03690_ net595 VGND VGND VPWR VPWR _03691_ sky130_fd_sc_hd__a211o_1
XFILLER_43_15 VGND VGND VPWR VPWR sky130_fd_sc_hd__decap_8
X_06538_ picorv32_core.count_instr\[25\] picorv32_core.count_instr\[24\] _02839_ VGND
+ VGND VPWR VPWR _02843_ sky130_fd_sc_hd__and3_1
X_09326_ _04515_ _04516_ net652 VGND VGND VPWR VPWR _04519_ sky130_fd_sc_hd__mux2_1
XTAP_TAPCELL_ROW_101_1769 VGND VPWR sky130_fd_sc_hd__tapvpwrvgnd_1
X_09257_ net816 _04452_ net282 VGND VGND VPWR VPWR _01322_ sky130_fd_sc_hd__mux2_1
Xpicorv32_axi_1002 VGND VGND VPWR VPWR picorv32_axi_1002/HI eoi[3] sky130_fd_sc_hd__conb_1
XFILLER_138_158 VGND VGND VPWR VPWR sky130_fd_sc_hd__fill_1
XFILLER_126_309 VGND VGND VPWR VPWR sky130_fd_sc_hd__fill_2
X_08208_ _04187_ _04198_ _04204_ net524 net2246 VGND VGND VPWR VPWR _00457_ sky130_fd_sc_hd__a32o_1
X_06469_ picorv32_core.count_instr\[0\] net588 net972 VGND VGND VPWR VPWR _02799_
+ sky130_fd_sc_hd__a21oi_1
Xpicorv32_axi_1013 VGND VGND VPWR VPWR picorv32_axi_1013/HI eoi[14] sky130_fd_sc_hd__conb_1
XFILLER_135_821 VPWR VGND VPWR VGND sky130_ef_sc_hd__decap_12
Xpicorv32_axi_1046 VGND VGND VPWR VPWR picorv32_axi_1046/HI pcpi_insn[6] sky130_fd_sc_hd__conb_1
XTAP_TAPCELL_ROW_134_2246 VGND VPWR sky130_fd_sc_hd__tapvpwrvgnd_1
Xpicorv32_axi_1035 VGND VGND VPWR VPWR picorv32_axi_1035/HI mem_axi_awaddr[0] sky130_fd_sc_hd__conb_1
XFILLER_119_361 VGND VGND VPWR VPWR sky130_fd_sc_hd__decap_6
X_09188_ picorv32_core.cpuregs\[10\]\[1\] picorv32_core.cpuregs\[11\]\[1\] net886
+ VGND VGND VPWR VPWR _04386_ sky130_fd_sc_hd__mux2_1
Xpicorv32_axi_1024 VGND VGND VPWR VPWR picorv32_axi_1024/HI eoi[25] sky130_fd_sc_hd__conb_1
Xpicorv32_axi_1057 VGND VGND VPWR VPWR picorv32_axi_1057/HI pcpi_insn[17] sky130_fd_sc_hd__conb_1
Xpicorv32_axi_1068 VGND VGND VPWR VPWR picorv32_axi_1068/HI pcpi_insn[28] sky130_fd_sc_hd__conb_1
Xpicorv32_axi_1079 VGND VGND VPWR VPWR picorv32_axi_1079/HI trace_data[6] sky130_fd_sc_hd__conb_1
X_08139_ net2300 net29 net521 VGND VGND VPWR VPWR _00744_ sky130_fd_sc_hd__mux2_1
X_11150_ clknet_leaf_114_clk _01001_ VGND VGND VPWR VPWR picorv32_core.cpuregs\[7\]\[4\]
+ sky130_fd_sc_hd__dfxtp_1
XFILLER_134_386 VGND VGND VPWR VPWR sky130_fd_sc_hd__decap_4
XTAP_TAPCELL_ROW_116_1990 VGND VPWR sky130_fd_sc_hd__tapvpwrvgnd_1
X_10101_ net1148 VGND VGND VPWR VPWR _00951_ sky130_fd_sc_hd__clkbuf_1
XTAP_TAPCELL_ROW_8_422 VGND VPWR sky130_fd_sc_hd__tapvpwrvgnd_1
X_11081_ clknet_leaf_62_clk _00932_ VGND VGND VPWR VPWR picorv32_core.cpuregs\[10\]\[31\]
+ sky130_fd_sc_hd__dfxtp_1
X_10032_ net1809 net225 net311 VGND VGND VPWR VPWR _01508_ sky130_fd_sc_hd__mux2_1
XFILLER_88_462 VGND VGND VPWR VPWR sky130_fd_sc_hd__decap_4
XFILLER_0_399 VGND VGND VPWR VPWR sky130_fd_sc_hd__decap_3
X_10934_ clknet_leaf_5_clk _00785_ VGND VGND VPWR VPWR picorv32_core.cpuregs\[19\]\[12\]
+ sky130_fd_sc_hd__dfxtp_1
XFILLER_140_83 VGND VGND VPWR VPWR sky130_fd_sc_hd__fill_1
XTAP_TAPCELL_ROW_63_1219 VGND VPWR sky130_fd_sc_hd__tapvpwrvgnd_1
XFILLER_16_289 VGND VGND VPWR VPWR sky130_fd_sc_hd__fill_2
X_10865_ clknet_leaf_0_clk _00716_ VGND VGND VPWR VPWR picorv32_core.cpuregs\[16\]\[9\]
+ sky130_fd_sc_hd__dfxtp_1
XFILLER_32_727 VGND VGND VPWR VPWR sky130_fd_sc_hd__decap_3
X_10796_ clknet_leaf_138_clk _00647_ VGND VGND VPWR VPWR picorv32_core.cpuregs\[15\]\[5\]
+ sky130_fd_sc_hd__dfxtp_1
XFILLER_40_771 VGND VGND VPWR VPWR sky130_fd_sc_hd__decap_3
XFILLER_40_793 VGND VGND VPWR VPWR sky130_fd_sc_hd__decap_6
XPHY_EDGE_ROW_49_Left_191 VGND VGND VPWR VPWR sky130_fd_sc_hd__decap_3
XFILLER_137_191 VGND VGND VPWR VPWR sky130_fd_sc_hd__decap_6
XTAP_TAPCELL_ROW_78_1440 VGND VPWR sky130_fd_sc_hd__tapvpwrvgnd_1
X_11417_ clknet_leaf_132_clk _01253_ VGND VGND VPWR VPWR picorv32_core.cpuregs\[1\]\[0\]
+ sky130_fd_sc_hd__dfxtp_1
XFILLER_141_813 VGND VGND VPWR VPWR sky130_fd_sc_hd__fill_2
X_11348_ clknet_leaf_134_clk _01189_ VGND VGND VPWR VPWR picorv32_core.cpuregs\[18\]\[0\]
+ sky130_fd_sc_hd__dfxtp_1
XFILLER_99_749 VGND VGND VPWR VPWR sky130_fd_sc_hd__fill_2
XFILLER_98_259 VGND VGND VPWR VPWR sky130_fd_sc_hd__fill_1
X_11279_ clknet_leaf_135_clk _01127_ VGND VGND VPWR VPWR picorv32_core.cpuregs\[3\]\[2\]
+ sky130_fd_sc_hd__dfxtp_1
XFILLER_3_193 VPWR VGND VPWR VGND sky130_ef_sc_hd__decap_12
XFILLER_79_473 VGND VGND VPWR VPWR sky130_fd_sc_hd__decap_8
XFILLER_39_337 VGND VGND VPWR VPWR sky130_fd_sc_hd__decap_4
X_05840_ _02313_ _02316_ net506 VGND VGND VPWR VPWR _02318_ sky130_fd_sc_hd__o21a_1
X_07510_ net776 _03627_ net535 VGND VGND VPWR VPWR _03628_ sky130_fd_sc_hd__mux2_1
XTAP_TAPCELL_ROW_89_1591 VGND VPWR sky130_fd_sc_hd__tapvpwrvgnd_1
XFILLER_35_532 VGND VGND VPWR VPWR sky130_fd_sc_hd__decap_6
X_05771_ net823 picorv32_core.mem_la_wdata\[0\] net567 net506 VGND VGND VPWR VPWR
+ _02255_ sky130_fd_sc_hd__a31o_1
X_08490_ net1905 net296 net406 VGND VGND VPWR VPWR _00620_ sky130_fd_sc_hd__mux2_1
XFILLER_62_373 VPWR VGND VPWR VGND sky130_ef_sc_hd__decap_12
XFILLER_23_727 VGND VGND VPWR VPWR sky130_fd_sc_hd__fill_1
X_07441_ picorv32_core.mem_do_rinst picorv32_core.mem_do_prefetch VGND VGND VPWR VPWR
+ _03580_ sky130_fd_sc_hd__or2_2
X_07372_ net781 picorv32_core.decoded_imm\[20\] VGND VGND VPWR VPWR _03512_ sky130_fd_sc_hd__or2_1
X_09111_ net231 net2139 net335 VGND VGND VPWR VPWR _01278_ sky130_fd_sc_hd__mux2_1
X_06323_ picorv32_core.reg_out\[17\] picorv32_core.alu_out_q\[17\] net952 VGND VGND
+ VPWR VPWR _02732_ sky130_fd_sc_hd__mux2_1
XTAP_TAPCELL_ROW_33_777 VGND VPWR sky130_fd_sc_hd__tapvpwrvgnd_1
XTAP_TAPCELL_ROW_33_788 VGND VPWR sky130_fd_sc_hd__tapvpwrvgnd_1
XFILLER_117_821 VGND VGND VPWR VPWR sky130_fd_sc_hd__decap_8
X_09042_ net240 net1743 net342 VGND VGND VPWR VPWR _01211_ sky130_fd_sc_hd__mux2_1
XTAP_TAPCELL_ROW_13_490 VGND VPWR sky130_fd_sc_hd__tapvpwrvgnd_1
X_06254_ _02675_ _02676_ net563 VGND VGND VPWR VPWR _02677_ sky130_fd_sc_hd__mux2_2
Xhold411 picorv32_core.cpuregs\[19\]\[27\] VGND VGND VPWR VPWR net1520 sky130_fd_sc_hd__dlygate4sd3_1
Xhold400 picorv32_core.cpuregs\[12\]\[4\] VGND VGND VPWR VPWR net1509 sky130_fd_sc_hd__dlygate4sd3_1
X_06185_ picorv32_core.cpuregs\[24\]\[2\] picorv32_core.cpuregs\[25\]\[2\] picorv32_core.cpuregs\[26\]\[2\]
+ picorv32_core.cpuregs\[27\]\[2\] net734 net701 VGND VGND VPWR VPWR _02617_ sky130_fd_sc_hd__mux4_1
X_05205_ net925 _01596_ net822 VGND VGND VPWR VPWR _01721_ sky130_fd_sc_hd__o21bai_2
XFILLER_132_813 VPWR VGND VPWR VGND sky130_ef_sc_hd__decap_12
Xhold444 picorv32_core.cpuregs\[23\]\[16\] VGND VGND VPWR VPWR net1553 sky130_fd_sc_hd__dlygate4sd3_1
Xhold433 picorv32_core.cpuregs\[21\]\[15\] VGND VGND VPWR VPWR net1542 sky130_fd_sc_hd__dlygate4sd3_1
Xhold422 picorv32_core.cpuregs\[24\]\[5\] VGND VGND VPWR VPWR net1531 sky130_fd_sc_hd__dlygate4sd3_1
X_05136_ net975 _01597_ VGND VGND VPWR VPWR _00038_ sky130_fd_sc_hd__nor2_1
Xhold477 picorv32_core.cpuregs\[22\]\[28\] VGND VGND VPWR VPWR net1586 sky130_fd_sc_hd__dlygate4sd3_1
XFILLER_131_323 VGND VGND VPWR VPWR sky130_fd_sc_hd__fill_2
Xhold466 picorv32_core.cpuregs\[29\]\[16\] VGND VGND VPWR VPWR net1575 sky130_fd_sc_hd__dlygate4sd3_1
Xhold455 picorv32_core.cpuregs\[31\]\[14\] VGND VGND VPWR VPWR net1564 sky130_fd_sc_hd__dlygate4sd3_1
XFILLER_131_334 VGND VGND VPWR VPWR sky130_fd_sc_hd__fill_2
Xhold488 picorv32_core.cpuregs\[5\]\[24\] VGND VGND VPWR VPWR net1597 sky130_fd_sc_hd__dlygate4sd3_1
Xfanout902 net906 VGND VGND VPWR VPWR net902 sky130_fd_sc_hd__clkbuf_4
X_05067_ net764 VGND VGND VPWR VPWR _01602_ sky130_fd_sc_hd__inv_2
Xhold499 net139 VGND VGND VPWR VPWR net1608 sky130_fd_sc_hd__dlygate4sd3_1
X_09944_ net2205 net466 net317 VGND VGND VPWR VPWR _01422_ sky130_fd_sc_hd__mux2_1
Xfanout924 picorv32_core.cpu_state\[1\] VGND VGND VPWR VPWR net924 sky130_fd_sc_hd__buf_2
Xfanout913 net914 VGND VGND VPWR VPWR net913 sky130_fd_sc_hd__clkbuf_4
XFILLER_98_793 VGND VGND VPWR VPWR sky130_fd_sc_hd__fill_1
Xhold1100 picorv32_core.count_instr\[50\] VGND VGND VPWR VPWR net2209 sky130_fd_sc_hd__dlygate4sd3_1
Xfanout946 picorv32_core.instr_rdcycleh VGND VGND VPWR VPWR net946 sky130_fd_sc_hd__buf_2
Xfanout957 net176 VGND VGND VPWR VPWR net957 sky130_fd_sc_hd__clkbuf_4
Xfanout935 picorv32_core.instr_rdinstrh VGND VGND VPWR VPWR net935 sky130_fd_sc_hd__buf_2
X_09875_ net1477 net277 net324 VGND VGND VPWR VPWR _01363_ sky130_fd_sc_hd__mux2_1
Xfanout968 picorv32_core.mem_la_wdata\[1\] VGND VGND VPWR VPWR net968 sky130_fd_sc_hd__clkbuf_4
Xhold1122 picorv32_core.cpuregs\[29\]\[23\] VGND VGND VPWR VPWR net2231 sky130_fd_sc_hd__dlygate4sd3_1
Xfanout979 _01589_ VGND VGND VPWR VPWR net979 sky130_fd_sc_hd__buf_2
Xhold1133 picorv32_core.count_cycle\[24\] VGND VGND VPWR VPWR net2242 sky130_fd_sc_hd__dlygate4sd3_1
Xhold1111 net48 VGND VGND VPWR VPWR net2220 sky130_fd_sc_hd__dlygate4sd3_1
X_08826_ net1343 net448 net366 VGND VGND VPWR VPWR _01002_ sky130_fd_sc_hd__mux2_1
XFILLER_100_776 VGND VGND VPWR VPWR sky130_fd_sc_hd__fill_2
Xhold1166 picorv32_core.count_cycle\[45\] VGND VGND VPWR VPWR net2275 sky130_fd_sc_hd__dlygate4sd3_1
Xhold1144 picorv32_core.count_cycle\[9\] VGND VGND VPWR VPWR net2253 sky130_fd_sc_hd__dlygate4sd3_1
Xhold1155 picorv32_core.mem_rdata_q\[10\] VGND VGND VPWR VPWR net2264 sky130_fd_sc_hd__dlygate4sd3_1
Xhold1177 picorv32_core.count_instr\[63\] VGND VGND VPWR VPWR net2286 sky130_fd_sc_hd__dlygate4sd3_1
Xhold1199 net50 VGND VGND VPWR VPWR net2308 sky130_fd_sc_hd__dlygate4sd3_1
X_05969_ net507 _02435_ _02436_ _02421_ VGND VGND VPWR VPWR picorv32_core.alu_out\[16\]
+ sky130_fd_sc_hd__a31o_1
Xhold1188 picorv32_core.is_alu_reg_reg VGND VGND VPWR VPWR net2297 sky130_fd_sc_hd__dlygate4sd3_1
X_08757_ net492 net1600 net377 VGND VGND VPWR VPWR _00904_ sky130_fd_sc_hd__mux2_1
XFILLER_38_370 VGND VGND VPWR VPWR sky130_fd_sc_hd__fill_1
X_07708_ picorv32_core.decoded_imm\[10\] net590 net595 VGND VGND VPWR VPWR _03803_
+ sky130_fd_sc_hd__a21o_1
XFILLER_54_47 VGND VGND VPWR VPWR sky130_fd_sc_hd__decap_4
X_08688_ net1276 net503 net382 VGND VGND VPWR VPWR _00837_ sky130_fd_sc_hd__mux2_1
XFILLER_53_373 VPWR VGND VPWR VGND sky130_ef_sc_hd__decap_12
X_07639_ picorv32_core.cpuregs\[0\]\[7\] picorv32_core.cpuregs\[1\]\[7\] picorv32_core.cpuregs\[2\]\[7\]
+ picorv32_core.cpuregs\[3\]\[7\] net735 net702 VGND VGND VPWR VPWR _03737_ sky130_fd_sc_hd__mux4_1
XFILLER_26_587 VGND VGND VPWR VPWR sky130_fd_sc_hd__fill_1
X_10650_ clknet_leaf_51_clk _00504_ VGND VGND VPWR VPWR picorv32_core.cpuregs\[20\]\[18\]
+ sky130_fd_sc_hd__dfxtp_1
XFILLER_14_749 VGND VGND VPWR VPWR sky130_fd_sc_hd__decap_6
X_09309_ _03452_ _03471_ _03473_ VGND VGND VPWR VPWR _04502_ sky130_fd_sc_hd__or3_1
XFILLER_70_57 VGND VGND VPWR VPWR sky130_fd_sc_hd__fill_2
X_10581_ clknet_leaf_92_clk _00435_ VGND VGND VPWR VPWR picorv32_core.instr_bge sky130_fd_sc_hd__dfxtp_1
XFILLER_22_793 VGND VGND VPWR VPWR sky130_fd_sc_hd__decap_8
XFILLER_108_821 VGND VGND VPWR VPWR sky130_fd_sc_hd__fill_2
XFILLER_126_139 VGND VGND VPWR VPWR sky130_fd_sc_hd__fill_1
XFILLER_119_180 VGND VGND VPWR VPWR sky130_fd_sc_hd__decap_6
XFILLER_141_109 VGND VGND VPWR VPWR sky130_fd_sc_hd__decap_3
X_11202_ clknet_leaf_35_clk _01053_ VGND VGND VPWR VPWR picorv32_core.cpuregs\[6\]\[24\]
+ sky130_fd_sc_hd__dfxtp_1
X_11133_ clknet_leaf_32_clk _00984_ VGND VGND VPWR VPWR picorv32_core.cpuregs\[8\]\[19\]
+ sky130_fd_sc_hd__dfxtp_1
XFILLER_1_653 VPWR VGND VPWR VGND sky130_ef_sc_hd__decap_12
XFILLER_110_518 VGND VGND VPWR VPWR sky130_fd_sc_hd__fill_1
XFILLER_95_21 VGND VGND VPWR VPWR sky130_fd_sc_hd__fill_1
X_11064_ clknet_leaf_25_clk _00915_ VGND VGND VPWR VPWR picorv32_core.cpuregs\[10\]\[14\]
+ sky130_fd_sc_hd__dfxtp_1
XTAP_TAPCELL_ROW_73_1370 VGND VPWR sky130_fd_sc_hd__tapvpwrvgnd_1
XFILLER_0_141 VPWR VGND VPWR VGND sky130_ef_sc_hd__decap_12
XFILLER_103_592 VGND VGND VPWR VPWR sky130_fd_sc_hd__decap_6
XFILLER_76_443 VGND VGND VPWR VPWR sky130_fd_sc_hd__fill_2
XFILLER_1_697 VPWR VGND VPWR VGND sky130_ef_sc_hd__decap_12
X_10015_ net1901 net301 net308 VGND VGND VPWR VPWR _01491_ sky130_fd_sc_hd__mux2_1
XFILLER_76_498 VGND VGND VPWR VPWR sky130_fd_sc_hd__decap_3
XFILLER_60_811 VGND VGND VPWR VPWR sky130_fd_sc_hd__fill_1
X_10917_ clknet_leaf_94_clk _00768_ VGND VGND VPWR VPWR picorv32_core.mem_rdata_q\[27\]
+ sky130_fd_sc_hd__dfxtp_2
X_10848_ clknet_leaf_66_clk _00699_ VGND VGND VPWR VPWR picorv32_core.cpuregs\[17\]\[25\]
+ sky130_fd_sc_hd__dfxtp_1
X_10779_ clknet_leaf_21_clk _00630_ VGND VGND VPWR VPWR picorv32_core.cpuregs\[14\]\[20\]
+ sky130_fd_sc_hd__dfxtp_1
XFILLER_9_753 VPWR VGND VPWR VGND sky130_ef_sc_hd__decap_12
XTAP_TAPCELL_ROW_30_736 VGND VPWR sky130_fd_sc_hd__tapvpwrvgnd_1
XTAP_TAPCELL_ROW_30_747 VGND VPWR sky130_fd_sc_hd__tapvpwrvgnd_1
XFILLER_9_797 VPWR VGND VPWR VGND sky130_ef_sc_hd__decap_12
XFILLER_132_109 VGND VGND VPWR VPWR sky130_fd_sc_hd__fill_1
XFILLER_126_673 VGND VGND VPWR VPWR sky130_fd_sc_hd__decap_3
XFILLER_114_813 VGND VGND VPWR VPWR sky130_fd_sc_hd__decap_4
XFILLER_5_30 VPWR VGND VPWR VGND sky130_ef_sc_hd__decap_12
X_07990_ _04063_ _04064_ net640 VGND VGND VPWR VPWR _04069_ sky130_fd_sc_hd__mux2_1
Xfanout209 _02794_ VGND VGND VPWR VPWR net209 sky130_fd_sc_hd__clkbuf_2
XFILLER_140_153 VPWR VGND VPWR VGND sky130_ef_sc_hd__decap_12
X_06941_ _02931_ _02932_ _03135_ VGND VGND VPWR VPWR _03157_ sky130_fd_sc_hd__and3_1
XFILLER_140_197 VGND VGND VPWR VPWR sky130_fd_sc_hd__decap_8
X_09660_ net838 _04836_ net645 VGND VGND VPWR VPWR _04838_ sky130_fd_sc_hd__o21a_1
XFILLER_67_421 VGND VGND VPWR VPWR sky130_fd_sc_hd__fill_1
X_08611_ net223 net2006 net396 VGND VGND VPWR VPWR _00734_ sky130_fd_sc_hd__mux2_1
X_06872_ picorv32_core.decoded_imm_j\[15\] _02927_ VGND VGND VPWR VPWR _03093_ sky130_fd_sc_hd__or2_1
X_09591_ picorv32_core.cpuregs\[12\]\[18\] picorv32_core.cpuregs\[13\]\[18\] picorv32_core.cpuregs\[14\]\[18\]
+ picorv32_core.cpuregs\[15\]\[18\] net893 net859 VGND VGND VPWR VPWR _04772_ sky130_fd_sc_hd__mux4_1
XFILLER_82_435 VGND VGND VPWR VPWR sky130_fd_sc_hd__fill_1
X_05823_ net811 net964 net573 VGND VGND VPWR VPWR _02302_ sky130_fd_sc_hd__a21oi_1
X_08542_ net1534 net223 net405 VGND VGND VPWR VPWR _00669_ sky130_fd_sc_hd__mux2_1
X_05754_ net775 _01612_ _02227_ _02237_ VGND VGND VPWR VPWR _02238_ sky130_fd_sc_hd__o211a_1
XFILLER_82_457 VGND VGND VPWR VPWR sky130_fd_sc_hd__decap_6
XTAP_TAPCELL_ROW_38_858 VGND VPWR sky130_fd_sc_hd__tapvpwrvgnd_1
XTAP_TAPCELL_ROW_18_560 VGND VPWR sky130_fd_sc_hd__tapvpwrvgnd_1
XTAP_TAPCELL_ROW_18_571 VGND VPWR sky130_fd_sc_hd__tapvpwrvgnd_1
XFILLER_23_502 VGND VGND VPWR VPWR sky130_fd_sc_hd__fill_2
X_08473_ net673 picorv32_core.decoded_imm_j\[2\] _04282_ picorv32_core.mem_rdata_q\[9\]
+ net525 VGND VGND VPWR VPWR _04319_ sky130_fd_sc_hd__a221o_1
X_07424_ net839 _03559_ _03563_ VGND VGND VPWR VPWR _03564_ sky130_fd_sc_hd__a21o_1
X_05685_ _02155_ _02158_ _02162_ _02168_ VGND VGND VPWR VPWR _02169_ sky130_fd_sc_hd__or4b_1
XFILLER_62_170 VGND VGND VPWR VPWR sky130_fd_sc_hd__fill_2
XFILLER_23_535 VGND VGND VPWR VPWR sky130_fd_sc_hd__fill_2
XFILLER_50_365 VPWR VGND VPWR VGND sky130_ef_sc_hd__decap_12
XFILLER_23_568 VGND VGND VPWR VPWR sky130_fd_sc_hd__decap_8
XTAP_TAPCELL_ROW_118_2016 VGND VPWR sky130_fd_sc_hd__tapvpwrvgnd_1
X_07355_ _03428_ _03429_ VGND VGND VPWR VPWR _03495_ sky130_fd_sc_hd__nand2_1
XFILLER_50_398 VGND VGND VPWR VPWR sky130_fd_sc_hd__fill_1
X_07286_ net793 picorv32_core.decoded_imm\[14\] VGND VGND VPWR VPWR _03426_ sky130_fd_sc_hd__or2_1
X_06306_ _02717_ _02718_ VGND VGND VPWR VPWR _02719_ sky130_fd_sc_hd__nor2_1
XTAP_TAPCELL_ROW_131_2205 VGND VPWR sky130_fd_sc_hd__tapvpwrvgnd_1
X_09025_ net449 net2025 net340 VGND VGND VPWR VPWR _01194_ sky130_fd_sc_hd__mux2_1
X_06237_ net2160 net519 net982 VGND VGND VPWR VPWR _00037_ sky130_fd_sc_hd__mux2_1
Xhold252 picorv32_core.cpuregs\[24\]\[31\] VGND VGND VPWR VPWR net1361 sky130_fd_sc_hd__dlygate4sd3_1
XFILLER_117_673 VGND VGND VPWR VPWR sky130_fd_sc_hd__fill_2
Xhold230 picorv32_core.cpuregs\[23\]\[24\] VGND VGND VPWR VPWR net1339 sky130_fd_sc_hd__dlygate4sd3_1
Xhold241 picorv32_core.cpuregs\[20\]\[5\] VGND VGND VPWR VPWR net1350 sky130_fd_sc_hd__dlygate4sd3_1
X_06168_ picorv32_core.decoded_imm_j\[4\] _00765_ net438 VGND VGND VPWR VPWR _00024_
+ sky130_fd_sc_hd__mux2_1
XFILLER_120_805 VGND VGND VPWR VPWR sky130_fd_sc_hd__decap_6
X_06099_ _02543_ _02548_ _02554_ _02254_ VGND VGND VPWR VPWR _02556_ sky130_fd_sc_hd__a31o_1
Xhold296 picorv32_core.cpuregs\[15\]\[17\] VGND VGND VPWR VPWR net1405 sky130_fd_sc_hd__dlygate4sd3_1
X_05119_ picorv32_core.instr_sltu picorv32_core.instr_slt picorv32_core.instr_sltiu
+ picorv32_core.instr_slti VGND VGND VPWR VPWR _01650_ sky130_fd_sc_hd__or4_1
Xhold285 picorv32_core.cpuregs\[14\]\[14\] VGND VGND VPWR VPWR net1394 sky130_fd_sc_hd__dlygate4sd3_1
Xhold274 picorv32_core.cpuregs\[31\]\[2\] VGND VGND VPWR VPWR net1383 sky130_fd_sc_hd__dlygate4sd3_1
Xhold263 picorv32_core.cpuregs\[7\]\[6\] VGND VGND VPWR VPWR net1372 sky130_fd_sc_hd__dlygate4sd3_1
X_09927_ net222 net2156 net323 VGND VGND VPWR VPWR _01411_ sky130_fd_sc_hd__mux2_1
Xfanout721 net725 VGND VGND VPWR VPWR net721 sky130_fd_sc_hd__clkbuf_4
Xfanout710 net713 VGND VGND VPWR VPWR net710 sky130_fd_sc_hd__buf_2
Xfanout732 net741 VGND VGND VPWR VPWR net732 sky130_fd_sc_hd__buf_4
Xfanout754 net758 VGND VGND VPWR VPWR net754 sky130_fd_sc_hd__buf_4
Xfanout765 net162 VGND VGND VPWR VPWR net765 sky130_fd_sc_hd__clkbuf_4
Xfanout776 net156 VGND VGND VPWR VPWR net776 sky130_fd_sc_hd__clkbuf_2
Xfanout743 net746 VGND VGND VPWR VPWR net743 sky130_fd_sc_hd__clkbuf_4
XTAP_TAPCELL_ROW_129_2178 VGND VPWR sky130_fd_sc_hd__tapvpwrvgnd_1
X_09858_ picorv32_core.reg_pc\[30\] net538 _05026_ net483 VGND VGND VPWR VPWR _05027_
+ sky130_fd_sc_hd__a211o_1
Xfanout787 net788 VGND VGND VPWR VPWR net787 sky130_fd_sc_hd__buf_2
Xfanout798 net144 VGND VGND VPWR VPWR net798 sky130_fd_sc_hd__clkbuf_4
X_09789_ net838 _04955_ net828 VGND VGND VPWR VPWR _04961_ sky130_fd_sc_hd__o21a_1
X_08809_ net242 net2137 net372 VGND VGND VPWR VPWR _00987_ sky130_fd_sc_hd__mux2_1
XFILLER_26_373 VGND VGND VPWR VPWR sky130_fd_sc_hd__decap_3
Xclkbuf_leaf_80_clk clknet_4_14_0_clk VGND VGND VPWR VPWR clknet_leaf_80_clk sky130_fd_sc_hd__clkbuf_8
X_10702_ clknet_leaf_6_clk _00553_ VGND VGND VPWR VPWR net107 sky130_fd_sc_hd__dfxtp_1
X_11682_ clknet_leaf_60_clk _01513_ VGND VGND VPWR VPWR picorv32_core.cpuregs\[26\]\[31\]
+ sky130_fd_sc_hd__dfxtp_1
XFILLER_81_78 VGND VGND VPWR VPWR sky130_fd_sc_hd__fill_1
X_10633_ clknet_leaf_111_clk _00487_ VGND VGND VPWR VPWR picorv32_core.cpuregs\[20\]\[1\]
+ sky130_fd_sc_hd__dfxtp_1
X_10564_ clknet_leaf_50_clk _00418_ VGND VGND VPWR VPWR picorv32_core.cpuregs\[25\]\[20\]
+ sky130_fd_sc_hd__dfxtp_1
XFILLER_6_701 VPWR VGND VPWR VGND sky130_ef_sc_hd__decap_12
XFILLER_14_83 VGND VGND VPWR VPWR sky130_fd_sc_hd__fill_1
XFILLER_108_640 VGND VGND VPWR VPWR sky130_fd_sc_hd__decap_4
X_10495_ clknet_leaf_48_clk _00381_ VGND VGND VPWR VPWR net186 sky130_fd_sc_hd__dfxtp_2
XFILLER_5_266 VGND VGND VPWR VPWR sky130_fd_sc_hd__fill_1
XTAP_TAPCELL_ROW_71_1329 VGND VPWR sky130_fd_sc_hd__tapvpwrvgnd_1
X_11116_ clknet_leaf_135_clk _00967_ VGND VGND VPWR VPWR picorv32_core.cpuregs\[8\]\[2\]
+ sky130_fd_sc_hd__dfxtp_1
XFILLER_122_197 VGND VGND VPWR VPWR sky130_fd_sc_hd__decap_6
XFILLER_49_410 VGND VGND VPWR VPWR sky130_fd_sc_hd__fill_1
X_11047_ clknet_leaf_68_clk _00898_ VGND VGND VPWR VPWR picorv32_core.cpuregs\[11\]\[29\]
+ sky130_fd_sc_hd__dfxtp_1
XFILLER_77_785 VGND VGND VPWR VPWR sky130_fd_sc_hd__decap_3
XFILLER_77_752 VGND VGND VPWR VPWR sky130_fd_sc_hd__fill_1
XFILLER_49_454 VGND VGND VPWR VPWR sky130_fd_sc_hd__fill_1
XFILLER_92_722 VGND VGND VPWR VPWR sky130_fd_sc_hd__fill_1
Xinput9 mem_axi_rdata[14] VGND VGND VPWR VPWR net9 sky130_fd_sc_hd__buf_1
XFILLER_64_468 VGND VGND VPWR VPWR sky130_fd_sc_hd__decap_8
XFILLER_36_137 VGND VGND VPWR VPWR sky130_fd_sc_hd__decap_3
XTAP_TAPCELL_ROW_86_1550 VGND VPWR sky130_fd_sc_hd__tapvpwrvgnd_1
XTAP_TAPCELL_ROW_35_806 VGND VPWR sky130_fd_sc_hd__tapvpwrvgnd_1
XTAP_TAPCELL_ROW_35_817 VGND VPWR sky130_fd_sc_hd__tapvpwrvgnd_1
XFILLER_45_671 VGND VGND VPWR VPWR sky130_fd_sc_hd__fill_1
Xclkbuf_leaf_71_clk clknet_4_15_0_clk VGND VGND VPWR VPWR clknet_leaf_71_clk sky130_fd_sc_hd__clkbuf_8
X_05470_ picorv32_core.reg_pc\[19\] picorv32_core.decoded_imm\[19\] VGND VGND VPWR
+ VPWR _01967_ sky130_fd_sc_hd__or2_1
XFILLER_32_354 VGND VGND VPWR VPWR sky130_fd_sc_hd__fill_2
X_07140_ net2242 _03318_ net994 VGND VGND VPWR VPWR _03320_ sky130_fd_sc_hd__o21ai_1
X_07071_ net933 _02943_ VGND VGND VPWR VPWR _03276_ sky130_fd_sc_hd__xnor2_1
X_06022_ net186 _02484_ VGND VGND VPWR VPWR _02485_ sky130_fd_sc_hd__xnor2_1
XFILLER_102_805 VGND VGND VPWR VPWR sky130_fd_sc_hd__decap_3
XFILLER_87_505 VPWR VGND VPWR VGND sky130_ef_sc_hd__decap_12
X_07973_ _04044_ _04045_ net639 VGND VGND VPWR VPWR _04053_ sky130_fd_sc_hd__mux2_1
X_09712_ _03525_ _03527_ _04886_ VGND VGND VPWR VPWR _04887_ sky130_fd_sc_hd__a21oi_1
X_06924_ picorv32_core.decoded_imm_j\[19\] _02931_ VGND VGND VPWR VPWR _03141_ sky130_fd_sc_hd__and2_1
X_09643_ net782 _04821_ net284 VGND VGND VPWR VPWR _01339_ sky130_fd_sc_hd__mux2_1
X_06855_ _02925_ _03062_ _03077_ VGND VGND VPWR VPWR _03078_ sky130_fd_sc_hd__a21oi_1
XFILLER_67_273 VGND VGND VPWR VPWR sky130_fd_sc_hd__fill_1
X_09574_ net488 _04737_ _04739_ _04740_ _04755_ VGND VGND VPWR VPWR _04756_ sky130_fd_sc_hd__o41a_1
XFILLER_55_468 VGND VGND VPWR VPWR sky130_fd_sc_hd__fill_2
XFILLER_55_446 VGND VGND VPWR VPWR sky130_fd_sc_hd__fill_2
X_05806_ net669 _02285_ VGND VGND VPWR VPWR _02286_ sky130_fd_sc_hd__nand2_1
XTAP_TAPCELL_ROW_124_2097 VGND VPWR sky130_fd_sc_hd__tapvpwrvgnd_1
XFILLER_55_479 VPWR VGND VPWR VGND sky130_ef_sc_hd__decap_12
X_06786_ _03012_ _03013_ VGND VGND VPWR VPWR _03014_ sky130_fd_sc_hd__nor2_1
XFILLER_24_811 VGND VGND VPWR VPWR sky130_fd_sc_hd__fill_1
X_08525_ net1377 net296 net402 VGND VGND VPWR VPWR _00652_ sky130_fd_sc_hd__mux2_1
Xclkbuf_leaf_62_clk clknet_4_13_0_clk VGND VGND VPWR VPWR clknet_leaf_62_clk sky130_fd_sc_hd__clkbuf_8
XFILLER_82_298 VGND VGND VPWR VPWR sky130_fd_sc_hd__fill_1
X_05737_ net791 _01608_ _02187_ _02219_ _02220_ VGND VGND VPWR VPWR _02221_ sky130_fd_sc_hd__o221a_1
X_05668_ net765 net954 VGND VGND VPWR VPWR _02152_ sky130_fd_sc_hd__xnor2_1
X_08456_ net675 picorv32_core.decoded_imm_j\[9\] _04283_ picorv32_core.mem_rdata_q\[29\]
+ net524 VGND VGND VPWR VPWR _04309_ sky130_fd_sc_hd__a221o_1
X_07407_ net902 picorv32_core.cpuregs\[10\]\[31\] VGND VGND VPWR VPWR _03547_ sky130_fd_sc_hd__and2b_1
X_08387_ net2320 _04235_ _04268_ VGND VGND VPWR VPWR _00572_ sky130_fd_sc_hd__o21a_1
XFILLER_50_184 VGND VGND VPWR VPWR sky130_fd_sc_hd__fill_1
XFILLER_50_162 VGND VGND VPWR VPWR sky130_fd_sc_hd__fill_2
XFILLER_23_376 VGND VGND VPWR VPWR sky130_fd_sc_hd__decap_3
X_05599_ net945 picorv32_core.count_cycle\[60\] net604 _02086_ VGND VGND VPWR VPWR
+ _02087_ sky130_fd_sc_hd__a211o_1
X_07338_ _03447_ _03448_ _03452_ _03476_ VGND VGND VPWR VPWR _03478_ sky130_fd_sc_hd__a31o_1
X_07269_ net772 picorv32_core.decoded_imm\[25\] VGND VGND VPWR VPWR _03409_ sky130_fd_sc_hd__nand2_1
XFILLER_124_429 VGND VGND VPWR VPWR sky130_fd_sc_hd__decap_8
X_09008_ net246 net2068 net346 VGND VGND VPWR VPWR _01178_ sky130_fd_sc_hd__mux2_1
XFILLER_3_726 VGND VGND VPWR VPWR sky130_fd_sc_hd__fill_2
X_10280_ clknet_leaf_122_clk _00199_ VGND VGND VPWR VPWR picorv32_core.reg_pc\[1\]
+ sky130_fd_sc_hd__dfxtp_2
XTAP_TAPCELL_ROW_111_1919 VGND VPWR sky130_fd_sc_hd__tapvpwrvgnd_1
XTAP_TAPCELL_ROW_111_1908 VGND VPWR sky130_fd_sc_hd__tapvpwrvgnd_1
Xfanout551 net552 VGND VGND VPWR VPWR net551 sky130_fd_sc_hd__buf_2
Xfanout540 net541 VGND VGND VPWR VPWR net540 sky130_fd_sc_hd__buf_2
Xfanout584 net586 VGND VGND VPWR VPWR net584 sky130_fd_sc_hd__dlymetal6s2s_1
Xfanout562 _02910_ VGND VGND VPWR VPWR net562 sky130_fd_sc_hd__clkbuf_2
Xfanout573 _02248_ VGND VGND VPWR VPWR net573 sky130_fd_sc_hd__clkbuf_4
Xfanout595 net598 VGND VGND VPWR VPWR net595 sky130_fd_sc_hd__buf_2
XFILLER_46_402 VGND VGND VPWR VPWR sky130_fd_sc_hd__fill_1
Xclkbuf_leaf_53_clk clknet_4_6_0_clk VGND VGND VPWR VPWR clknet_leaf_53_clk sky130_fd_sc_hd__clkbuf_8
XFILLER_92_55 VGND VGND VPWR VPWR sky130_fd_sc_hd__fill_1
XTAP_TAPCELL_ROW_68_1291 VGND VPWR sky130_fd_sc_hd__tapvpwrvgnd_1
XFILLER_27_682 VGND VGND VPWR VPWR sky130_fd_sc_hd__fill_1
XTAP_TAPCELL_ROW_81_1480 VGND VPWR sky130_fd_sc_hd__tapvpwrvgnd_1
X_11665_ clknet_leaf_23_clk _01496_ VGND VGND VPWR VPWR picorv32_core.cpuregs\[26\]\[14\]
+ sky130_fd_sc_hd__dfxtp_1
XFILLER_25_82 VGND VGND VPWR VPWR sky130_fd_sc_hd__fill_1
XFILLER_30_825 VGND VGND VPWR VPWR sky130_fd_sc_hd__decap_4
Xclkbuf_4_6_0_clk clknet_0_clk VGND VGND VPWR VPWR clknet_4_6_0_clk sky130_fd_sc_hd__clkbuf_8
X_10616_ clknet_leaf_96_clk _00470_ VGND VGND VPWR VPWR picorv32_core.instr_rdcycleh
+ sky130_fd_sc_hd__dfxtp_1
XFILLER_128_757 VPWR VGND VPWR VGND sky130_ef_sc_hd__decap_12
XFILLER_128_724 VPWR VGND VPWR VGND sky130_ef_sc_hd__decap_12
X_11596_ clknet_leaf_0_clk _01427_ VGND VGND VPWR VPWR picorv32_core.cpuregs\[23\]\[9\]
+ sky130_fd_sc_hd__dfxtp_1
XTAP_TAPCELL_ROW_40_886 VGND VPWR sky130_fd_sc_hd__tapvpwrvgnd_1
XFILLER_127_245 VGND VGND VPWR VPWR sky130_fd_sc_hd__decap_4
X_10547_ clknet_leaf_120_clk _00401_ VGND VGND VPWR VPWR picorv32_core.cpuregs\[25\]\[3\]
+ sky130_fd_sc_hd__dfxtp_1
X_10478_ clknet_leaf_119_clk _00364_ VGND VGND VPWR VPWR picorv32_core.mem_la_wdata\[4\]
+ sky130_fd_sc_hd__dfxtp_2
XFILLER_111_613 VGND VGND VPWR VPWR sky130_fd_sc_hd__decap_3
XFILLER_69_538 VGND VGND VPWR VPWR sky130_fd_sc_hd__fill_2
XFILLER_2_781 VPWR VGND VPWR VGND sky130_ef_sc_hd__decap_12
XFILLER_111_679 VGND VGND VPWR VPWR sky130_fd_sc_hd__fill_1
XFILLER_110_156 VGND VGND VPWR VPWR sky130_fd_sc_hd__fill_1
XPHY_EDGE_ROW_10_Right_10 VGND VGND VPWR VPWR sky130_fd_sc_hd__decap_3
XFILLER_2_53 VPWR VGND VPWR VGND sky130_ef_sc_hd__decap_12
XFILLER_110_178 VGND VGND VPWR VPWR sky130_fd_sc_hd__fill_2
XPHY_EDGE_ROW_139_Right_139 VGND VGND VPWR VPWR sky130_fd_sc_hd__decap_3
X_06640_ net2350 _02905_ _02907_ VGND VGND VPWR VPWR _00197_ sky130_fd_sc_hd__o21a_1
XFILLER_2_97 VPWR VGND VPWR VGND sky130_ef_sc_hd__decap_12
XTAP_TAPCELL_ROW_48_997 VGND VPWR sky130_fd_sc_hd__tapvpwrvgnd_1
Xclkbuf_leaf_44_clk clknet_4_7_0_clk VGND VGND VPWR VPWR clknet_leaf_44_clk sky130_fd_sc_hd__clkbuf_8
XFILLER_80_769 VGND VGND VPWR VPWR sky130_fd_sc_hd__decap_4
X_06571_ _02863_ net985 _02862_ VGND VGND VPWR VPWR _00172_ sky130_fd_sc_hd__and3b_1
X_05522_ net911 net303 _02011_ _02015_ VGND VGND VPWR VPWR _02016_ sky130_fd_sc_hd__a31o_1
X_08310_ net2367 _02600_ _04229_ _04231_ VGND VGND VPWR VPWR _00532_ sky130_fd_sc_hd__a22o_1
X_09290_ net474 _04421_ _04482_ _04483_ net469 VGND VGND VPWR VPWR _04484_ sky130_fd_sc_hd__a32o_1
XANTENNA_14 _03623_ VGND VGND VPWR VPWR sky130_fd_sc_hd__diode_2
X_05453_ net946 picorv32_core.count_cycle\[49\] net604 _01951_ VGND VGND VPWR VPWR
+ _01952_ sky130_fd_sc_hd__a211o_1
X_08241_ net1194 net477 _04182_ _04224_ VGND VGND VPWR VPWR _00472_ sky130_fd_sc_hd__a22o_1
XFILLER_21_836 VGND VGND VPWR VPWR sky130_fd_sc_hd__fill_1
XANTENNA_47 net196 VGND VGND VPWR VPWR sky130_fd_sc_hd__diode_2
XANTENNA_36 _05042_ VGND VGND VPWR VPWR sky130_fd_sc_hd__diode_2
XANTENNA_25 _04343_ VGND VGND VPWR VPWR sky130_fd_sc_hd__diode_2
XANTENNA_58 net481 VGND VGND VPWR VPWR sky130_fd_sc_hd__diode_2
XANTENNA_69 _00000_ VGND VGND VPWR VPWR sky130_fd_sc_hd__diode_2
XTAP_TAPCELL_ROW_99_1741 VGND VPWR sky130_fd_sc_hd__tapvpwrvgnd_1
X_08172_ picorv32_core.mem_rdata_q\[13\] net8 net520 VGND VGND VPWR VPWR _00754_ sky130_fd_sc_hd__mux2_1
X_05384_ _01886_ _01887_ _01881_ VGND VGND VPWR VPWR _01888_ sky130_fd_sc_hd__a21o_1
X_07123_ picorv32_core.count_cycle\[16\] picorv32_core.count_cycle\[17\] picorv32_core.count_cycle\[18\]
+ _03304_ VGND VGND VPWR VPWR _03309_ sky130_fd_sc_hd__and4_1
XFILLER_118_289 VGND VGND VPWR VPWR sky130_fd_sc_hd__decap_3
X_07054_ net677 _03260_ _03259_ _01700_ VGND VGND VPWR VPWR _03261_ sky130_fd_sc_hd__o211a_1
Xoutput110 net110 VGND VGND VPWR VPWR mem_axi_wdata[15] sky130_fd_sc_hd__buf_2
X_06005_ net183 _02458_ VGND VGND VPWR VPWR _02469_ sky130_fd_sc_hd__or2_1
Xoutput143 net800 VGND VGND VPWR VPWR pcpi_rs1[11] sky130_fd_sc_hd__buf_2
Xoutput132 net132 VGND VGND VPWR VPWR mem_axi_wdata[6] sky130_fd_sc_hd__buf_2
Xoutput121 net121 VGND VGND VPWR VPWR mem_axi_wdata[25] sky130_fd_sc_hd__buf_2
Xoutput154 net780 VGND VGND VPWR VPWR pcpi_rs1[21] sky130_fd_sc_hd__buf_2
XFILLER_114_440 VGND VGND VPWR VPWR sky130_fd_sc_hd__fill_2
Xoutput165 net165 VGND VGND VPWR VPWR pcpi_rs1[31] sky130_fd_sc_hd__buf_2
XFILLER_99_151 VGND VGND VPWR VPWR sky130_fd_sc_hd__fill_1
XFILLER_88_836 VGND VGND VPWR VPWR sky130_fd_sc_hd__fill_1
XFILLER_87_302 VGND VGND VPWR VPWR sky130_fd_sc_hd__decap_3
Xoutput176 net957 VGND VGND VPWR VPWR pcpi_rs2[12] sky130_fd_sc_hd__buf_2
XFILLER_0_729 VGND VGND VPWR VPWR sky130_fd_sc_hd__fill_2
Xoutput187 net187 VGND VGND VPWR VPWR pcpi_rs2[22] sky130_fd_sc_hd__buf_2
XFILLER_141_281 VPWR VGND VPWR VGND sky130_ef_sc_hd__decap_12
XFILLER_102_624 VPWR VGND VPWR VGND sky130_ef_sc_hd__decap_12
Xoutput198 net198 VGND VGND VPWR VPWR pcpi_rs2[3] sky130_fd_sc_hd__buf_2
X_07956_ _04031_ _04032_ net637 VGND VGND VPWR VPWR _04037_ sky130_fd_sc_hd__mux2_1
XTAP_TAPCELL_ROW_126_2137 VGND VPWR sky130_fd_sc_hd__tapvpwrvgnd_1
XTAP_TAPCELL_ROW_126_2126 VGND VPWR sky130_fd_sc_hd__tapvpwrvgnd_1
XFILLER_101_167 VGND VGND VPWR VPWR sky130_fd_sc_hd__fill_1
X_06907_ _02929_ _03111_ net664 VGND VGND VPWR VPWR _03126_ sky130_fd_sc_hd__o21a_1
XFILLER_46_15 VGND VGND VPWR VPWR sky130_fd_sc_hd__decap_4
XPHY_EDGE_ROW_106_Right_106 VGND VGND VPWR VPWR sky130_fd_sc_hd__decap_3
X_07887_ _03958_ _03959_ net695 VGND VGND VPWR VPWR _03972_ sky130_fd_sc_hd__mux2_1
XFILLER_56_755 VGND VGND VPWR VPWR sky130_fd_sc_hd__fill_1
XFILLER_46_48 VGND VGND VPWR VPWR sky130_fd_sc_hd__decap_4
X_09626_ net790 net542 _04804_ net472 VGND VGND VPWR VPWR _04805_ sky130_fd_sc_hd__o211a_1
XFILLER_83_585 VGND VGND VPWR VPWR sky130_fd_sc_hd__fill_1
XFILLER_71_725 VGND VGND VPWR VPWR sky130_fd_sc_hd__decap_3
X_06838_ _02923_ _02924_ _03040_ VGND VGND VPWR VPWR _03062_ sky130_fd_sc_hd__and3_1
XTAP_TAPCELL_ROW_108_1870 VGND VPWR sky130_fd_sc_hd__tapvpwrvgnd_1
X_09557_ net796 net546 _04738_ net473 VGND VGND VPWR VPWR _04739_ sky130_fd_sc_hd__o211a_1
XFILLER_71_747 VGND VGND VPWR VPWR sky130_fd_sc_hd__fill_1
X_06769_ net980 _02998_ VGND VGND VPWR VPWR _00235_ sky130_fd_sc_hd__and2_1
X_08508_ net1201 net217 net409 VGND VGND VPWR VPWR _00638_ sky130_fd_sc_hd__mux2_1
Xclkbuf_leaf_35_clk clknet_4_5_0_clk VGND VGND VPWR VPWR clknet_leaf_35_clk sky130_fd_sc_hd__clkbuf_8
X_09488_ net794 net280 VGND VGND VPWR VPWR _04673_ sky130_fd_sc_hd__and2_1
XFILLER_70_246 VGND VGND VPWR VPWR sky130_fd_sc_hd__decap_6
X_08439_ net676 picorv32_core.decoded_imm_j\[17\] net616 picorv32_core.mem_rdata_q\[17\]
+ VGND VGND VPWR VPWR _04300_ sky130_fd_sc_hd__a22o_1
XFILLER_12_825 VGND VGND VPWR VPWR sky130_fd_sc_hd__decap_8
XFILLER_127_3 VPWR VGND VPWR VGND sky130_ef_sc_hd__decap_12
XFILLER_7_317 VGND VGND VPWR VPWR sky130_fd_sc_hd__fill_1
X_11450_ clknet_leaf_111_clk _01286_ VGND VGND VPWR VPWR picorv32_core.cpuregs\[24\]\[1\]
+ sky130_fd_sc_hd__dfxtp_1
XFILLER_137_565 VGND VGND VPWR VPWR sky130_fd_sc_hd__fill_2
XTAP_TAPCELL_ROW_137_2288 VGND VPWR sky130_fd_sc_hd__tapvpwrvgnd_1
XFILLER_109_245 VGND VGND VPWR VPWR sky130_fd_sc_hd__fill_1
X_10401_ clknet_leaf_77_clk _00320_ VGND VGND VPWR VPWR picorv32_core.count_cycle\[59\]
+ sky130_fd_sc_hd__dfxtp_1
X_11381_ clknet_leaf_83_clk _00026_ VGND VGND VPWR VPWR _00006_ sky130_fd_sc_hd__dfxtp_4
XPHY_EDGE_ROW_12_Left_154 VGND VGND VPWR VPWR sky130_fd_sc_hd__decap_3
X_10332_ clknet_leaf_58_clk _00251_ VGND VGND VPWR VPWR picorv32_core.reg_next_pc\[22\]
+ sky130_fd_sc_hd__dfxtp_1
XFILLER_127_51 VGND VGND VPWR VPWR sky130_fd_sc_hd__decap_4
XFILLER_105_462 VPWR VGND VPWR VGND sky130_ef_sc_hd__decap_12
X_10263_ clknet_leaf_81_clk _00182_ VGND VGND VPWR VPWR picorv32_core.count_instr\[47\]
+ sky130_fd_sc_hd__dfxtp_1
XFILLER_120_421 VGND VGND VPWR VPWR sky130_fd_sc_hd__decap_4
XFILLER_87_66 VGND VGND VPWR VPWR sky130_fd_sc_hd__fill_2
X_10194_ clknet_leaf_2_clk _00113_ VGND VGND VPWR VPWR picorv32_core.cpuregs\[9\]\[10\]
+ sky130_fd_sc_hd__dfxtp_1
Xfanout392 net393 VGND VGND VPWR VPWR net392 sky130_fd_sc_hd__clkbuf_8
Xfanout381 _04337_ VGND VGND VPWR VPWR net381 sky130_fd_sc_hd__buf_4
XTAP_TAPCELL_ROW_6_394 VGND VPWR sky130_fd_sc_hd__tapvpwrvgnd_1
XPHY_EDGE_ROW_21_Left_163 VGND VGND VPWR VPWR sky130_fd_sc_hd__decap_3
Xfanout370 net371 VGND VGND VPWR VPWR net370 sky130_fd_sc_hd__buf_4
XFILLER_19_468 VGND VGND VPWR VPWR sky130_fd_sc_hd__decap_6
XFILLER_34_449 VPWR VGND VPWR VGND sky130_ef_sc_hd__decap_12
Xclkbuf_leaf_26_clk clknet_4_4_0_clk VGND VGND VPWR VPWR clknet_leaf_26_clk sky130_fd_sc_hd__clkbuf_8
XTAP_TAPCELL_ROW_45_956 VGND VPWR sky130_fd_sc_hd__tapvpwrvgnd_1
XFILLER_42_493 VPWR VGND VPWR VGND sky130_ef_sc_hd__decap_12
X_11648_ clknet_leaf_70_clk _01479_ VGND VGND VPWR VPWR picorv32_core.cpuregs\[28\]\[29\]
+ sky130_fd_sc_hd__dfxtp_1
Xinput12 mem_axi_rdata[17] VGND VGND VPWR VPWR net12 sky130_fd_sc_hd__clkbuf_2
XPHY_EDGE_ROW_30_Left_172 VGND VGND VPWR VPWR sky130_fd_sc_hd__decap_3
X_11579_ clknet_leaf_64_clk _01410_ VGND VGND VPWR VPWR picorv32_core.cpuregs\[2\]\[26\]
+ sky130_fd_sc_hd__dfxtp_1
Xinput23 mem_axi_rdata[27] VGND VGND VPWR VPWR net23 sky130_fd_sc_hd__clkbuf_2
Xinput34 mem_axi_rdata[8] VGND VGND VPWR VPWR net34 sky130_fd_sc_hd__dlymetal6s2s_1
Xhold818 picorv32_core.cpuregs\[18\]\[23\] VGND VGND VPWR VPWR net1927 sky130_fd_sc_hd__dlygate4sd3_1
Xhold807 picorv32_core.cpuregs\[17\]\[23\] VGND VGND VPWR VPWR net1916 sky130_fd_sc_hd__dlygate4sd3_1
Xhold829 picorv32_core.cpuregs\[5\]\[22\] VGND VGND VPWR VPWR net1938 sky130_fd_sc_hd__dlygate4sd3_1
XTAP_TAPCELL_ROW_94_1671 VGND VPWR sky130_fd_sc_hd__tapvpwrvgnd_1
XFILLER_42_3 VGND VGND VPWR VPWR sky130_fd_sc_hd__fill_2
XFILLER_124_793 VPWR VGND VPWR VGND sky130_ef_sc_hd__decap_12
XFILLER_123_270 VGND VGND VPWR VPWR sky130_fd_sc_hd__fill_2
X_07810_ _03889_ _03890_ net635 VGND VGND VPWR VPWR _03899_ sky130_fd_sc_hd__mux2_1
X_08790_ net492 net1876 net371 VGND VGND VPWR VPWR _00968_ sky130_fd_sc_hd__mux2_1
X_07741_ _03827_ _03832_ _03833_ net682 net687 VGND VGND VPWR VPWR _03834_ sky130_fd_sc_hd__a221o_1
XFILLER_65_541 VGND VGND VPWR VPWR sky130_fd_sc_hd__fill_1
XFILLER_65_552 VGND VGND VPWR VPWR sky130_fd_sc_hd__decap_8
X_07672_ picorv32_core.cpuregs\[20\]\[9\] picorv32_core.cpuregs\[21\]\[9\] picorv32_core.cpuregs\[22\]\[9\]
+ picorv32_core.cpuregs\[23\]\[9\] net731 net698 VGND VGND VPWR VPWR _03768_ sky130_fd_sc_hd__mux4_1
X_06623_ net2331 _02894_ net996 VGND VGND VPWR VPWR _02897_ sky130_fd_sc_hd__o21ai_1
XFILLER_92_382 VGND VGND VPWR VPWR sky130_fd_sc_hd__fill_1
XFILLER_16_18 VGND VGND VPWR VPWR sky130_fd_sc_hd__decap_8
XFILLER_16_29 VPWR VGND VPWR VGND sky130_ef_sc_hd__decap_12
XFILLER_25_427 VGND VGND VPWR VPWR sky130_fd_sc_hd__fill_2
X_09411_ picorv32_core.cpuregs\[12\]\[10\] picorv32_core.cpuregs\[13\]\[10\] picorv32_core.cpuregs\[14\]\[10\]
+ picorv32_core.cpuregs\[15\]\[10\] net873 net840 VGND VGND VPWR VPWR _04600_ sky130_fd_sc_hd__mux4_1
XTAP_TAPCELL_ROW_121_2056 VGND VPWR sky130_fd_sc_hd__tapvpwrvgnd_1
X_06554_ picorv32_core.count_instr\[31\] picorv32_core.count_instr\[30\] _02849_ VGND
+ VGND VPWR VPWR _02853_ sky130_fd_sc_hd__and3_1
Xclkbuf_leaf_17_clk clknet_4_6_0_clk VGND VGND VPWR VPWR clknet_leaf_17_clk sky130_fd_sc_hd__clkbuf_8
X_09342_ picorv32_core.cpuregs\[4\]\[7\] picorv32_core.cpuregs\[5\]\[7\] picorv32_core.cpuregs\[6\]\[7\]
+ picorv32_core.cpuregs\[7\]\[7\] net877 net844 VGND VGND VPWR VPWR _04534_ sky130_fd_sc_hd__mux4_1
X_05505_ picorv32_core.count_instr\[53\] net937 net941 picorv32_core.count_instr\[21\]
+ VGND VGND VPWR VPWR _02000_ sky130_fd_sc_hd__a22o_1
XTAP_TAPCELL_ROW_23_639 VGND VPWR sky130_fd_sc_hd__tapvpwrvgnd_1
X_06485_ picorv32_core.count_instr\[6\] picorv32_core.count_instr\[5\] _02805_ VGND
+ VGND VPWR VPWR _02809_ sky130_fd_sc_hd__and3_1
X_09273_ _04461_ _04463_ net649 VGND VGND VPWR VPWR _04468_ sky130_fd_sc_hd__o21a_1
XFILLER_138_318 VGND VGND VPWR VPWR sky130_fd_sc_hd__decap_4
XFILLER_119_521 VGND VGND VPWR VPWR sky130_fd_sc_hd__fill_2
X_05436_ _01934_ _01935_ VGND VGND VPWR VPWR _01936_ sky130_fd_sc_hd__nor2_1
X_08224_ picorv32_core.mem_rdata_q\[24\] picorv32_core.mem_rdata_q\[27\] net524 _04201_
+ VGND VGND VPWR VPWR _04211_ sky130_fd_sc_hd__or4_1
XFILLER_119_565 VGND VGND VPWR VPWR sky130_fd_sc_hd__fill_1
X_05367_ net921 _01863_ _01864_ _01871_ VGND VGND VPWR VPWR _01549_ sky130_fd_sc_hd__a31o_1
X_08155_ net988 net527 _04180_ VGND VGND VPWR VPWR _04182_ sky130_fd_sc_hd__and3_1
XFILLER_107_727 VGND VGND VPWR VPWR sky130_fd_sc_hd__fill_1
X_07106_ _03298_ net992 _03297_ VGND VGND VPWR VPWR _00272_ sky130_fd_sc_hd__and3b_1
X_08086_ _01621_ _04159_ net626 VGND VGND VPWR VPWR _04160_ sky130_fd_sc_hd__a21o_1
X_05298_ _01778_ _01792_ _01794_ _01791_ VGND VGND VPWR VPWR _01807_ sky130_fd_sc_hd__o31a_1
XFILLER_115_771 VPWR VGND VPWR VGND sky130_ef_sc_hd__decap_12
X_07037_ _03231_ _03235_ _03243_ VGND VGND VPWR VPWR _03245_ sky130_fd_sc_hd__a21oi_1
XFILLER_88_622 VGND VGND VPWR VPWR sky130_fd_sc_hd__fill_2
XFILLER_102_432 VGND VGND VPWR VPWR sky130_fd_sc_hd__fill_2
XFILLER_88_666 VGND VGND VPWR VPWR sky130_fd_sc_hd__fill_1
XFILLER_88_699 VGND VGND VPWR VPWR sky130_fd_sc_hd__fill_1
XTAP_TAPCELL_ROW_50_1029 VGND VPWR sky130_fd_sc_hd__tapvpwrvgnd_1
X_08988_ net500 net1914 net345 VGND VGND VPWR VPWR _01158_ sky130_fd_sc_hd__mux2_1
X_07939_ _04014_ _04015_ net638 VGND VGND VPWR VPWR _04021_ sky130_fd_sc_hd__mux2_1
XTAP_TAPCELL_ROW_3_353 VGND VPWR sky130_fd_sc_hd__tapvpwrvgnd_1
XTAP_TAPCELL_ROW_3_342 VGND VPWR sky130_fd_sc_hd__tapvpwrvgnd_1
X_10950_ clknet_leaf_36_clk _00801_ VGND VGND VPWR VPWR picorv32_core.cpuregs\[19\]\[28\]
+ sky130_fd_sc_hd__dfxtp_1
XFILLER_29_766 VPWR VGND VPWR VGND sky130_ef_sc_hd__decap_12
X_10881_ clknet_leaf_67_clk _00732_ VGND VGND VPWR VPWR picorv32_core.cpuregs\[16\]\[25\]
+ sky130_fd_sc_hd__dfxtp_1
X_09609_ picorv32_core.cpuregs\[16\]\[19\] picorv32_core.cpuregs\[17\]\[19\] picorv32_core.cpuregs\[18\]\[19\]
+ picorv32_core.cpuregs\[19\]\[19\] net890 net856 VGND VGND VPWR VPWR _04789_ sky130_fd_sc_hd__mux4_1
XFILLER_83_393 VPWR VGND VPWR VGND sky130_ef_sc_hd__decap_12
XFILLER_83_371 VGND VGND VPWR VPWR sky130_fd_sc_hd__decap_4
XFILLER_28_298 VGND VGND VPWR VPWR sky130_fd_sc_hd__fill_1
XFILLER_73_57 VGND VGND VPWR VPWR sky130_fd_sc_hd__fill_2
XTAP_TAPCELL_ROW_65_1250 VGND VPWR sky130_fd_sc_hd__tapvpwrvgnd_1
XTAP_TAPCELL_ROW_139_2317 VGND VPWR sky130_fd_sc_hd__tapvpwrvgnd_1
XFILLER_52_780 VGND VGND VPWR VPWR sky130_fd_sc_hd__decap_4
XTAP_TAPCELL_ROW_42_915 VGND VPWR sky130_fd_sc_hd__tapvpwrvgnd_1
XFILLER_43_279 VGND VGND VPWR VPWR sky130_fd_sc_hd__fill_1
XFILLER_24_482 VGND VGND VPWR VPWR sky130_fd_sc_hd__fill_2
X_11502_ clknet_leaf_56_clk _01338_ VGND VGND VPWR VPWR net151 sky130_fd_sc_hd__dfxtp_1
X_11433_ clknet_leaf_21_clk _01269_ VGND VGND VPWR VPWR picorv32_core.cpuregs\[1\]\[16\]
+ sky130_fd_sc_hd__dfxtp_1
XFILLER_7_125 VPWR VGND VPWR VGND sky130_ef_sc_hd__decap_12
XFILLER_7_169 VPWR VGND VPWR VGND sky130_ef_sc_hd__decap_12
XFILLER_22_83 VGND VGND VPWR VPWR sky130_fd_sc_hd__fill_1
XFILLER_138_83 VGND VGND VPWR VPWR sky130_fd_sc_hd__fill_1
X_11364_ clknet_leaf_21_clk _01205_ VGND VGND VPWR VPWR picorv32_core.cpuregs\[18\]\[16\]
+ sky130_fd_sc_hd__dfxtp_1
X_11295_ clknet_leaf_50_clk _01143_ VGND VGND VPWR VPWR picorv32_core.cpuregs\[3\]\[18\]
+ sky130_fd_sc_hd__dfxtp_1
XFILLER_98_419 VGND VGND VPWR VPWR sky130_fd_sc_hd__fill_1
X_10315_ clknet_leaf_123_clk _00234_ VGND VGND VPWR VPWR picorv32_core.reg_next_pc\[5\]
+ sky130_fd_sc_hd__dfxtp_1
XFILLER_112_218 VGND VGND VPWR VPWR sky130_fd_sc_hd__fill_1
XFILLER_106_782 VGND VGND VPWR VPWR sky130_fd_sc_hd__decap_4
X_10246_ clknet_leaf_77_clk _00165_ VGND VGND VPWR VPWR picorv32_core.count_instr\[30\]
+ sky130_fd_sc_hd__dfxtp_1
XFILLER_121_741 VPWR VGND VPWR VGND sky130_ef_sc_hd__decap_12
XFILLER_105_292 VGND VGND VPWR VPWR sky130_fd_sc_hd__decap_4
X_10177_ clknet_leaf_66_clk _00096_ VGND VGND VPWR VPWR picorv32_core.cpuregs\[21\]\[25\]
+ sky130_fd_sc_hd__dfxtp_1
XFILLER_121_785 VPWR VGND VPWR VGND sky130_ef_sc_hd__decap_12
XFILLER_120_273 VGND VGND VPWR VPWR sky130_fd_sc_hd__fill_1
XFILLER_94_625 VGND VGND VPWR VPWR sky130_fd_sc_hd__fill_1
XFILLER_120_295 VGND VGND VPWR VPWR sky130_fd_sc_hd__fill_1
XFILLER_59_390 VGND VGND VPWR VPWR sky130_fd_sc_hd__fill_2
XFILLER_47_530 VGND VGND VPWR VPWR sky130_fd_sc_hd__fill_1
XFILLER_81_308 VGND VGND VPWR VPWR sky130_fd_sc_hd__fill_2
XFILLER_62_533 VPWR VGND VPWR VGND sky130_ef_sc_hd__decap_12
XFILLER_34_213 VGND VGND VPWR VPWR sky130_fd_sc_hd__fill_1
XFILLER_15_460 VGND VGND VPWR VPWR sky130_fd_sc_hd__fill_1
XFILLER_30_430 VGND VGND VPWR VPWR sky130_fd_sc_hd__decap_6
XFILLER_8_41 VPWR VGND VPWR VGND sky130_ef_sc_hd__decap_12
X_06270_ _02688_ _02689_ net563 VGND VGND VPWR VPWR _02690_ sky130_fd_sc_hd__mux2_1
XTAP_TAPCELL_ROW_96_1700 VGND VPWR sky130_fd_sc_hd__tapvpwrvgnd_1
XFILLER_8_85 VPWR VGND VPWR VGND sky130_ef_sc_hd__decap_12
XFILLER_30_496 VGND VGND VPWR VPWR sky130_fd_sc_hd__fill_2
X_05221_ picorv32_core.reg_pc\[1\] picorv32_core.decoded_imm\[1\] net921 VGND VGND
+ VPWR VPWR _01736_ sky130_fd_sc_hd__o21ai_1
Xhold615 picorv32_core.cpuregs\[9\]\[29\] VGND VGND VPWR VPWR net1724 sky130_fd_sc_hd__dlygate4sd3_1
Xhold604 picorv32_core.cpuregs\[31\]\[20\] VGND VGND VPWR VPWR net1713 sky130_fd_sc_hd__dlygate4sd3_1
Xhold626 picorv32_core.cpuregs\[22\]\[16\] VGND VGND VPWR VPWR net1735 sky130_fd_sc_hd__dlygate4sd3_1
X_05152_ picorv32_core.instr_rdcycle net599 VGND VGND VPWR VPWR _01679_ sky130_fd_sc_hd__nor2_1
Xhold637 picorv32_core.cpuregs\[31\]\[23\] VGND VGND VPWR VPWR net1746 sky130_fd_sc_hd__dlygate4sd3_1
X_09960_ net1241 net248 net318 VGND VGND VPWR VPWR _01438_ sky130_fd_sc_hd__mux2_1
Xhold648 picorv32_core.cpuregs\[23\]\[21\] VGND VGND VPWR VPWR net1757 sky130_fd_sc_hd__dlygate4sd3_1
Xclkbuf_leaf_6_clk clknet_4_1_0_clk VGND VGND VPWR VPWR clknet_leaf_6_clk sky130_fd_sc_hd__clkbuf_8
Xhold659 picorv32_core.cpuregs\[26\]\[8\] VGND VGND VPWR VPWR net1768 sky130_fd_sc_hd__dlygate4sd3_1
X_05083_ net825 VGND VGND VPWR VPWR _01618_ sky130_fd_sc_hd__inv_2
X_08911_ net232 net1597 net360 VGND VGND VPWR VPWR _01085_ sky130_fd_sc_hd__mux2_1
X_09891_ net1369 net214 net327 VGND VGND VPWR VPWR _01379_ sky130_fd_sc_hd__mux2_1
X_08842_ net1936 net245 net367 VGND VGND VPWR VPWR _01018_ sky130_fd_sc_hd__mux2_1
XFILLER_85_603 VGND VGND VPWR VPWR sky130_fd_sc_hd__decap_4
X_08773_ net253 net2173 net375 VGND VGND VPWR VPWR _00920_ sky130_fd_sc_hd__mux2_1
XFILLER_85_658 VPWR VGND VPWR VGND sky130_ef_sc_hd__decap_12
X_05985_ net785 _02449_ VGND VGND VPWR VPWR _02451_ sky130_fd_sc_hd__or2_1
XTAP_TAPCELL_ROW_0_301 VGND VPWR sky130_fd_sc_hd__tapvpwrvgnd_1
XTAP_TAPCELL_ROW_0_312 VGND VPWR sky130_fd_sc_hd__tapvpwrvgnd_1
XTAP_TAPCELL_ROW_28_709 VGND VPWR sky130_fd_sc_hd__tapvpwrvgnd_1
X_07724_ net692 _03813_ _03812_ net618 VGND VGND VPWR VPWR _03818_ sky130_fd_sc_hd__o211a_1
XFILLER_81_820 VGND VGND VPWR VPWR sky130_fd_sc_hd__fill_1
XFILLER_65_393 VGND VGND VPWR VPWR sky130_fd_sc_hd__decap_4
XFILLER_65_382 VGND VGND VPWR VPWR sky130_fd_sc_hd__decap_8
X_07655_ picorv32_core.cpuregs\[20\]\[8\] picorv32_core.cpuregs\[21\]\[8\] picorv32_core.cpuregs\[22\]\[8\]
+ picorv32_core.cpuregs\[23\]\[8\] net738 net705 VGND VGND VPWR VPWR _03752_ sky130_fd_sc_hd__mux4_1
X_06606_ _01586_ _02884_ _02885_ _02881_ net976 VGND VGND VPWR VPWR _00185_ sky130_fd_sc_hd__a221oi_1
XFILLER_26_769 VPWR VGND VPWR VGND sky130_ef_sc_hd__decap_12
X_07586_ picorv32_core.decoded_imm\[1\] _01682_ VGND VGND VPWR VPWR _03690_ sky130_fd_sc_hd__nor2_1
X_06537_ picorv32_core.count_instr\[24\] _02839_ picorv32_core.count_instr\[25\] VGND
+ VGND VPWR VPWR _02842_ sky130_fd_sc_hd__a21o_1
X_09325_ net652 _04510_ net825 VGND VGND VPWR VPWR _04518_ sky130_fd_sc_hd__o21a_1
XFILLER_33_290 VGND VGND VPWR VPWR sky130_fd_sc_hd__decap_3
XFILLER_139_638 VGND VGND VPWR VPWR sky130_fd_sc_hd__fill_1
X_06468_ net209 net2041 net420 VGND VGND VPWR VPWR _00134_ sky130_fd_sc_hd__mux2_1
X_09256_ net610 _03467_ _04447_ _04451_ _04446_ VGND VGND VPWR VPWR _04452_ sky130_fd_sc_hd__a311o_1
X_05419_ net10 _01818_ _01919_ VGND VGND VPWR VPWR _01920_ sky130_fd_sc_hd__o21a_1
XTAP_TAPCELL_ROW_60_1180 VGND VPWR sky130_fd_sc_hd__tapvpwrvgnd_1
Xpicorv32_axi_1003 VGND VGND VPWR VPWR picorv32_axi_1003/HI eoi[4] sky130_fd_sc_hd__conb_1
X_08207_ net947 _04205_ _04206_ net1125 VGND VGND VPWR VPWR _00456_ sky130_fd_sc_hd__a22o_1
XTAP_TAPCELL_ROW_134_2247 VGND VPWR sky130_fd_sc_hd__tapvpwrvgnd_1
X_06399_ _02792_ _02793_ net564 VGND VGND VPWR VPWR _02794_ sky130_fd_sc_hd__mux2_1
XFILLER_107_502 VGND VGND VPWR VPWR sky130_fd_sc_hd__fill_2
X_09187_ picorv32_core.cpuregs\[12\]\[1\] picorv32_core.cpuregs\[13\]\[1\] net887
+ VGND VGND VPWR VPWR _04385_ sky130_fd_sc_hd__mux2_1
Xpicorv32_axi_1036 VGND VGND VPWR VPWR picorv32_axi_1036/HI mem_axi_awaddr[1] sky130_fd_sc_hd__conb_1
Xpicorv32_axi_1025 VGND VGND VPWR VPWR picorv32_axi_1025/HI eoi[26] sky130_fd_sc_hd__conb_1
Xpicorv32_axi_1014 VGND VGND VPWR VPWR picorv32_axi_1014/HI eoi[15] sky130_fd_sc_hd__conb_1
Xpicorv32_axi_1069 VGND VGND VPWR VPWR picorv32_axi_1069/HI pcpi_insn[29] sky130_fd_sc_hd__conb_1
XFILLER_135_833 VGND VGND VPWR VPWR sky130_fd_sc_hd__fill_1
X_08138_ net2322 net15 net521 VGND VGND VPWR VPWR _00742_ sky130_fd_sc_hd__mux2_1
XFILLER_4_139 VGND VGND VPWR VPWR sky130_fd_sc_hd__fill_1
Xpicorv32_axi_1058 VGND VGND VPWR VPWR picorv32_axi_1058/HI pcpi_insn[18] sky130_fd_sc_hd__conb_1
Xpicorv32_axi_1047 VGND VGND VPWR VPWR picorv32_axi_1047/HI pcpi_insn[7] sky130_fd_sc_hd__conb_1
XTAP_TAPCELL_ROW_116_1980 VGND VPWR sky130_fd_sc_hd__tapvpwrvgnd_1
X_08069_ picorv32_core.decoded_imm\[30\] net593 net598 VGND VGND VPWR VPWR _04144_
+ sky130_fd_sc_hd__a21o_1
X_11080_ clknet_leaf_63_clk _00931_ VGND VGND VPWR VPWR picorv32_core.cpuregs\[10\]\[30\]
+ sky130_fd_sc_hd__dfxtp_1
XFILLER_122_527 VGND VGND VPWR VPWR sky130_fd_sc_hd__decap_4
XTAP_TAPCELL_ROW_116_1991 VGND VPWR sky130_fd_sc_hd__tapvpwrvgnd_1
X_10100_ net1138 VGND VGND VPWR VPWR _00950_ sky130_fd_sc_hd__clkbuf_1
XTAP_TAPCELL_ROW_8_423 VGND VPWR sky130_fd_sc_hd__tapvpwrvgnd_1
X_10031_ net1199 net230 net311 VGND VGND VPWR VPWR _01507_ sky130_fd_sc_hd__mux2_1
XFILLER_0_345 VGND VGND VPWR VPWR sky130_fd_sc_hd__fill_1
XFILLER_130_571 VGND VGND VPWR VPWR sky130_fd_sc_hd__fill_1
XFILLER_88_474 VGND VGND VPWR VPWR sky130_fd_sc_hd__fill_2
XFILLER_75_102 VGND VGND VPWR VPWR sky130_fd_sc_hd__fill_1
XFILLER_0_378 VGND VGND VPWR VPWR sky130_fd_sc_hd__decap_3
XFILLER_124_41 VPWR VGND VPWR VGND sky130_ef_sc_hd__decap_12
XFILLER_76_636 VGND VGND VPWR VPWR sky130_fd_sc_hd__fill_1
XFILLER_124_85 VGND VGND VPWR VPWR sky130_fd_sc_hd__decap_4
XFILLER_91_617 VGND VGND VPWR VPWR sky130_fd_sc_hd__decap_4
XFILLER_84_45 VGND VGND VPWR VPWR sky130_fd_sc_hd__fill_1
XFILLER_75_146 VGND VGND VPWR VPWR sky130_fd_sc_hd__decap_4
XFILLER_84_680 VPWR VGND VPWR VGND sky130_ef_sc_hd__decap_12
X_10933_ clknet_leaf_4_clk _00784_ VGND VGND VPWR VPWR picorv32_core.cpuregs\[19\]\[11\]
+ sky130_fd_sc_hd__dfxtp_1
X_10864_ clknet_leaf_130_clk _00715_ VGND VGND VPWR VPWR picorv32_core.cpuregs\[16\]\[8\]
+ sky130_fd_sc_hd__dfxtp_1
X_10795_ clknet_leaf_115_clk _00646_ VGND VGND VPWR VPWR picorv32_core.cpuregs\[15\]\[4\]
+ sky130_fd_sc_hd__dfxtp_1
XFILLER_126_811 VGND VGND VPWR VPWR sky130_fd_sc_hd__fill_1
XTAP_TAPCELL_ROW_78_1430 VGND VPWR sky130_fd_sc_hd__tapvpwrvgnd_1
XFILLER_125_332 VGND VGND VPWR VPWR sky130_fd_sc_hd__decap_4
XFILLER_125_310 VGND VGND VPWR VPWR sky130_fd_sc_hd__fill_1
X_11416_ clknet_leaf_60_clk _01252_ VGND VGND VPWR VPWR picorv32_core.cpuregs\[31\]\[31\]
+ sky130_fd_sc_hd__dfxtp_1
XTAP_TAPCELL_ROW_78_1441 VGND VPWR sky130_fd_sc_hd__tapvpwrvgnd_1
X_11347_ clknet_leaf_60_clk _01188_ VGND VGND VPWR VPWR picorv32_core.cpuregs\[29\]\[31\]
+ sky130_fd_sc_hd__dfxtp_1
XFILLER_141_825 VGND VGND VPWR VPWR sky130_fd_sc_hd__fill_1
XTAP_TAPCELL_ROW_91_1630 VGND VPWR sky130_fd_sc_hd__tapvpwrvgnd_1
XFILLER_3_161 VGND VGND VPWR VPWR sky130_fd_sc_hd__decap_6
X_11278_ clknet_leaf_109_clk _01126_ VGND VGND VPWR VPWR picorv32_core.cpuregs\[3\]\[1\]
+ sky130_fd_sc_hd__dfxtp_1
X_10229_ clknet_leaf_100_clk _00148_ VGND VGND VPWR VPWR picorv32_core.count_instr\[13\]
+ sky130_fd_sc_hd__dfxtp_1
Xhold1 picorv32_core.cpuregs\[0\]\[29\] VGND VGND VPWR VPWR net1110 sky130_fd_sc_hd__dlygate4sd3_1
XFILLER_94_477 VGND VGND VPWR VPWR sky130_fd_sc_hd__decap_3
XFILLER_82_606 VGND VGND VPWR VPWR sky130_fd_sc_hd__fill_1
X_05770_ picorv32_core.is_compare net606 net572 net568 VGND VGND VPWR VPWR _02254_
+ sky130_fd_sc_hd__or4_4
XFILLER_94_499 VGND VGND VPWR VPWR sky130_fd_sc_hd__fill_2
XTAP_TAPCELL_ROW_89_1592 VGND VPWR sky130_fd_sc_hd__tapvpwrvgnd_1
XFILLER_47_393 VGND VGND VPWR VPWR sky130_fd_sc_hd__fill_1
XFILLER_62_385 VGND VGND VPWR VPWR sky130_fd_sc_hd__decap_6
XFILLER_62_363 VGND VGND VPWR VPWR sky130_fd_sc_hd__fill_1
XPHY_EDGE_ROW_8_Right_8 VGND VGND VPWR VPWR sky130_fd_sc_hd__decap_3
X_07440_ picorv32_core.mem_do_rinst picorv32_core.mem_do_prefetch VGND VGND VPWR VPWR
+ _03579_ sky130_fd_sc_hd__nor2_1
X_07371_ _03503_ _03505_ _03507_ _03510_ _03506_ VGND VGND VPWR VPWR _03511_ sky130_fd_sc_hd__a311oi_2
X_09110_ net232 net1401 net334 VGND VGND VPWR VPWR _01277_ sky130_fd_sc_hd__mux2_1
X_06322_ net1735 net265 net435 VGND VGND VPWR VPWR _00055_ sky130_fd_sc_hd__mux2_1
XTAP_TAPCELL_ROW_33_778 VGND VPWR sky130_fd_sc_hd__tapvpwrvgnd_1
XTAP_TAPCELL_ROW_33_789 VGND VPWR sky130_fd_sc_hd__tapvpwrvgnd_1
X_09041_ net245 net2113 net342 VGND VGND VPWR VPWR _01210_ sky130_fd_sc_hd__mux2_1
XFILLER_31_783 VGND VGND VPWR VPWR sky130_fd_sc_hd__fill_1
XTAP_TAPCELL_ROW_13_491 VGND VPWR sky130_fd_sc_hd__tapvpwrvgnd_1
X_06253_ picorv32_core.reg_pc\[3\] picorv32_core.reg_pc\[2\] VGND VGND VPWR VPWR _02676_
+ sky130_fd_sc_hd__xor2_1
XFILLER_129_682 VGND VGND VPWR VPWR sky130_fd_sc_hd__decap_4
X_05204_ net820 net34 _01718_ _01719_ VGND VGND VPWR VPWR _01720_ sky130_fd_sc_hd__o211a_1
X_06184_ picorv32_core.cpuregs\[28\]\[2\] picorv32_core.cpuregs\[29\]\[2\] picorv32_core.cpuregs\[30\]\[2\]
+ picorv32_core.cpuregs\[31\]\[2\] net734 net701 VGND VGND VPWR VPWR _02616_ sky130_fd_sc_hd__mux4_1
Xhold401 picorv32_core.cpuregs\[27\]\[0\] VGND VGND VPWR VPWR net1510 sky130_fd_sc_hd__dlygate4sd3_1
Xhold423 picorv32_core.cpuregs\[31\]\[28\] VGND VGND VPWR VPWR net1532 sky130_fd_sc_hd__dlygate4sd3_1
Xhold412 picorv32_core.cpuregs\[15\]\[15\] VGND VGND VPWR VPWR net1521 sky130_fd_sc_hd__dlygate4sd3_1
Xhold445 picorv32_core.cpuregs\[15\]\[2\] VGND VGND VPWR VPWR net1554 sky130_fd_sc_hd__dlygate4sd3_1
Xhold434 picorv32_core.cpuregs\[12\]\[6\] VGND VGND VPWR VPWR net1543 sky130_fd_sc_hd__dlygate4sd3_1
X_05135_ _01663_ net595 VGND VGND VPWR VPWR _01666_ sky130_fd_sc_hd__nor2_1
XFILLER_132_825 VGND VGND VPWR VPWR sky130_fd_sc_hd__decap_8
Xhold467 picorv32_core.cpuregs\[28\]\[31\] VGND VGND VPWR VPWR net1576 sky130_fd_sc_hd__dlygate4sd3_1
XFILLER_104_516 VGND VGND VPWR VPWR sky130_fd_sc_hd__fill_1
Xhold456 picorv32_core.cpuregs\[29\]\[7\] VGND VGND VPWR VPWR net1565 sky130_fd_sc_hd__dlygate4sd3_1
Xhold478 picorv32_core.cpuregs\[13\]\[7\] VGND VGND VPWR VPWR net1587 sky130_fd_sc_hd__dlygate4sd3_1
Xfanout903 net906 VGND VGND VPWR VPWR net903 sky130_fd_sc_hd__clkbuf_4
Xhold489 picorv32_core.cpuregs\[30\]\[22\] VGND VGND VPWR VPWR net1598 sky130_fd_sc_hd__dlygate4sd3_1
X_05066_ net765 VGND VGND VPWR VPWR _01601_ sky130_fd_sc_hd__inv_2
Xfanout925 net927 VGND VGND VPWR VPWR net925 sky130_fd_sc_hd__clkbuf_4
X_09943_ net1266 net494 net317 VGND VGND VPWR VPWR _01421_ sky130_fd_sc_hd__mux2_1
Xfanout914 net915 VGND VGND VPWR VPWR net914 sky130_fd_sc_hd__clkbuf_4
XPHY_EDGE_ROW_39_Right_39 VGND VGND VPWR VPWR sky130_fd_sc_hd__decap_3
Xfanout936 picorv32_core.instr_rdinstrh VGND VGND VPWR VPWR net936 sky130_fd_sc_hd__clkbuf_2
X_09874_ net1773 net288 net324 VGND VGND VPWR VPWR _01362_ sky130_fd_sc_hd__mux2_1
Xfanout958 net174 VGND VGND VPWR VPWR net958 sky130_fd_sc_hd__clkbuf_4
Xfanout947 picorv32_core.latched_rd\[4\] VGND VGND VPWR VPWR net947 sky130_fd_sc_hd__clkbuf_4
Xhold1112 picorv32_core.cpuregs\[8\]\[20\] VGND VGND VPWR VPWR net2221 sky130_fd_sc_hd__dlygate4sd3_1
XFILLER_100_744 VPWR VGND VPWR VGND sky130_ef_sc_hd__decap_12
Xhold1101 _00185_ VGND VGND VPWR VPWR net2210 sky130_fd_sc_hd__dlygate4sd3_1
XFILLER_57_113 VGND VGND VPWR VPWR sky130_fd_sc_hd__decap_3
Xhold1123 picorv32_core.instr_lhu VGND VGND VPWR VPWR net2232 sky130_fd_sc_hd__dlygate4sd3_1
X_08825_ net1252 net467 net369 VGND VGND VPWR VPWR _01001_ sky130_fd_sc_hd__mux2_1
Xfanout969 picorv32_core.mem_la_wdata\[0\] VGND VGND VPWR VPWR net969 sky130_fd_sc_hd__clkbuf_4
Xhold1167 picorv32_core.count_cycle\[60\] VGND VGND VPWR VPWR net2276 sky130_fd_sc_hd__dlygate4sd3_1
Xhold1156 net47 VGND VGND VPWR VPWR net2265 sky130_fd_sc_hd__dlygate4sd3_1
XFILLER_85_466 VGND VGND VPWR VPWR sky130_fd_sc_hd__fill_1
XFILLER_73_606 VGND VGND VPWR VPWR sky130_fd_sc_hd__decap_8
Xhold1145 picorv32_core.count_instr\[10\] VGND VGND VPWR VPWR net2254 sky130_fd_sc_hd__dlygate4sd3_1
Xhold1134 picorv32_core.cpuregs\[10\]\[11\] VGND VGND VPWR VPWR net2243 sky130_fd_sc_hd__dlygate4sd3_1
X_05968_ _02428_ _02434_ VGND VGND VPWR VPWR _02436_ sky130_fd_sc_hd__or2_1
Xhold1178 picorv32_core.count_instr\[41\] VGND VGND VPWR VPWR net2287 sky130_fd_sc_hd__dlygate4sd3_1
XTAP_TAPCELL_ROW_49_1020 VGND VPWR sky130_fd_sc_hd__tapvpwrvgnd_1
X_08756_ net495 net2117 net374 VGND VGND VPWR VPWR _00903_ sky130_fd_sc_hd__mux2_1
Xhold1189 net130 VGND VGND VPWR VPWR net2298 sky130_fd_sc_hd__dlygate4sd3_1
X_05899_ _02370_ _02371_ VGND VGND VPWR VPWR _02372_ sky130_fd_sc_hd__nand2_1
XFILLER_53_330 VGND VGND VPWR VPWR sky130_fd_sc_hd__decap_6
X_08687_ _04225_ _04322_ VGND VGND VPWR VPWR _04336_ sky130_fd_sc_hd__nor2_2
XFILLER_26_533 VGND VGND VPWR VPWR sky130_fd_sc_hd__decap_3
X_07707_ _03800_ _03801_ net457 _03798_ VGND VGND VPWR VPWR _03802_ sky130_fd_sc_hd__o211a_1
X_07638_ picorv32_core.cpuregs\[4\]\[7\] picorv32_core.cpuregs\[5\]\[7\] picorv32_core.cpuregs\[6\]\[7\]
+ picorv32_core.cpuregs\[7\]\[7\] net735 net702 VGND VGND VPWR VPWR _03736_ sky130_fd_sc_hd__mux4_1
XFILLER_41_503 VGND VGND VPWR VPWR sky130_fd_sc_hd__fill_1
XFILLER_53_385 VGND VGND VPWR VPWR sky130_fd_sc_hd__decap_6
XPHY_EDGE_ROW_48_Right_48 VGND VGND VPWR VPWR sky130_fd_sc_hd__decap_3
X_07569_ picorv32_core.cpuregs\[4\]\[1\] picorv32_core.cpuregs\[5\]\[1\] picorv32_core.cpuregs\[6\]\[1\]
+ picorv32_core.cpuregs\[7\]\[1\] net745 net712 VGND VGND VPWR VPWR _03673_ sky130_fd_sc_hd__mux4_1
XFILLER_13_249 VGND VGND VPWR VPWR sky130_fd_sc_hd__fill_2
XFILLER_41_536 VGND VGND VPWR VPWR sky130_fd_sc_hd__decap_3
X_09308_ net282 _04485_ _04500_ _04501_ VGND VGND VPWR VPWR _01324_ sky130_fd_sc_hd__a31o_1
X_10580_ clknet_leaf_92_clk _00434_ VGND VGND VPWR VPWR picorv32_core.instr_blt sky130_fd_sc_hd__dfxtp_1
XFILLER_108_800 VPWR VGND VPWR VGND sky130_ef_sc_hd__decap_12
X_09239_ net837 _04434_ net644 VGND VGND VPWR VPWR _04435_ sky130_fd_sc_hd__a21o_1
XFILLER_119_52 VGND VGND VPWR VPWR sky130_fd_sc_hd__decap_4
XFILLER_119_41 VGND VGND VPWR VPWR sky130_fd_sc_hd__decap_3
X_11201_ clknet_leaf_43_clk _01052_ VGND VGND VPWR VPWR picorv32_core.cpuregs\[6\]\[23\]
+ sky130_fd_sc_hd__dfxtp_1
XFILLER_107_354 VGND VGND VPWR VPWR sky130_fd_sc_hd__fill_1
XFILLER_123_836 VGND VGND VPWR VPWR sky130_fd_sc_hd__fill_1
X_11132_ clknet_leaf_51_clk _00983_ VGND VGND VPWR VPWR picorv32_core.cpuregs\[8\]\[18\]
+ sky130_fd_sc_hd__dfxtp_1
XPHY_EDGE_ROW_57_Right_57 VGND VGND VPWR VPWR sky130_fd_sc_hd__decap_3
Xhold990 picorv32_core.cpuregs\[9\]\[27\] VGND VGND VPWR VPWR net2099 sky130_fd_sc_hd__dlygate4sd3_1
XTAP_TAPCELL_ROW_73_1360 VGND VPWR sky130_fd_sc_hd__tapvpwrvgnd_1
XFILLER_135_51 VGND VGND VPWR VPWR sky130_fd_sc_hd__decap_4
X_11063_ clknet_leaf_13_clk _00914_ VGND VGND VPWR VPWR picorv32_core.cpuregs\[10\]\[13\]
+ sky130_fd_sc_hd__dfxtp_1
XFILLER_49_603 VGND VGND VPWR VPWR sky130_fd_sc_hd__decap_3
XFILLER_0_153 VPWR VGND VPWR VGND sky130_ef_sc_hd__decap_12
XFILLER_1_665 VGND VGND VPWR VPWR sky130_fd_sc_hd__decap_6
X_10014_ net1768 _02698_ net309 VGND VGND VPWR VPWR _01490_ sky130_fd_sc_hd__mux2_1
XFILLER_0_197 VPWR VGND VPWR VGND sky130_ef_sc_hd__decap_12
XFILLER_76_477 VGND VGND VPWR VPWR sky130_fd_sc_hd__decap_4
XFILLER_57_691 VGND VGND VPWR VPWR sky130_fd_sc_hd__decap_3
XFILLER_17_511 VGND VGND VPWR VPWR sky130_fd_sc_hd__fill_1
XPHY_EDGE_ROW_66_Right_66 VGND VGND VPWR VPWR sky130_fd_sc_hd__decap_3
X_10916_ clknet_leaf_94_clk _00767_ VGND VGND VPWR VPWR picorv32_core.mem_rdata_q\[26\]
+ sky130_fd_sc_hd__dfxtp_1
XFILLER_17_577 VGND VGND VPWR VPWR sky130_fd_sc_hd__fill_1
XFILLER_32_503 VGND VGND VPWR VPWR sky130_fd_sc_hd__fill_2
XFILLER_44_363 VGND VGND VPWR VPWR sky130_fd_sc_hd__fill_1
XFILLER_32_558 VGND VGND VPWR VPWR sky130_fd_sc_hd__decap_8
X_10847_ clknet_leaf_35_clk _00698_ VGND VGND VPWR VPWR picorv32_core.cpuregs\[17\]\[24\]
+ sky130_fd_sc_hd__dfxtp_1
X_10778_ clknet_leaf_31_clk _00629_ VGND VGND VPWR VPWR picorv32_core.cpuregs\[14\]\[19\]
+ sky130_fd_sc_hd__dfxtp_1
XPHY_EDGE_ROW_4_Left_146 VGND VGND VPWR VPWR sky130_fd_sc_hd__decap_3
XFILLER_13_783 VGND VGND VPWR VPWR sky130_fd_sc_hd__fill_1
XTAP_TAPCELL_ROW_30_737 VGND VPWR sky130_fd_sc_hd__tapvpwrvgnd_1
XFILLER_118_619 VGND VGND VPWR VPWR sky130_fd_sc_hd__fill_1
XFILLER_9_765 VPWR VGND VPWR VGND sky130_ef_sc_hd__decap_12
XFILLER_8_253 VGND VGND VPWR VPWR sky130_fd_sc_hd__fill_1
XTAP_TAPCELL_ROW_10_450 VGND VPWR sky130_fd_sc_hd__tapvpwrvgnd_1
XFILLER_8_297 VGND VGND VPWR VPWR sky130_fd_sc_hd__fill_2
XFILLER_99_503 VGND VGND VPWR VPWR sky130_fd_sc_hd__fill_1
XPHY_EDGE_ROW_75_Right_75 VGND VGND VPWR VPWR sky130_fd_sc_hd__decap_3
XFILLER_113_313 VGND VGND VPWR VPWR sky130_fd_sc_hd__fill_2
XFILLER_5_42 VPWR VGND VPWR VGND sky130_ef_sc_hd__decap_12
XFILLER_140_121 VPWR VGND VPWR VGND sky130_ef_sc_hd__decap_12
XFILLER_141_699 VGND VGND VPWR VPWR sky130_fd_sc_hd__fill_1
XFILLER_140_165 VPWR VGND VPWR VGND sky130_ef_sc_hd__decap_12
XFILLER_113_379 VGND VGND VPWR VPWR sky130_fd_sc_hd__decap_3
X_06940_ _03141_ _03146_ _03154_ net677 VGND VGND VPWR VPWR _03156_ sky130_fd_sc_hd__o31a_1
X_06871_ picorv32_core.decoded_imm_j\[15\] _02927_ VGND VGND VPWR VPWR _03092_ sky130_fd_sc_hd__nand2_1
XFILLER_39_113 VGND VGND VPWR VPWR sky130_fd_sc_hd__decap_4
X_08610_ net226 net1941 net397 VGND VGND VPWR VPWR _00733_ sky130_fd_sc_hd__mux2_1
XFILLER_95_775 VGND VGND VPWR VPWR sky130_fd_sc_hd__fill_1
XFILLER_94_230 VGND VGND VPWR VPWR sky130_fd_sc_hd__decap_4
XFILLER_67_477 VGND VGND VPWR VPWR sky130_fd_sc_hd__fill_2
X_05822_ _02254_ _02300_ VGND VGND VPWR VPWR _02301_ sky130_fd_sc_hd__nor2_1
XFILLER_39_146 VGND VGND VPWR VPWR sky130_fd_sc_hd__fill_1
X_09590_ picorv32_core.cpuregs\[0\]\[18\] picorv32_core.cpuregs\[1\]\[18\] picorv32_core.cpuregs\[2\]\[18\]
+ picorv32_core.cpuregs\[3\]\[18\] net892 net858 VGND VGND VPWR VPWR _04771_ sky130_fd_sc_hd__mux4_1
XPHY_EDGE_ROW_84_Right_84 VGND VGND VPWR VPWR sky130_fd_sc_hd__decap_3
XFILLER_82_403 VGND VGND VPWR VPWR sky130_fd_sc_hd__decap_8
XFILLER_55_639 VGND VGND VPWR VPWR sky130_fd_sc_hd__fill_2
X_08541_ net1670 net226 net405 VGND VGND VPWR VPWR _00668_ sky130_fd_sc_hd__mux2_1
X_05753_ _02175_ _02229_ _02233_ _02180_ VGND VGND VPWR VPWR _02237_ sky130_fd_sc_hd__o22a_1
XTAP_TAPCELL_ROW_38_859 VGND VPWR sky130_fd_sc_hd__tapvpwrvgnd_1
X_05684_ _02166_ _02167_ _02165_ VGND VGND VPWR VPWR _02168_ sky130_fd_sc_hd__a21oi_1
XTAP_TAPCELL_ROW_18_561 VGND VPWR sky130_fd_sc_hd__tapvpwrvgnd_1
X_08472_ picorv32_core.mem_rdata_q\[22\] _04227_ VGND VGND VPWR VPWR _04318_ sky130_fd_sc_hd__and2_1
X_07423_ net868 _03560_ _03561_ _03562_ net661 VGND VGND VPWR VPWR _03563_ sky130_fd_sc_hd__o221a_1
XTAP_TAPCELL_ROW_18_572 VGND VPWR sky130_fd_sc_hd__tapvpwrvgnd_1
XFILLER_24_29 VGND VGND VPWR VPWR sky130_fd_sc_hd__decap_8
XTAP_TAPCELL_ROW_118_2017 VGND VPWR sky130_fd_sc_hd__tapvpwrvgnd_1
X_07354_ _03423_ _03492_ _03493_ VGND VGND VPWR VPWR _03494_ sky130_fd_sc_hd__and3b_1
XFILLER_50_377 VGND VGND VPWR VPWR sky130_fd_sc_hd__fill_1
XFILLER_136_416 VGND VGND VPWR VPWR sky130_fd_sc_hd__decap_4
X_07285_ net793 picorv32_core.decoded_imm\[14\] VGND VGND VPWR VPWR _03425_ sky130_fd_sc_hd__nand2_1
X_06305_ picorv32_core.reg_pc\[13\] picorv32_core.reg_pc\[12\] _02710_ VGND VGND VPWR
+ VPWR _02718_ sky130_fd_sc_hd__and3_1
XFILLER_136_449 VGND VGND VPWR VPWR sky130_fd_sc_hd__fill_1
XTAP_TAPCELL_ROW_131_2206 VGND VPWR sky130_fd_sc_hd__tapvpwrvgnd_1
XPHY_EDGE_ROW_93_Right_93 VGND VGND VPWR VPWR sky130_fd_sc_hd__decap_3
X_09024_ net466 net2097 net341 VGND VGND VPWR VPWR _01193_ sky130_fd_sc_hd__mux2_1
X_06236_ net437 _02663_ _00395_ VGND VGND VPWR VPWR _00030_ sky130_fd_sc_hd__a21o_1
Xhold220 picorv32_core.cpuregs\[22\]\[17\] VGND VGND VPWR VPWR net1329 sky130_fd_sc_hd__dlygate4sd3_1
Xhold253 picorv32_core.cpuregs\[31\]\[22\] VGND VGND VPWR VPWR net1362 sky130_fd_sc_hd__dlygate4sd3_1
Xhold231 picorv32_core.cpuregs\[30\]\[18\] VGND VGND VPWR VPWR net1340 sky130_fd_sc_hd__dlygate4sd3_1
Xhold242 picorv32_core.cpuregs\[26\]\[17\] VGND VGND VPWR VPWR net1351 sky130_fd_sc_hd__dlygate4sd3_1
X_06167_ picorv32_core.mem_rdata_q\[24\] net20 net518 VGND VGND VPWR VPWR _00765_
+ sky130_fd_sc_hd__mux2_1
XTAP_TAPCELL_ROW_113_1950 VGND VPWR sky130_fd_sc_hd__tapvpwrvgnd_1
X_06098_ _02543_ _02548_ _02554_ VGND VGND VPWR VPWR _02555_ sky130_fd_sc_hd__a21oi_1
Xhold286 net43 VGND VGND VPWR VPWR net1395 sky130_fd_sc_hd__dlygate4sd3_1
X_05118_ picorv32_core.instr_or picorv32_core.instr_ori VGND VGND VPWR VPWR _01649_
+ sky130_fd_sc_hd__or2_2
Xfanout700 net701 VGND VGND VPWR VPWR net700 sky130_fd_sc_hd__clkbuf_4
Xhold275 picorv32_core.cpuregs\[13\]\[4\] VGND VGND VPWR VPWR net1384 sky130_fd_sc_hd__dlygate4sd3_1
Xhold264 net138 VGND VGND VPWR VPWR net1373 sky130_fd_sc_hd__dlygate4sd3_1
X_09926_ net227 net1602 net323 VGND VGND VPWR VPWR _01410_ sky130_fd_sc_hd__mux2_1
Xfanout722 net724 VGND VGND VPWR VPWR net722 sky130_fd_sc_hd__clkbuf_4
XFILLER_104_357 VGND VGND VPWR VPWR sky130_fd_sc_hd__decap_4
Xhold297 picorv32_core.instr_sll VGND VGND VPWR VPWR net1406 sky130_fd_sc_hd__dlygate4sd3_1
Xfanout733 net734 VGND VGND VPWR VPWR net733 sky130_fd_sc_hd__buf_4
Xfanout711 net713 VGND VGND VPWR VPWR net711 sky130_fd_sc_hd__clkbuf_4
X_05049_ picorv32_core.reg_pc\[2\] VGND VGND VPWR VPWR _01584_ sky130_fd_sc_hd__inv_2
Xfanout755 net757 VGND VGND VPWR VPWR net755 sky130_fd_sc_hd__buf_4
Xfanout766 net767 VGND VGND VPWR VPWR net766 sky130_fd_sc_hd__buf_2
Xfanout744 net746 VGND VGND VPWR VPWR net744 sky130_fd_sc_hd__buf_4
XTAP_TAPCELL_ROW_129_2179 VGND VPWR sky130_fd_sc_hd__tapvpwrvgnd_1
X_09857_ net834 _05022_ _05025_ net481 VGND VGND VPWR VPWR _05026_ sky130_fd_sc_hd__o211a_1
XFILLER_100_563 VGND VGND VPWR VPWR sky130_fd_sc_hd__fill_1
Xfanout777 net778 VGND VGND VPWR VPWR net777 sky130_fd_sc_hd__clkbuf_2
Xfanout788 net149 VGND VGND VPWR VPWR net788 sky130_fd_sc_hd__buf_2
Xfanout799 net800 VGND VGND VPWR VPWR net799 sky130_fd_sc_hd__clkbuf_2
X_09788_ _04951_ _04952_ _04956_ _04957_ net658 net646 VGND VGND VPWR VPWR _04960_
+ sky130_fd_sc_hd__mux4_1
X_08808_ net246 net1852 net372 VGND VGND VPWR VPWR _00986_ sky130_fd_sc_hd__mux2_1
XFILLER_58_499 VGND VGND VPWR VPWR sky130_fd_sc_hd__decap_4
X_08739_ net1307 net255 net379 VGND VGND VPWR VPWR _00887_ sky130_fd_sc_hd__mux2_1
XFILLER_73_447 VGND VGND VPWR VPWR sky130_fd_sc_hd__fill_1
XFILLER_26_363 VGND VGND VPWR VPWR sky130_fd_sc_hd__fill_1
X_10701_ clknet_leaf_6_clk _00552_ VGND VGND VPWR VPWR net106 sky130_fd_sc_hd__dfxtp_1
XFILLER_54_694 VGND VGND VPWR VPWR sky130_fd_sc_hd__decap_6
XFILLER_26_385 VGND VGND VPWR VPWR sky130_fd_sc_hd__decap_3
X_11681_ clknet_leaf_62_clk _01512_ VGND VGND VPWR VPWR picorv32_core.cpuregs\[26\]\[30\]
+ sky130_fd_sc_hd__dfxtp_1
XFILLER_41_366 VGND VGND VPWR VPWR sky130_fd_sc_hd__fill_2
X_10632_ clknet_leaf_118_clk _00486_ VGND VGND VPWR VPWR picorv32_core.cpuregs\[20\]\[0\]
+ sky130_fd_sc_hd__dfxtp_1
X_10563_ clknet_leaf_21_clk _00417_ VGND VGND VPWR VPWR picorv32_core.cpuregs\[25\]\[19\]
+ sky130_fd_sc_hd__dfxtp_1
XFILLER_139_276 VGND VGND VPWR VPWR sky130_fd_sc_hd__decap_4
XFILLER_127_449 VGND VGND VPWR VPWR sky130_fd_sc_hd__fill_1
XFILLER_6_713 VPWR VGND VPWR VGND sky130_ef_sc_hd__decap_12
X_10494_ clknet_leaf_51_clk _00380_ VGND VGND VPWR VPWR net185 sky130_fd_sc_hd__dfxtp_1
XFILLER_6_757 VPWR VGND VPWR VGND sky130_ef_sc_hd__decap_12
XFILLER_5_245 VGND VGND VPWR VPWR sky130_fd_sc_hd__decap_4
XFILLER_5_223 VGND VGND VPWR VPWR sky130_fd_sc_hd__fill_1
XFILLER_107_140 VGND VGND VPWR VPWR sky130_fd_sc_hd__decap_6
XFILLER_5_289 VGND VGND VPWR VPWR sky130_fd_sc_hd__fill_1
XFILLER_30_83 VGND VGND VPWR VPWR sky130_fd_sc_hd__fill_1
XFILLER_68_219 VGND VGND VPWR VPWR sky130_fd_sc_hd__fill_2
X_11115_ clknet_leaf_110_clk _00966_ VGND VGND VPWR VPWR picorv32_core.cpuregs\[8\]\[1\]
+ sky130_fd_sc_hd__dfxtp_1
X_11046_ clknet_leaf_38_clk _00897_ VGND VGND VPWR VPWR picorv32_core.cpuregs\[11\]\[28\]
+ sky130_fd_sc_hd__dfxtp_1
XFILLER_77_720 VGND VGND VPWR VPWR sky130_fd_sc_hd__decap_8
XFILLER_49_433 VGND VGND VPWR VPWR sky130_fd_sc_hd__decap_4
XFILLER_37_617 VGND VGND VPWR VPWR sky130_fd_sc_hd__decap_6
XTAP_TAPCELL_ROW_86_1551 VGND VPWR sky130_fd_sc_hd__tapvpwrvgnd_1
XFILLER_51_108 VGND VGND VPWR VPWR sky130_fd_sc_hd__decap_4
XTAP_TAPCELL_ROW_35_807 VGND VPWR sky130_fd_sc_hd__tapvpwrvgnd_1
XTAP_TAPCELL_ROW_35_818 VGND VPWR sky130_fd_sc_hd__tapvpwrvgnd_1
XTAP_TAPCELL_ROW_15_520 VGND VPWR sky130_fd_sc_hd__tapvpwrvgnd_1
XFILLER_32_399 VGND VGND VPWR VPWR sky130_fd_sc_hd__decap_4
XFILLER_13_591 VGND VGND VPWR VPWR sky130_fd_sc_hd__fill_2
X_07070_ _03254_ _03257_ _03266_ _03274_ VGND VGND VPWR VPWR _03275_ sky130_fd_sc_hd__a31o_1
X_06021_ net955 _02469_ net670 VGND VGND VPWR VPWR _02484_ sky130_fd_sc_hd__o21a_1
XFILLER_126_471 VGND VGND VPWR VPWR sky130_fd_sc_hd__decap_4
XFILLER_114_611 VGND VGND VPWR VPWR sky130_fd_sc_hd__decap_8
XFILLER_87_517 VGND VGND VPWR VPWR sky130_fd_sc_hd__fill_1
X_07972_ _04048_ _04049_ net639 VGND VGND VPWR VPWR _04052_ sky130_fd_sc_hd__mux2_1
X_09711_ _03525_ _03527_ net611 VGND VGND VPWR VPWR _04886_ sky130_fd_sc_hd__o21ai_1
XFILLER_19_18 VPWR VGND VPWR VGND sky130_ef_sc_hd__decap_12
X_06923_ _03139_ _03140_ net989 VGND VGND VPWR VPWR _00247_ sky130_fd_sc_hd__o21a_1
X_09642_ net487 _04802_ _04803_ _04805_ _04820_ VGND VGND VPWR VPWR _04821_ sky130_fd_sc_hd__o41a_1
X_06854_ _02925_ _03062_ _01703_ VGND VGND VPWR VPWR _03077_ sky130_fd_sc_hd__o21ai_1
X_09573_ picorv32_core.reg_pc\[17\] net537 _04754_ net484 VGND VGND VPWR VPWR _04755_
+ sky130_fd_sc_hd__a211o_1
X_06785_ _02920_ _03007_ net663 VGND VGND VPWR VPWR _03013_ sky130_fd_sc_hd__o21ai_1
X_05805_ net969 net968 net967 net966 VGND VGND VPWR VPWR _02285_ sky130_fd_sc_hd__or4_2
X_05736_ net793 _02184_ net178 VGND VGND VPWR VPWR _02220_ sky130_fd_sc_hd__or3b_1
X_08524_ net1358 net300 net402 VGND VGND VPWR VPWR _00651_ sky130_fd_sc_hd__mux2_1
XFILLER_35_28 VGND VGND VPWR VPWR sky130_fd_sc_hd__decap_3
XFILLER_36_661 VGND VGND VPWR VPWR sky130_fd_sc_hd__fill_2
XTAP_TAPCELL_ROW_124_2098 VGND VPWR sky130_fd_sc_hd__tapvpwrvgnd_1
XPHY_EDGE_ROW_67_Left_209 VGND VGND VPWR VPWR sky130_fd_sc_hd__decap_3
X_05667_ _02149_ _02150_ VGND VGND VPWR VPWR _02151_ sky130_fd_sc_hd__nand2_1
X_08455_ picorv32_core.decoded_imm\[10\] net531 _04308_ VGND VGND VPWR VPWR _00600_
+ sky130_fd_sc_hd__o21a_1
X_07406_ picorv32_core.cpuregs\[8\]\[31\] picorv32_core.cpuregs\[9\]\[31\] net902
+ VGND VGND VPWR VPWR _03546_ sky130_fd_sc_hd__mux2_1
X_05598_ picorv32_core.count_instr\[60\] net938 net942 picorv32_core.count_instr\[28\]
+ VGND VGND VPWR VPWR _02086_ sky130_fd_sc_hd__a22o_1
X_08386_ net197 net586 net452 _04251_ VGND VGND VPWR VPWR _04268_ sky130_fd_sc_hd__a211o_1
XFILLER_109_405 VGND VGND VPWR VPWR sky130_fd_sc_hd__decap_4
X_07337_ _03447_ _03448_ VGND VGND VPWR VPWR _03477_ sky130_fd_sc_hd__nand2_1
XFILLER_136_213 VGND VGND VPWR VPWR sky130_fd_sc_hd__fill_1
XFILLER_109_416 VGND VGND VPWR VPWR sky130_fd_sc_hd__decap_8
XFILLER_136_246 VGND VGND VPWR VPWR sky130_fd_sc_hd__decap_6
X_07268_ net772 picorv32_core.decoded_imm\[25\] VGND VGND VPWR VPWR _03408_ sky130_fd_sc_hd__nor2_1
XFILLER_124_419 VGND VGND VPWR VPWR sky130_fd_sc_hd__fill_1
X_09007_ net247 net1659 net347 VGND VGND VPWR VPWR _01177_ sky130_fd_sc_hd__mux2_1
XPHY_EDGE_ROW_76_Left_218 VGND VGND VPWR VPWR sky130_fd_sc_hd__decap_3
X_07199_ net2347 _03354_ _03356_ VGND VGND VPWR VPWR _00307_ sky130_fd_sc_hd__o21a_1
XTAP_TAPCELL_ROW_57_1130 VGND VPWR sky130_fd_sc_hd__tapvpwrvgnd_1
X_06219_ _02647_ _02648_ net632 VGND VGND VPWR VPWR _02649_ sky130_fd_sc_hd__mux2_1
XTAP_TAPCELL_ROW_111_1909 VGND VPWR sky130_fd_sc_hd__tapvpwrvgnd_1
XFILLER_4_6 VPWR VGND VPWR VGND sky130_ef_sc_hd__decap_12
XFILLER_132_474 VGND VGND VPWR VPWR sky130_fd_sc_hd__fill_2
XFILLER_105_688 VGND VGND VPWR VPWR sky130_fd_sc_hd__decap_4
XFILLER_116_53 VGND VGND VPWR VPWR sky130_fd_sc_hd__decap_6
Xfanout530 net531 VGND VGND VPWR VPWR net530 sky130_fd_sc_hd__buf_1
Xfanout541 _03388_ VGND VGND VPWR VPWR net541 sky130_fd_sc_hd__clkbuf_4
Xfanout574 net575 VGND VGND VPWR VPWR net574 sky130_fd_sc_hd__buf_2
X_09909_ net298 net1680 net320 VGND VGND VPWR VPWR _01393_ sky130_fd_sc_hd__mux2_1
Xfanout563 net566 VGND VGND VPWR VPWR net563 sky130_fd_sc_hd__clkbuf_4
Xfanout552 _02913_ VGND VGND VPWR VPWR net552 sky130_fd_sc_hd__buf_2
XFILLER_86_572 VGND VGND VPWR VPWR sky130_fd_sc_hd__fill_2
Xfanout585 net586 VGND VGND VPWR VPWR net585 sky130_fd_sc_hd__buf_2
Xfanout596 net598 VGND VGND VPWR VPWR net596 sky130_fd_sc_hd__clkbuf_4
XFILLER_19_617 VGND VGND VPWR VPWR sky130_fd_sc_hd__decap_3
XFILLER_132_41 VPWR VGND VPWR VGND sky130_ef_sc_hd__decap_12
XFILLER_100_382 VPWR VGND VPWR VGND sky130_ef_sc_hd__decap_12
XFILLER_132_85 VPWR VGND VPWR VGND sky130_ef_sc_hd__decap_12
XPHY_EDGE_ROW_85_Left_227 VGND VGND VPWR VPWR sky130_fd_sc_hd__decap_3
XFILLER_73_277 VGND VGND VPWR VPWR sky130_fd_sc_hd__decap_3
XFILLER_73_266 VGND VGND VPWR VPWR sky130_fd_sc_hd__fill_2
XTAP_TAPCELL_ROW_68_1292 VGND VPWR sky130_fd_sc_hd__tapvpwrvgnd_1
XFILLER_61_439 VGND VGND VPWR VPWR sky130_fd_sc_hd__decap_8
X_11664_ clknet_leaf_10_clk _01495_ VGND VGND VPWR VPWR picorv32_core.cpuregs\[26\]\[13\]
+ sky130_fd_sc_hd__dfxtp_1
XFILLER_42_697 VGND VGND VPWR VPWR sky130_fd_sc_hd__decap_3
XTAP_TAPCELL_ROW_81_1481 VGND VPWR sky130_fd_sc_hd__tapvpwrvgnd_1
X_10615_ clknet_leaf_96_clk _00469_ VGND VGND VPWR VPWR picorv32_core.instr_rdcycle
+ sky130_fd_sc_hd__dfxtp_1
XFILLER_128_736 VPWR VGND VPWR VGND sky130_ef_sc_hd__decap_12
XTAP_TAPCELL_ROW_40_887 VGND VPWR sky130_fd_sc_hd__tapvpwrvgnd_1
X_11595_ clknet_leaf_12_clk _01426_ VGND VGND VPWR VPWR picorv32_core.cpuregs\[23\]\[8\]
+ sky130_fd_sc_hd__dfxtp_1
XFILLER_128_769 VPWR VGND VPWR VGND sky130_ef_sc_hd__decap_12
XPHY_EDGE_ROW_94_Left_236 VGND VGND VPWR VPWR sky130_fd_sc_hd__decap_3
X_10546_ clknet_leaf_131_clk _00400_ VGND VGND VPWR VPWR picorv32_core.cpuregs\[25\]\[2\]
+ sky130_fd_sc_hd__dfxtp_1
XFILLER_127_279 VGND VGND VPWR VPWR sky130_fd_sc_hd__fill_1
X_10477_ clknet_leaf_132_clk _00363_ VGND VGND VPWR VPWR picorv32_core.mem_la_wdata\[3\]
+ sky130_fd_sc_hd__dfxtp_1
XFILLER_44_7 VPWR VGND VPWR VGND sky130_ef_sc_hd__decap_12
XFILLER_2_793 VPWR VGND VPWR VGND sky130_ef_sc_hd__decap_12
XFILLER_96_358 VGND VGND VPWR VPWR sky130_fd_sc_hd__decap_6
XFILLER_77_550 VGND VGND VPWR VPWR sky130_fd_sc_hd__decap_3
XFILLER_1_281 VGND VGND VPWR VPWR sky130_fd_sc_hd__decap_3
XFILLER_2_65 VPWR VGND VPWR VGND sky130_ef_sc_hd__decap_12
X_11029_ clknet_leaf_2_clk _00880_ VGND VGND VPWR VPWR picorv32_core.cpuregs\[11\]\[11\]
+ sky130_fd_sc_hd__dfxtp_1
XFILLER_92_542 VPWR VGND VPWR VGND sky130_ef_sc_hd__decap_12
XFILLER_64_233 VGND VGND VPWR VPWR sky130_fd_sc_hd__decap_3
XFILLER_52_406 VPWR VGND VPWR VGND sky130_ef_sc_hd__decap_12
X_06570_ picorv32_core.count_instr\[37\] picorv32_core.count_instr\[36\] _02859_ VGND
+ VGND VPWR VPWR _02863_ sky130_fd_sc_hd__and3_1
XTAP_TAPCELL_ROW_48_998 VGND VPWR sky130_fd_sc_hd__tapvpwrvgnd_1
X_05521_ net579 _02013_ _02014_ net778 net916 VGND VGND VPWR VPWR _02015_ sky130_fd_sc_hd__a32o_1
XFILLER_32_141 VGND VGND VPWR VPWR sky130_fd_sc_hd__fill_1
X_05452_ picorv32_core.count_instr\[49\] net938 net942 picorv32_core.count_instr\[17\]
+ VGND VGND VPWR VPWR _01951_ sky130_fd_sc_hd__a22o_1
X_08240_ _04223_ VGND VGND VPWR VPWR _04224_ sky130_fd_sc_hd__inv_2
XANTENNA_26 _04351_ VGND VGND VPWR VPWR sky130_fd_sc_hd__diode_2
XANTENNA_15 _03702_ VGND VGND VPWR VPWR sky130_fd_sc_hd__diode_2
X_08171_ net930 net7 net520 VGND VGND VPWR VPWR _00753_ sky130_fd_sc_hd__mux2_1
XANTENNA_37 picorv32_core.mem_la_wdata\[4\] VGND VGND VPWR VPWR sky130_fd_sc_hd__diode_2
XANTENNA_48 net321 VGND VGND VPWR VPWR sky130_fd_sc_hd__diode_2
XANTENNA_59 net481 VGND VGND VPWR VPWR sky130_fd_sc_hd__diode_2
XTAP_TAPCELL_ROW_99_1742 VGND VPWR sky130_fd_sc_hd__tapvpwrvgnd_1
X_07122_ _03308_ net993 _03307_ VGND VGND VPWR VPWR _00278_ sky130_fd_sc_hd__and3b_1
X_05383_ _01855_ _01859_ _01860_ VGND VGND VPWR VPWR _01887_ sky130_fd_sc_hd__o21a_1
X_07053_ _02941_ _03248_ VGND VGND VPWR VPWR _03260_ sky130_fd_sc_hd__xor2_1
Xoutput100 net100 VGND VGND VPWR VPWR mem_axi_awaddr[9] sky130_fd_sc_hd__buf_2
XFILLER_114_430 VGND VGND VPWR VPWR sky130_fd_sc_hd__fill_1
Xoutput111 net111 VGND VGND VPWR VPWR mem_axi_wdata[16] sky130_fd_sc_hd__buf_2
X_06004_ net507 _02465_ _02466_ _02468_ VGND VGND VPWR VPWR picorv32_core.alu_out\[19\]
+ sky130_fd_sc_hd__a31o_1
Xoutput122 net122 VGND VGND VPWR VPWR mem_axi_wdata[26] sky130_fd_sc_hd__buf_2
Xoutput133 net133 VGND VGND VPWR VPWR mem_axi_wdata[7] sky130_fd_sc_hd__buf_2
Xoutput155 net778 VGND VGND VPWR VPWR pcpi_rs1[22] sky130_fd_sc_hd__buf_2
Xoutput144 net798 VGND VGND VPWR VPWR pcpi_rs1[12] sky130_fd_sc_hd__buf_2
Xoutput177 net177 VGND VGND VPWR VPWR pcpi_rs2[13] sky130_fd_sc_hd__buf_2
Xoutput166 net816 VGND VGND VPWR VPWR pcpi_rs1[3] sky130_fd_sc_hd__buf_2
Xoutput188 net188 VGND VGND VPWR VPWR pcpi_rs2[23] sky130_fd_sc_hd__buf_2
XFILLER_102_636 VGND VGND VPWR VPWR sky130_fd_sc_hd__decap_8
XFILLER_101_113 VGND VGND VPWR VPWR sky130_fd_sc_hd__fill_2
XFILLER_87_314 VGND VGND VPWR VPWR sky130_fd_sc_hd__decap_4
Xoutput199 net199 VGND VGND VPWR VPWR pcpi_rs2[4] sky130_fd_sc_hd__buf_2
XFILLER_141_293 VGND VGND VPWR VPWR sky130_fd_sc_hd__decap_3
X_07955_ net695 _04028_ net684 VGND VGND VPWR VPWR _04036_ sky130_fd_sc_hd__o21a_1
XTAP_TAPCELL_ROW_52_1060 VGND VPWR sky130_fd_sc_hd__tapvpwrvgnd_1
XTAP_TAPCELL_ROW_126_2138 VGND VPWR sky130_fd_sc_hd__tapvpwrvgnd_1
XTAP_TAPCELL_ROW_126_2127 VGND VPWR sky130_fd_sc_hd__tapvpwrvgnd_1
X_06906_ _02929_ _03111_ VGND VGND VPWR VPWR _03125_ sky130_fd_sc_hd__nand2_1
X_07886_ net696 _03967_ _03966_ net620 VGND VGND VPWR VPWR _03971_ sky130_fd_sc_hd__o211a_1
X_09625_ net773 net547 VGND VGND VPWR VPWR _04804_ sky130_fd_sc_hd__or2_1
X_06837_ _03059_ _03060_ VGND VGND VPWR VPWR _03061_ sky130_fd_sc_hd__xor2_1
XFILLER_28_469 VGND VGND VPWR VPWR sky130_fd_sc_hd__fill_1
XTAP_TAPCELL_ROW_108_1871 VGND VPWR sky130_fd_sc_hd__tapvpwrvgnd_1
XFILLER_102_55 VGND VGND VPWR VPWR sky130_fd_sc_hd__fill_1
X_09556_ net779 net547 VGND VGND VPWR VPWR _04738_ sky130_fd_sc_hd__or2_1
XFILLER_43_439 VGND VGND VPWR VPWR sky130_fd_sc_hd__fill_1
X_06768_ net588 _02996_ _02997_ VGND VGND VPWR VPWR _02998_ sky130_fd_sc_hd__a21o_1
X_08507_ net1517 net224 net409 VGND VGND VPWR VPWR _00637_ sky130_fd_sc_hd__mux2_1
X_06699_ _02774_ picorv32_core.reg_next_pc\[27\] net559 VGND VGND VPWR VPWR _02939_
+ sky130_fd_sc_hd__mux2_2
X_09487_ net795 _04672_ net283 VGND VGND VPWR VPWR _01332_ sky130_fd_sc_hd__mux2_1
X_05719_ _02141_ _02181_ _02202_ VGND VGND VPWR VPWR _02203_ sky130_fd_sc_hd__or3b_4
XFILLER_23_130 VGND VGND VPWR VPWR sky130_fd_sc_hd__fill_1
X_08438_ picorv32_core.decoded_imm\[18\] net529 _04284_ _04299_ VGND VGND VPWR VPWR
+ _00592_ sky130_fd_sc_hd__o22a_1
X_08369_ net1191 _04259_ net455 VGND VGND VPWR VPWR _00563_ sky130_fd_sc_hd__mux2_1
XFILLER_11_369 VGND VGND VPWR VPWR sky130_fd_sc_hd__fill_1
XTAP_TAPCELL_ROW_137_2289 VGND VPWR sky130_fd_sc_hd__tapvpwrvgnd_1
X_10400_ clknet_leaf_77_clk _00319_ VGND VGND VPWR VPWR picorv32_core.count_cycle\[58\]
+ sky130_fd_sc_hd__dfxtp_1
X_11380_ clknet_leaf_83_clk _00025_ VGND VGND VPWR VPWR _00005_ sky130_fd_sc_hd__dfxtp_1
X_10331_ clknet_leaf_87_clk _00250_ VGND VGND VPWR VPWR picorv32_core.reg_next_pc\[21\]
+ sky130_fd_sc_hd__dfxtp_1
XFILLER_11_30 VPWR VGND VPWR VGND sky130_ef_sc_hd__decap_12
X_10262_ clknet_leaf_81_clk _00181_ VGND VGND VPWR VPWR picorv32_core.count_instr\[46\]
+ sky130_fd_sc_hd__dfxtp_1
XFILLER_117_290 VGND VGND VPWR VPWR sky130_fd_sc_hd__fill_2
XFILLER_79_804 VGND VGND VPWR VPWR sky130_fd_sc_hd__decap_6
XFILLER_3_579 VGND VGND VPWR VPWR sky130_fd_sc_hd__decap_8
XFILLER_133_783 VGND VGND VPWR VPWR sky130_fd_sc_hd__fill_1
XFILLER_105_474 VGND VGND VPWR VPWR sky130_fd_sc_hd__fill_1
X_10193_ clknet_leaf_1_clk _00112_ VGND VGND VPWR VPWR picorv32_core.cpuregs\[9\]\[9\]
+ sky130_fd_sc_hd__dfxtp_1
XFILLER_120_477 VGND VGND VPWR VPWR sky130_fd_sc_hd__fill_1
XFILLER_93_317 VGND VGND VPWR VPWR sky130_fd_sc_hd__decap_3
Xfanout360 net361 VGND VGND VPWR VPWR net360 sky130_fd_sc_hd__clkbuf_8
Xfanout393 _04334_ VGND VGND VPWR VPWR net393 sky130_fd_sc_hd__buf_4
XTAP_TAPCELL_ROW_6_395 VGND VPWR sky130_fd_sc_hd__tapvpwrvgnd_1
Xfanout371 _04339_ VGND VGND VPWR VPWR net371 sky130_fd_sc_hd__clkbuf_4
Xfanout382 net383 VGND VGND VPWR VPWR net382 sky130_fd_sc_hd__buf_4
XFILLER_74_531 VGND VGND VPWR VPWR sky130_fd_sc_hd__fill_1
XTAP_TAPCELL_ROW_83_1510 VGND VPWR sky130_fd_sc_hd__tapvpwrvgnd_1
XFILLER_36_71 VGND VGND VPWR VPWR sky130_fd_sc_hd__fill_2
XFILLER_36_82 VGND VGND VPWR VPWR sky130_fd_sc_hd__fill_2
XTAP_TAPCELL_ROW_45_957 VGND VPWR sky130_fd_sc_hd__tapvpwrvgnd_1
XTAP_TAPCELL_ROW_25_670 VGND VPWR sky130_fd_sc_hd__tapvpwrvgnd_1
X_11647_ clknet_leaf_42_clk _01478_ VGND VGND VPWR VPWR picorv32_core.cpuregs\[28\]\[28\]
+ sky130_fd_sc_hd__dfxtp_1
Xinput13 mem_axi_rdata[18] VGND VGND VPWR VPWR net13 sky130_fd_sc_hd__clkbuf_2
X_11578_ clknet_leaf_71_clk _01409_ VGND VGND VPWR VPWR picorv32_core.cpuregs\[2\]\[25\]
+ sky130_fd_sc_hd__dfxtp_1
XFILLER_128_533 VGND VGND VPWR VPWR sky130_fd_sc_hd__fill_1
Xinput24 mem_axi_rdata[28] VGND VGND VPWR VPWR net24 sky130_fd_sc_hd__buf_1
Xinput35 mem_axi_rdata[9] VGND VGND VPWR VPWR net35 sky130_fd_sc_hd__dlymetal6s2s_1
Xhold819 picorv32_core.cpuregs\[7\]\[19\] VGND VGND VPWR VPWR net1928 sky130_fd_sc_hd__dlygate4sd3_1
X_10529_ clknet_leaf_89_clk picorv32_core.alu_out\[17\] VGND VGND VPWR VPWR picorv32_core.alu_out_q\[17\]
+ sky130_fd_sc_hd__dfxtp_1
XFILLER_6_362 VGND VGND VPWR VPWR sky130_fd_sc_hd__fill_2
XFILLER_6_340 VGND VGND VPWR VPWR sky130_fd_sc_hd__fill_1
Xhold808 picorv32_core.cpuregs\[4\]\[0\] VGND VGND VPWR VPWR net1917 sky130_fd_sc_hd__dlygate4sd3_1
XFILLER_124_750 VGND VGND VPWR VPWR sky130_fd_sc_hd__decap_6
XTAP_TAPCELL_ROW_94_1672 VGND VPWR sky130_fd_sc_hd__tapvpwrvgnd_1
XTAP_TAPCELL_ROW_94_1661 VGND VPWR sky130_fd_sc_hd__tapvpwrvgnd_1
XFILLER_35_3 VPWR VGND VPWR VGND sky130_ef_sc_hd__decap_12
XFILLER_111_455 VGND VGND VPWR VPWR sky130_fd_sc_hd__decap_3
X_07740_ _03822_ _03823_ net629 VGND VGND VPWR VPWR _03833_ sky130_fd_sc_hd__mux2_1
X_07671_ net960 net513 _03766_ _03767_ VGND VGND VPWR VPWR _00368_ sky130_fd_sc_hd__o22a_1
X_06622_ picorv32_core.count_instr\[56\] _02894_ VGND VGND VPWR VPWR _02896_ sky130_fd_sc_hd__and2_1
XFILLER_53_748 VPWR VGND VPWR VGND sky130_ef_sc_hd__decap_12
X_09410_ picorv32_core.cpuregs\[0\]\[10\] picorv32_core.cpuregs\[1\]\[10\] picorv32_core.cpuregs\[2\]\[10\]
+ picorv32_core.cpuregs\[3\]\[10\] net878 net845 VGND VGND VPWR VPWR _04599_ sky130_fd_sc_hd__mux4_1
XTAP_TAPCELL_ROW_121_2057 VGND VPWR sky130_fd_sc_hd__tapvpwrvgnd_1
X_06553_ picorv32_core.count_instr\[30\] _02849_ picorv32_core.count_instr\[31\] VGND
+ VGND VPWR VPWR _02852_ sky130_fd_sc_hd__a21o_1
XFILLER_18_491 VGND VGND VPWR VPWR sky130_fd_sc_hd__fill_2
X_09341_ picorv32_core.cpuregs\[16\]\[7\] picorv32_core.cpuregs\[17\]\[7\] picorv32_core.cpuregs\[18\]\[7\]
+ picorv32_core.cpuregs\[19\]\[7\] net877 net844 VGND VGND VPWR VPWR _04533_ sky130_fd_sc_hd__mux4_1
XFILLER_40_409 VGND VGND VPWR VPWR sky130_fd_sc_hd__decap_8
X_05504_ net17 net583 net574 VGND VGND VPWR VPWR _01999_ sky130_fd_sc_hd__a21o_1
XFILLER_52_269 VGND VGND VPWR VPWR sky130_fd_sc_hd__fill_2
XFILLER_139_809 VPWR VGND VPWR VGND sky130_ef_sc_hd__decap_12
X_06484_ picorv32_core.count_instr\[5\] _02805_ picorv32_core.count_instr\[6\] VGND
+ VGND VPWR VPWR _02808_ sky130_fd_sc_hd__a21o_1
X_09272_ net827 _04466_ VGND VGND VPWR VPWR _04467_ sky130_fd_sc_hd__or2_1
X_05435_ _01932_ _01933_ _01580_ VGND VGND VPWR VPWR _01935_ sky130_fd_sc_hd__a21o_1
X_08223_ picorv32_core.instr_srai net523 _04198_ _04210_ VGND VGND VPWR VPWR _00468_
+ sky130_fd_sc_hd__a22o_1
X_05366_ net915 net800 _01867_ net909 _01870_ VGND VGND VPWR VPWR _01871_ sky130_fd_sc_hd__a221o_1
X_08154_ net527 _04180_ VGND VGND VPWR VPWR _04181_ sky130_fd_sc_hd__and2_1
X_08085_ _04153_ _04154_ net640 VGND VGND VPWR VPWR _04159_ sky130_fd_sc_hd__mux2_1
X_07105_ picorv32_core.count_cycle\[10\] picorv32_core.count_cycle\[11\] _03294_ VGND
+ VGND VPWR VPWR _03298_ sky130_fd_sc_hd__and3_1
X_07036_ _03243_ VGND VGND VPWR VPWR _03244_ sky130_fd_sc_hd__inv_2
X_05297_ _01804_ _01805_ VGND VGND VPWR VPWR _01806_ sky130_fd_sc_hd__or2_1
XFILLER_88_601 VGND VGND VPWR VPWR sky130_fd_sc_hd__decap_6
XFILLER_115_783 VGND VGND VPWR VPWR sky130_fd_sc_hd__fill_1
XFILLER_87_100 VGND VGND VPWR VPWR sky130_fd_sc_hd__decap_3
Xclkbuf_4_5_0_clk clknet_0_clk VGND VGND VPWR VPWR clknet_4_5_0_clk sky130_fd_sc_hd__clkbuf_8
X_08987_ net502 net1730 net344 VGND VGND VPWR VPWR _01157_ sky130_fd_sc_hd__mux2_1
XFILLER_29_701 VGND VGND VPWR VPWR sky130_fd_sc_hd__fill_2
X_07938_ _04018_ _04019_ net638 VGND VGND VPWR VPWR _04020_ sky130_fd_sc_hd__mux2_1
XFILLER_56_531 VGND VGND VPWR VPWR sky130_fd_sc_hd__fill_1
XFILLER_56_520 VGND VGND VPWR VPWR sky130_fd_sc_hd__fill_1
XTAP_TAPCELL_ROW_3_354 VGND VPWR sky130_fd_sc_hd__tapvpwrvgnd_1
XTAP_TAPCELL_ROW_3_343 VGND VPWR sky130_fd_sc_hd__tapvpwrvgnd_1
X_07869_ net685 _03953_ net625 VGND VGND VPWR VPWR _03955_ sky130_fd_sc_hd__a21o_1
XFILLER_29_778 VGND VGND VPWR VPWR sky130_fd_sc_hd__decap_6
X_10880_ clknet_leaf_33_clk _00731_ VGND VGND VPWR VPWR picorv32_core.cpuregs\[16\]\[24\]
+ sky130_fd_sc_hd__dfxtp_1
X_09608_ picorv32_core.cpuregs\[20\]\[19\] picorv32_core.cpuregs\[21\]\[19\] picorv32_core.cpuregs\[22\]\[19\]
+ picorv32_core.cpuregs\[23\]\[19\] net890 net856 VGND VGND VPWR VPWR _04788_ sky130_fd_sc_hd__mux4_1
XFILLER_71_534 VGND VGND VPWR VPWR sky130_fd_sc_hd__decap_8
XFILLER_43_225 VGND VGND VPWR VPWR sky130_fd_sc_hd__decap_4
X_09539_ picorv32_core.cpuregs\[28\]\[16\] picorv32_core.cpuregs\[29\]\[16\] picorv32_core.cpuregs\[30\]\[16\]
+ picorv32_core.cpuregs\[31\]\[16\] net893 net859 VGND VGND VPWR VPWR _04722_ sky130_fd_sc_hd__mux4_1
XTAP_TAPCELL_ROW_139_2318 VGND VPWR sky130_fd_sc_hd__tapvpwrvgnd_1
XTAP_TAPCELL_ROW_65_1251 VGND VPWR sky130_fd_sc_hd__tapvpwrvgnd_1
XTAP_TAPCELL_ROW_42_916 VGND VPWR sky130_fd_sc_hd__tapvpwrvgnd_1
XFILLER_129_319 VGND VGND VPWR VPWR sky130_fd_sc_hd__fill_1
X_11501_ clknet_leaf_55_clk _01337_ VGND VGND VPWR VPWR net150 sky130_fd_sc_hd__dfxtp_1
X_11432_ clknet_leaf_17_clk _01268_ VGND VGND VPWR VPWR picorv32_core.cpuregs\[1\]\[15\]
+ sky130_fd_sc_hd__dfxtp_1
XFILLER_7_137 VPWR VGND VPWR VGND sky130_ef_sc_hd__decap_12
XFILLER_4_811 VGND VGND VPWR VPWR sky130_fd_sc_hd__fill_1
X_11363_ clknet_leaf_19_clk _01204_ VGND VGND VPWR VPWR picorv32_core.cpuregs\[18\]\[15\]
+ sky130_fd_sc_hd__dfxtp_1
XFILLER_4_833 VGND VGND VPWR VPWR sky130_fd_sc_hd__fill_1
XFILLER_106_761 VGND VGND VPWR VPWR sky130_fd_sc_hd__fill_1
XFILLER_98_77 VGND VGND VPWR VPWR sky130_fd_sc_hd__decap_6
X_11294_ clknet_leaf_27_clk _01142_ VGND VGND VPWR VPWR picorv32_core.cpuregs\[3\]\[17\]
+ sky130_fd_sc_hd__dfxtp_1
X_10314_ clknet_leaf_122_clk _00233_ VGND VGND VPWR VPWR picorv32_core.reg_next_pc\[4\]
+ sky130_fd_sc_hd__dfxtp_1
XFILLER_106_772 VGND VGND VPWR VPWR sky130_fd_sc_hd__fill_1
X_10245_ clknet_leaf_78_clk _00164_ VGND VGND VPWR VPWR picorv32_core.count_instr\[29\]
+ sky130_fd_sc_hd__dfxtp_1
XFILLER_121_753 VPWR VGND VPWR VGND sky130_ef_sc_hd__decap_12
X_10176_ clknet_leaf_33_clk _00095_ VGND VGND VPWR VPWR picorv32_core.cpuregs\[21\]\[24\]
+ sky130_fd_sc_hd__dfxtp_1
XFILLER_121_797 VPWR VGND VPWR VGND sky130_ef_sc_hd__decap_12
XFILLER_19_255 VGND VGND VPWR VPWR sky130_fd_sc_hd__fill_2
XFILLER_62_523 VGND VGND VPWR VPWR sky130_fd_sc_hd__decap_8
XFILLER_62_545 VPWR VGND VPWR VGND sky130_ef_sc_hd__decap_12
XTAP_TAPCELL_ROW_96_1701 VGND VPWR sky130_fd_sc_hd__tapvpwrvgnd_1
XFILLER_8_53 VPWR VGND VPWR VGND sky130_ef_sc_hd__decap_12
X_05220_ picorv32_core.count_cycle\[1\] net599 VGND VGND VPWR VPWR _01735_ sky130_fd_sc_hd__or2_1
XFILLER_8_97 VPWR VGND VPWR VGND sky130_ef_sc_hd__decap_12
X_05151_ net908 _01676_ _01677_ _01678_ VGND VGND VPWR VPWR _00016_ sky130_fd_sc_hd__a22o_1
Xhold616 picorv32_core.cpuregs\[7\]\[27\] VGND VGND VPWR VPWR net1725 sky130_fd_sc_hd__dlygate4sd3_1
Xhold605 picorv32_core.cpuregs\[9\]\[24\] VGND VGND VPWR VPWR net1714 sky130_fd_sc_hd__dlygate4sd3_1
Xhold627 picorv32_core.cpuregs\[13\]\[11\] VGND VGND VPWR VPWR net1736 sky130_fd_sc_hd__dlygate4sd3_1
Xhold638 picorv32_core.instr_blt VGND VGND VPWR VPWR net1747 sky130_fd_sc_hd__dlygate4sd3_1
X_05082_ net830 VGND VGND VPWR VPWR _01617_ sky130_fd_sc_hd__inv_2
Xhold649 picorv32_core.cpuregs\[5\]\[8\] VGND VGND VPWR VPWR net1758 sky130_fd_sc_hd__dlygate4sd3_1
X_08910_ net238 net1494 net360 VGND VGND VPWR VPWR _01084_ sky130_fd_sc_hd__mux2_1
X_09890_ net2082 net219 net326 VGND VGND VPWR VPWR _01378_ sky130_fd_sc_hd__mux2_1
X_08841_ net1259 net248 net367 VGND VGND VPWR VPWR _01017_ sky130_fd_sc_hd__mux2_1
XFILLER_97_475 VGND VGND VPWR VPWR sky130_fd_sc_hd__fill_2
XFILLER_85_615 VGND VGND VPWR VPWR sky130_fd_sc_hd__fill_1
XFILLER_97_497 VGND VGND VPWR VPWR sky130_fd_sc_hd__fill_2
X_08772_ net255 net2159 net375 VGND VGND VPWR VPWR _00919_ sky130_fd_sc_hd__mux2_1
XFILLER_85_648 VGND VGND VPWR VPWR sky130_fd_sc_hd__decap_4
X_05984_ net785 _02449_ VGND VGND VPWR VPWR _02450_ sky130_fd_sc_hd__nand2_1
XFILLER_69_199 VGND VGND VPWR VPWR sky130_fd_sc_hd__decap_4
XFILLER_38_531 VGND VGND VPWR VPWR sky130_fd_sc_hd__fill_1
XFILLER_72_309 VGND VGND VPWR VPWR sky130_fd_sc_hd__decap_3
X_07723_ _03806_ _03807_ net629 VGND VGND VPWR VPWR _03817_ sky130_fd_sc_hd__mux2_1
XTAP_TAPCELL_ROW_0_302 VGND VPWR sky130_fd_sc_hd__tapvpwrvgnd_1
X_07654_ picorv32_core.cpuregs\[28\]\[8\] picorv32_core.cpuregs\[29\]\[8\] picorv32_core.cpuregs\[30\]\[8\]
+ picorv32_core.cpuregs\[31\]\[8\] net739 net706 VGND VGND VPWR VPWR _03751_ sky130_fd_sc_hd__mux4_1
XTAP_TAPCELL_ROW_105_1830 VGND VPWR sky130_fd_sc_hd__tapvpwrvgnd_1
X_06605_ picorv32_core.count_instr\[50\] picorv32_core.count_instr\[49\] VGND VGND
+ VPWR VPWR _02885_ sky130_fd_sc_hd__and2_1
XFILLER_25_247 VGND VGND VPWR VPWR sky130_fd_sc_hd__fill_2
X_07585_ _02611_ _03680_ _03688_ VGND VGND VPWR VPWR _03689_ sky130_fd_sc_hd__or3_1
X_06536_ net2351 _02839_ _02841_ VGND VGND VPWR VPWR _00159_ sky130_fd_sc_hd__o21a_1
X_09324_ _04508_ _04509_ _04513_ _04514_ net652 net642 VGND VGND VPWR VPWR _04517_
+ sky130_fd_sc_hd__mux4_1
X_06467_ net212 net1985 net420 VGND VGND VPWR VPWR _00133_ sky130_fd_sc_hd__mux2_1
X_09255_ picorv32_core.reg_pc\[3\] net485 net536 _04449_ _04450_ VGND VGND VPWR VPWR
+ _04451_ sky130_fd_sc_hd__a32o_1
X_05418_ net926 _01811_ net585 VGND VGND VPWR VPWR _01919_ sky130_fd_sc_hd__a21o_1
XTAP_TAPCELL_ROW_60_1170 VGND VPWR sky130_fd_sc_hd__tapvpwrvgnd_1
X_08206_ net948 _04205_ _04206_ net1179 VGND VGND VPWR VPWR _00455_ sky130_fd_sc_hd__a22o_1
Xpicorv32_axi_1026 VGND VGND VPWR VPWR picorv32_axi_1026/HI eoi[27] sky130_fd_sc_hd__conb_1
XTAP_TAPCELL_ROW_134_2248 VGND VPWR sky130_fd_sc_hd__tapvpwrvgnd_1
X_06398_ picorv32_core.reg_pc\[31\] _02789_ VGND VGND VPWR VPWR _02793_ sky130_fd_sc_hd__xnor2_1
XTAP_TAPCELL_ROW_60_1181 VGND VPWR sky130_fd_sc_hd__tapvpwrvgnd_1
X_09186_ picorv32_core.cpuregs\[14\]\[1\] picorv32_core.cpuregs\[15\]\[1\] net886
+ VGND VGND VPWR VPWR _04384_ sky130_fd_sc_hd__mux2_1
Xpicorv32_axi_1037 VGND VGND VPWR VPWR picorv32_axi_1037/HI mem_axi_awprot[0] sky130_fd_sc_hd__conb_1
Xpicorv32_axi_1004 VGND VGND VPWR VPWR picorv32_axi_1004/HI eoi[5] sky130_fd_sc_hd__conb_1
Xpicorv32_axi_1015 VGND VGND VPWR VPWR picorv32_axi_1015/HI eoi[16] sky130_fd_sc_hd__conb_1
X_08137_ net2315 net4 net521 VGND VGND VPWR VPWR _00741_ sky130_fd_sc_hd__mux2_1
X_05349_ picorv32_core.reg_pc\[10\] picorv32_core.decoded_imm\[10\] VGND VGND VPWR
+ VPWR _01855_ sky130_fd_sc_hd__nand2_1
Xpicorv32_axi_1048 VGND VGND VPWR VPWR picorv32_axi_1048/HI pcpi_insn[8] sky130_fd_sc_hd__conb_1
Xpicorv32_axi_1059 VGND VGND VPWR VPWR picorv32_axi_1059/HI pcpi_insn[19] sky130_fd_sc_hd__conb_1
X_08068_ _04141_ _04142_ net459 _04139_ VGND VGND VPWR VPWR _04143_ sky130_fd_sc_hd__o211a_1
XTAP_TAPCELL_ROW_116_1992 VGND VPWR sky130_fd_sc_hd__tapvpwrvgnd_1
XTAP_TAPCELL_ROW_116_1981 VGND VPWR sky130_fd_sc_hd__tapvpwrvgnd_1
X_07019_ net666 picorv32_core.reg_next_pc\[26\] _02938_ net489 VGND VGND VPWR VPWR
+ _03229_ sky130_fd_sc_hd__a22o_1
XTAP_TAPCELL_ROW_8_424 VGND VPWR sky130_fd_sc_hd__tapvpwrvgnd_1
X_10030_ net1240 net235 net310 VGND VGND VPWR VPWR _01506_ sky130_fd_sc_hd__mux2_1
XFILLER_103_775 VGND VGND VPWR VPWR sky130_fd_sc_hd__fill_2
XFILLER_124_53 VGND VGND VPWR VPWR sky130_fd_sc_hd__decap_8
XFILLER_48_339 VGND VGND VPWR VPWR sky130_fd_sc_hd__fill_2
XFILLER_91_607 VGND VGND VPWR VPWR sky130_fd_sc_hd__fill_1
XFILLER_75_169 VGND VGND VPWR VPWR sky130_fd_sc_hd__decap_3
XFILLER_84_692 VGND VGND VPWR VPWR sky130_fd_sc_hd__decap_8
X_10932_ clknet_leaf_3_clk _00783_ VGND VGND VPWR VPWR picorv32_core.cpuregs\[19\]\[10\]
+ sky130_fd_sc_hd__dfxtp_1
XFILLER_44_512 VGND VGND VPWR VPWR sky130_fd_sc_hd__decap_3
XFILLER_140_41 VPWR VGND VPWR VGND sky130_ef_sc_hd__decap_12
XFILLER_140_85 VPWR VGND VPWR VGND sky130_ef_sc_hd__decap_12
X_10863_ clknet_leaf_129_clk _00714_ VGND VGND VPWR VPWR picorv32_core.cpuregs\[16\]\[7\]
+ sky130_fd_sc_hd__dfxtp_1
XFILLER_44_567 VGND VGND VPWR VPWR sky130_fd_sc_hd__decap_8
XFILLER_44_589 VPWR VGND VPWR VGND sky130_ef_sc_hd__decap_12
X_10794_ clknet_leaf_135_clk _00645_ VGND VGND VPWR VPWR picorv32_core.cpuregs\[15\]\[3\]
+ sky130_fd_sc_hd__dfxtp_1
XFILLER_12_442 VGND VGND VPWR VPWR sky130_fd_sc_hd__decap_3
XFILLER_129_127 VGND VGND VPWR VPWR sky130_fd_sc_hd__decap_4
X_11415_ clknet_leaf_63_clk _01251_ VGND VGND VPWR VPWR picorv32_core.cpuregs\[31\]\[30\]
+ sky130_fd_sc_hd__dfxtp_1
XTAP_TAPCELL_ROW_78_1442 VGND VPWR sky130_fd_sc_hd__tapvpwrvgnd_1
XTAP_TAPCELL_ROW_78_1431 VGND VPWR sky130_fd_sc_hd__tapvpwrvgnd_1
XFILLER_141_804 VGND VGND VPWR VPWR sky130_fd_sc_hd__decap_4
X_11346_ clknet_leaf_63_clk _01187_ VGND VGND VPWR VPWR picorv32_core.cpuregs\[29\]\[30\]
+ sky130_fd_sc_hd__dfxtp_1
XFILLER_125_399 VGND VGND VPWR VPWR sky130_fd_sc_hd__fill_1
XTAP_TAPCELL_ROW_91_1631 VGND VPWR sky130_fd_sc_hd__tapvpwrvgnd_1
XTAP_TAPCELL_ROW_91_1620 VGND VPWR sky130_fd_sc_hd__tapvpwrvgnd_1
X_11277_ clknet_leaf_132_clk _01125_ VGND VGND VPWR VPWR picorv32_core.cpuregs\[3\]\[0\]
+ sky130_fd_sc_hd__dfxtp_1
X_10228_ clknet_leaf_100_clk _00147_ VGND VGND VPWR VPWR picorv32_core.count_instr\[12\]
+ sky130_fd_sc_hd__dfxtp_1
Xhold2 picorv32_core.cpuregs\[0\]\[15\] VGND VGND VPWR VPWR net1111 sky130_fd_sc_hd__dlygate4sd3_1
X_10159_ clknet_leaf_130_clk _00078_ VGND VGND VPWR VPWR picorv32_core.cpuregs\[21\]\[7\]
+ sky130_fd_sc_hd__dfxtp_1
XTAP_TAPCELL_ROW_89_1593 VGND VPWR sky130_fd_sc_hd__tapvpwrvgnd_1
XFILLER_75_670 VGND VGND VPWR VPWR sky130_fd_sc_hd__fill_2
XFILLER_47_350 VGND VGND VPWR VPWR sky130_fd_sc_hd__fill_2
XFILLER_23_729 VPWR VGND VPWR VGND sky130_ef_sc_hd__decap_12
X_07370_ _03504_ _03509_ VGND VGND VPWR VPWR _03510_ sky130_fd_sc_hd__nor2_1
XFILLER_16_781 VPWR VGND VPWR VGND sky130_ef_sc_hd__decap_12
X_06321_ _02729_ _02730_ net565 VGND VGND VPWR VPWR _02731_ sky130_fd_sc_hd__mux2_1
XTAP_TAPCELL_ROW_33_779 VGND VPWR sky130_fd_sc_hd__tapvpwrvgnd_1
X_09040_ net249 net1965 net342 VGND VGND VPWR VPWR _01209_ sky130_fd_sc_hd__mux2_1
XTAP_TAPCELL_ROW_100_1760 VGND VPWR sky130_fd_sc_hd__tapvpwrvgnd_1
X_06252_ picorv32_core.reg_out\[3\] picorv32_core.alu_out_q\[3\] net950 VGND VGND
+ VPWR VPWR _02675_ sky130_fd_sc_hd__mux2_1
X_05203_ net20 net820 VGND VGND VPWR VPWR _01719_ sky130_fd_sc_hd__nand2b_1
XTAP_TAPCELL_ROW_13_492 VGND VPWR sky130_fd_sc_hd__tapvpwrvgnd_1
XFILLER_135_119 VGND VGND VPWR VPWR sky130_fd_sc_hd__fill_1
X_06183_ net623 _02614_ VGND VGND VPWR VPWR _02615_ sky130_fd_sc_hd__nand2_1
Xhold402 picorv32_core.cpuregs\[14\]\[8\] VGND VGND VPWR VPWR net1511 sky130_fd_sc_hd__dlygate4sd3_1
Xhold435 picorv32_core.cpuregs\[12\]\[26\] VGND VGND VPWR VPWR net1544 sky130_fd_sc_hd__dlygate4sd3_1
Xhold424 picorv32_core.cpuregs\[31\]\[13\] VGND VGND VPWR VPWR net1533 sky130_fd_sc_hd__dlygate4sd3_1
Xhold413 picorv32_core.cpuregs\[23\]\[7\] VGND VGND VPWR VPWR net1522 sky130_fd_sc_hd__dlygate4sd3_1
X_05134_ net981 picorv32_core.cpu_state\[2\] VGND VGND VPWR VPWR _01665_ sky130_fd_sc_hd__nand2_1
Xhold457 picorv32_core.cpuregs\[7\]\[23\] VGND VGND VPWR VPWR net1566 sky130_fd_sc_hd__dlygate4sd3_1
Xhold468 picorv32_core.cpuregs\[22\]\[29\] VGND VGND VPWR VPWR net1577 sky130_fd_sc_hd__dlygate4sd3_1
X_05065_ net766 VGND VGND VPWR VPWR _01600_ sky130_fd_sc_hd__inv_2
X_09942_ net1536 net497 net317 VGND VGND VPWR VPWR _01420_ sky130_fd_sc_hd__mux2_1
Xhold446 picorv32_core.cpuregs\[21\]\[8\] VGND VGND VPWR VPWR net1555 sky130_fd_sc_hd__dlygate4sd3_1
Xfanout904 net906 VGND VGND VPWR VPWR net904 sky130_fd_sc_hd__buf_4
Xhold479 picorv32_core.cpuregs\[30\]\[2\] VGND VGND VPWR VPWR net1588 sky130_fd_sc_hd__dlygate4sd3_1
Xfanout915 net919 VGND VGND VPWR VPWR net915 sky130_fd_sc_hd__buf_2
XFILLER_100_712 VPWR VGND VPWR VGND sky130_ef_sc_hd__decap_12
Xfanout937 net938 VGND VGND VPWR VPWR net937 sky130_fd_sc_hd__buf_2
Xfanout926 net927 VGND VGND VPWR VPWR net926 sky130_fd_sc_hd__clkbuf_2
Xfanout948 picorv32_core.latched_rd\[3\] VGND VGND VPWR VPWR net948 sky130_fd_sc_hd__buf_2
X_09873_ net1505 net292 net324 VGND VGND VPWR VPWR _01361_ sky130_fd_sc_hd__mux2_1
Xhold1113 picorv32_core.cpuregs\[4\]\[30\] VGND VGND VPWR VPWR net2222 sky130_fd_sc_hd__dlygate4sd3_1
Xhold1124 picorv32_core.instr_lui VGND VGND VPWR VPWR net2233 sky130_fd_sc_hd__dlygate4sd3_1
XFILLER_57_125 VGND VGND VPWR VPWR sky130_fd_sc_hd__fill_2
Xfanout959 net204 VGND VGND VPWR VPWR net959 sky130_fd_sc_hd__buf_2
X_08824_ net1202 net493 net366 VGND VGND VPWR VPWR _01000_ sky130_fd_sc_hd__mux2_1
Xhold1102 picorv32_core.cpuregs\[16\]\[5\] VGND VGND VPWR VPWR net2211 sky130_fd_sc_hd__dlygate4sd3_1
Xhold1157 picorv32_core.count_cycle\[54\] VGND VGND VPWR VPWR net2266 sky130_fd_sc_hd__dlygate4sd3_1
Xhold1135 picorv32_core.instr_sw VGND VGND VPWR VPWR net2244 sky130_fd_sc_hd__dlygate4sd3_1
XFILLER_57_169 VGND VGND VPWR VPWR sky130_fd_sc_hd__fill_1
Xhold1146 picorv32_core.count_cycle\[39\] VGND VGND VPWR VPWR net2255 sky130_fd_sc_hd__dlygate4sd3_1
X_08755_ net498 net1592 net377 VGND VGND VPWR VPWR _00902_ sky130_fd_sc_hd__mux2_1
Xhold1168 net44 VGND VGND VPWR VPWR net2277 sky130_fd_sc_hd__dlygate4sd3_1
X_05967_ _02428_ _02434_ VGND VGND VPWR VPWR _02435_ sky130_fd_sc_hd__nand2_1
XTAP_TAPCELL_ROW_49_1010 VGND VPWR sky130_fd_sc_hd__tapvpwrvgnd_1
Xhold1179 picorv32_core.reg_sh\[0\] VGND VGND VPWR VPWR net2288 sky130_fd_sc_hd__dlygate4sd3_1
X_07706_ net681 _03799_ net623 VGND VGND VPWR VPWR _03801_ sky130_fd_sc_hd__a21o_1
X_08686_ net206 net1634 net389 VGND VGND VPWR VPWR _00836_ sky130_fd_sc_hd__mux2_1
X_05898_ _02354_ _02358_ VGND VGND VPWR VPWR _02371_ sky130_fd_sc_hd__and2_1
XTAP_TAPCELL_ROW_49_1021 VGND VPWR sky130_fd_sc_hd__tapvpwrvgnd_1
XFILLER_26_556 VGND VGND VPWR VPWR sky130_fd_sc_hd__decap_3
X_07637_ picorv32_core.cpuregs\[24\]\[7\] picorv32_core.cpuregs\[25\]\[7\] picorv32_core.cpuregs\[26\]\[7\]
+ picorv32_core.cpuregs\[27\]\[7\] net734 net701 VGND VGND VPWR VPWR _03735_ sky130_fd_sc_hd__mux4_1
XTAP_TAPCELL_ROW_62_1210 VGND VPWR sky130_fd_sc_hd__tapvpwrvgnd_1
X_07568_ net969 _03672_ net510 VGND VGND VPWR VPWR _00360_ sky130_fd_sc_hd__mux2_1
XFILLER_41_548 VGND VGND VPWR VPWR sky130_fd_sc_hd__decap_8
X_06519_ _02829_ _02830_ VGND VGND VPWR VPWR _00153_ sky130_fd_sc_hd__nor2_1
XFILLER_70_26 VGND VGND VPWR VPWR sky130_fd_sc_hd__fill_2
X_09307_ net811 net281 VGND VGND VPWR VPWR _04501_ sky130_fd_sc_hd__and2_1
X_07499_ net2220 _03620_ net462 VGND VGND VPWR VPWR _00343_ sky130_fd_sc_hd__mux2_1
XFILLER_21_250 VGND VGND VPWR VPWR sky130_fd_sc_hd__decap_3
X_09238_ picorv32_core.cpuregs\[28\]\[3\] picorv32_core.cpuregs\[29\]\[3\] picorv32_core.cpuregs\[30\]\[3\]
+ picorv32_core.cpuregs\[31\]\[3\] net885 net852 VGND VGND VPWR VPWR _04434_ sky130_fd_sc_hd__mux4_1
X_09169_ net649 _04361_ _04363_ _04367_ net827 VGND VGND VPWR VPWR _04368_ sky130_fd_sc_hd__o311a_1
XFILLER_119_75 VGND VGND VPWR VPWR sky130_fd_sc_hd__decap_6
X_11200_ clknet_leaf_30_clk _01051_ VGND VGND VPWR VPWR picorv32_core.cpuregs\[6\]\[22\]
+ sky130_fd_sc_hd__dfxtp_1
XFILLER_119_97 VGND VGND VPWR VPWR sky130_fd_sc_hd__fill_1
XFILLER_107_377 VPWR VGND VPWR VGND sky130_ef_sc_hd__decap_12
XFILLER_102_3 VPWR VGND VPWR VGND sky130_ef_sc_hd__decap_12
X_11131_ clknet_leaf_22_clk _00982_ VGND VGND VPWR VPWR picorv32_core.cpuregs\[8\]\[17\]
+ sky130_fd_sc_hd__dfxtp_1
Xhold980 picorv32_core.cpuregs\[18\]\[29\] VGND VGND VPWR VPWR net2089 sky130_fd_sc_hd__dlygate4sd3_1
XFILLER_107_399 VGND VGND VPWR VPWR sky130_fd_sc_hd__fill_1
Xhold991 picorv32_core.cpuregs\[10\]\[7\] VGND VGND VPWR VPWR net2100 sky130_fd_sc_hd__dlygate4sd3_1
XFILLER_122_369 VGND VGND VPWR VPWR sky130_fd_sc_hd__fill_1
XFILLER_103_561 VGND VGND VPWR VPWR sky130_fd_sc_hd__decap_8
XTAP_TAPCELL_ROW_73_1361 VGND VPWR sky130_fd_sc_hd__tapvpwrvgnd_1
X_11062_ clknet_leaf_7_clk _00913_ VGND VGND VPWR VPWR picorv32_core.cpuregs\[10\]\[12\]
+ sky130_fd_sc_hd__dfxtp_1
XFILLER_0_165 VGND VGND VPWR VPWR sky130_fd_sc_hd__decap_3
X_10013_ net1582 net431 net308 VGND VGND VPWR VPWR _01489_ sky130_fd_sc_hd__mux2_1
XFILLER_56_191 VGND VGND VPWR VPWR sky130_fd_sc_hd__decap_4
XFILLER_71_150 VGND VGND VPWR VPWR sky130_fd_sc_hd__fill_1
X_10915_ clknet_leaf_94_clk _00766_ VGND VGND VPWR VPWR picorv32_core.mem_rdata_q\[25\]
+ sky130_fd_sc_hd__dfxtp_1
X_10846_ clknet_leaf_45_clk _00697_ VGND VGND VPWR VPWR picorv32_core.cpuregs\[17\]\[23\]
+ sky130_fd_sc_hd__dfxtp_1
XFILLER_32_548 VGND VGND VPWR VPWR sky130_fd_sc_hd__fill_1
X_10777_ clknet_leaf_20_clk _00628_ VGND VGND VPWR VPWR picorv32_core.cpuregs\[14\]\[18\]
+ sky130_fd_sc_hd__dfxtp_1
XTAP_TAPCELL_ROW_30_738 VGND VPWR sky130_fd_sc_hd__tapvpwrvgnd_1
XFILLER_9_777 VGND VGND VPWR VPWR sky130_fd_sc_hd__decap_6
XTAP_TAPCELL_ROW_10_451 VGND VPWR sky130_fd_sc_hd__tapvpwrvgnd_1
XFILLER_126_697 VGND VGND VPWR VPWR sky130_fd_sc_hd__decap_3
XFILLER_5_54 VGND VGND VPWR VPWR sky130_fd_sc_hd__fill_2
XFILLER_140_133 VGND VGND VPWR VPWR sky130_fd_sc_hd__decap_6
XFILLER_99_559 VGND VGND VPWR VPWR sky130_fd_sc_hd__fill_1
X_11329_ clknet_leaf_13_clk _01170_ VGND VGND VPWR VPWR picorv32_core.cpuregs\[29\]\[13\]
+ sky130_fd_sc_hd__dfxtp_1
XFILLER_140_177 VPWR VGND VPWR VGND sky130_ef_sc_hd__decap_12
XPHY_EDGE_ROW_105_Left_247 VGND VGND VPWR VPWR sky130_fd_sc_hd__decap_3
XFILLER_95_732 VGND VGND VPWR VPWR sky130_fd_sc_hd__fill_1
X_06870_ _03090_ _03091_ net989 VGND VGND VPWR VPWR _00243_ sky130_fd_sc_hd__o21a_1
XFILLER_94_253 VGND VGND VPWR VPWR sky130_fd_sc_hd__decap_4
X_05821_ _02296_ _02297_ _02288_ _02290_ VGND VGND VPWR VPWR _02300_ sky130_fd_sc_hd__o211a_1
X_08540_ net1997 net228 net405 VGND VGND VPWR VPWR _00667_ sky130_fd_sc_hd__mux2_1
X_05752_ _02221_ _02226_ _02235_ _02181_ VGND VGND VPWR VPWR _02236_ sky130_fd_sc_hd__a31o_2
XTAP_TAPCELL_ROW_38_849 VGND VPWR sky130_fd_sc_hd__tapvpwrvgnd_1
X_05683_ net764 net196 VGND VGND VPWR VPWR _02167_ sky130_fd_sc_hd__nand2_1
XTAP_TAPCELL_ROW_18_562 VGND VPWR sky130_fd_sc_hd__tapvpwrvgnd_1
X_08471_ picorv32_core.decoded_imm\[3\] net527 _04316_ _04317_ VGND VGND VPWR VPWR
+ _00607_ sky130_fd_sc_hd__o22a_1
X_07422_ net902 picorv32_core.cpuregs\[27\]\[31\] net868 VGND VGND VPWR VPWR _03562_
+ sky130_fd_sc_hd__a21bo_1
XTAP_TAPCELL_ROW_18_573 VGND VPWR sky130_fd_sc_hd__tapvpwrvgnd_1
XTAP_TAPCELL_ROW_118_2018 VGND VPWR sky130_fd_sc_hd__tapvpwrvgnd_1
XPHY_EDGE_ROW_114_Left_256 VGND VGND VPWR VPWR sky130_fd_sc_hd__decap_3
X_07353_ _03424_ _03425_ VGND VGND VPWR VPWR _03493_ sky130_fd_sc_hd__or2_1
X_07284_ net791 picorv32_core.decoded_imm\[15\] VGND VGND VPWR VPWR _03424_ sky130_fd_sc_hd__nor2_1
X_06304_ picorv32_core.reg_pc\[12\] _02709_ picorv32_core.reg_pc\[13\] VGND VGND VPWR
+ VPWR _02717_ sky130_fd_sc_hd__a21oi_1
X_09023_ net492 net1863 net341 VGND VGND VPWR VPWR _01192_ sky130_fd_sc_hd__mux2_1
X_06235_ net613 _01698_ _02247_ VGND VGND VPWR VPWR _02663_ sky130_fd_sc_hd__or3b_1
XFILLER_40_29 VGND VGND VPWR VPWR sky130_fd_sc_hd__decap_4
XTAP_TAPCELL_ROW_131_2207 VGND VPWR sky130_fd_sc_hd__tapvpwrvgnd_1
XFILLER_117_653 VGND VGND VPWR VPWR sky130_fd_sc_hd__decap_3
Xhold210 picorv32_core.cpuregs\[15\]\[19\] VGND VGND VPWR VPWR net1319 sky130_fd_sc_hd__dlygate4sd3_1
Xhold221 picorv32_core.cpuregs\[1\]\[29\] VGND VGND VPWR VPWR net1330 sky130_fd_sc_hd__dlygate4sd3_1
XFILLER_116_141 VGND VGND VPWR VPWR sky130_fd_sc_hd__fill_2
Xhold243 picorv32_core.cpuregs\[11\]\[5\] VGND VGND VPWR VPWR net1352 sky130_fd_sc_hd__dlygate4sd3_1
XFILLER_2_408 VPWR VGND VPWR VGND sky130_ef_sc_hd__decap_12
Xhold232 picorv32_core.cpuregs\[5\]\[0\] VGND VGND VPWR VPWR net1341 sky130_fd_sc_hd__dlygate4sd3_1
X_06166_ picorv32_core.decoded_imm_j\[3\] _00764_ net437 VGND VGND VPWR VPWR _00023_
+ sky130_fd_sc_hd__mux2_1
XTAP_TAPCELL_ROW_113_1940 VGND VPWR sky130_fd_sc_hd__tapvpwrvgnd_1
Xhold287 picorv32_core.cpuregs\[15\]\[22\] VGND VGND VPWR VPWR net1396 sky130_fd_sc_hd__dlygate4sd3_1
X_06097_ _02552_ _02553_ VGND VGND VPWR VPWR _02554_ sky130_fd_sc_hd__nand2_1
X_05117_ picorv32_core.instr_bgeu picorv32_core.instr_bge VGND VGND VPWR VPWR _01648_
+ sky130_fd_sc_hd__nor2_1
Xhold276 picorv32_core.cpuregs\[27\]\[13\] VGND VGND VPWR VPWR net1385 sky130_fd_sc_hd__dlygate4sd3_1
Xhold254 picorv32_core.cpuregs\[15\]\[5\] VGND VGND VPWR VPWR net1363 sky130_fd_sc_hd__dlygate4sd3_1
Xhold265 picorv32_core.cpuregs\[17\]\[4\] VGND VGND VPWR VPWR net1374 sky130_fd_sc_hd__dlygate4sd3_1
X_09925_ net231 net1794 net323 VGND VGND VPWR VPWR _01409_ sky130_fd_sc_hd__mux2_1
Xfanout723 net724 VGND VGND VPWR VPWR net723 sky130_fd_sc_hd__clkbuf_4
XPHY_EDGE_ROW_123_Left_265 VGND VGND VPWR VPWR sky130_fd_sc_hd__decap_3
Xfanout712 net713 VGND VGND VPWR VPWR net712 sky130_fd_sc_hd__clkbuf_2
Xhold298 picorv32_core.cpuregs\[23\]\[5\] VGND VGND VPWR VPWR net1407 sky130_fd_sc_hd__dlygate4sd3_1
Xfanout701 net708 VGND VGND VPWR VPWR net701 sky130_fd_sc_hd__clkbuf_4
X_05048_ picorv32_core.cpu_state\[1\] VGND VGND VPWR VPWR _01583_ sky130_fd_sc_hd__inv_2
Xfanout756 net757 VGND VGND VPWR VPWR net756 sky130_fd_sc_hd__buf_4
X_09856_ _05016_ _05023_ _05024_ net647 net651 VGND VGND VPWR VPWR _05025_ sky130_fd_sc_hd__a221o_1
Xfanout767 net161 VGND VGND VPWR VPWR net767 sky130_fd_sc_hd__buf_2
Xfanout745 net746 VGND VGND VPWR VPWR net745 sky130_fd_sc_hd__clkbuf_2
Xfanout734 net741 VGND VGND VPWR VPWR net734 sky130_fd_sc_hd__buf_4
XTAP_TAPCELL_ROW_129_2169 VGND VPWR sky130_fd_sc_hd__tapvpwrvgnd_1
XFILLER_105_55 VGND VGND VPWR VPWR sky130_fd_sc_hd__fill_1
X_08807_ net250 net2221 net373 VGND VGND VPWR VPWR _00985_ sky130_fd_sc_hd__mux2_1
Xfanout778 net155 VGND VGND VPWR VPWR net778 sky130_fd_sc_hd__buf_2
Xfanout789 net790 VGND VGND VPWR VPWR net789 sky130_fd_sc_hd__buf_2
XFILLER_58_456 VGND VGND VPWR VPWR sky130_fd_sc_hd__decap_4
X_09787_ picorv32_core.cpuregs\[8\]\[27\] picorv32_core.cpuregs\[9\]\[27\] picorv32_core.cpuregs\[10\]\[27\]
+ picorv32_core.cpuregs\[11\]\[27\] net898 net864 VGND VGND VPWR VPWR _04959_ sky130_fd_sc_hd__mux4_1
X_06999_ _02933_ _02934_ _02935_ _02936_ net934 VGND VGND VPWR VPWR _03210_ sky130_fd_sc_hd__o41a_1
X_08738_ net1574 net261 net379 VGND VGND VPWR VPWR _00886_ sky130_fd_sc_hd__mux2_1
X_08669_ net272 net2051 net388 VGND VGND VPWR VPWR _00819_ sky130_fd_sc_hd__mux2_1
XPHY_EDGE_ROW_132_Left_274 VGND VGND VPWR VPWR sky130_fd_sc_hd__decap_3
X_10700_ clknet_leaf_26_clk _00551_ VGND VGND VPWR VPWR net105 sky130_fd_sc_hd__dfxtp_1
X_11680_ clknet_leaf_69_clk _01511_ VGND VGND VPWR VPWR picorv32_core.cpuregs\[26\]\[29\]
+ sky130_fd_sc_hd__dfxtp_1
XFILLER_41_334 VGND VGND VPWR VPWR sky130_fd_sc_hd__fill_2
X_10631_ clknet_leaf_83_clk _00485_ VGND VGND VPWR VPWR picorv32_core.decoded_imm_j\[20\]
+ sky130_fd_sc_hd__dfxtp_1
XFILLER_14_41 VPWR VGND VPWR VGND sky130_ef_sc_hd__decap_12
XFILLER_41_378 VGND VGND VPWR VPWR sky130_fd_sc_hd__fill_1
X_10562_ clknet_leaf_18_clk _00416_ VGND VGND VPWR VPWR picorv32_core.cpuregs\[25\]\[18\]
+ sky130_fd_sc_hd__dfxtp_1
XFILLER_14_85 VGND VGND VPWR VPWR sky130_fd_sc_hd__decap_4
XFILLER_6_725 VPWR VGND VPWR VGND sky130_ef_sc_hd__decap_12
X_10493_ clknet_leaf_54_clk _00379_ VGND VGND VPWR VPWR net183 sky130_fd_sc_hd__dfxtp_4
XFILLER_6_769 VPWR VGND VPWR VGND sky130_ef_sc_hd__decap_12
XFILLER_107_163 VGND VGND VPWR VPWR sky130_fd_sc_hd__decap_4
XFILLER_5_279 VGND VGND VPWR VPWR sky130_fd_sc_hd__fill_1
XPHY_EDGE_ROW_141_Left_283 VGND VGND VPWR VPWR sky130_fd_sc_hd__decap_3
XFILLER_108_697 VGND VGND VPWR VPWR sky130_fd_sc_hd__decap_3
X_11114_ clknet_leaf_132_clk _00965_ VGND VGND VPWR VPWR picorv32_core.cpuregs\[8\]\[0\]
+ sky130_fd_sc_hd__dfxtp_1
X_11045_ clknet_leaf_38_clk _00896_ VGND VGND VPWR VPWR picorv32_core.cpuregs\[11\]\[27\]
+ sky130_fd_sc_hd__dfxtp_1
XFILLER_89_592 VGND VGND VPWR VPWR sky130_fd_sc_hd__fill_1
XFILLER_76_253 VGND VGND VPWR VPWR sky130_fd_sc_hd__decap_4
XFILLER_92_757 VGND VGND VPWR VPWR sky130_fd_sc_hd__fill_2
XFILLER_64_437 VGND VGND VPWR VPWR sky130_fd_sc_hd__fill_1
XFILLER_17_331 VGND VGND VPWR VPWR sky130_fd_sc_hd__fill_1
XTAP_TAPCELL_ROW_86_1552 VGND VPWR sky130_fd_sc_hd__tapvpwrvgnd_1
XTAP_TAPCELL_ROW_35_808 VGND VPWR sky130_fd_sc_hd__tapvpwrvgnd_1
XTAP_TAPCELL_ROW_35_819 VGND VPWR sky130_fd_sc_hd__tapvpwrvgnd_1
XFILLER_45_673 VGND VGND VPWR VPWR sky130_fd_sc_hd__decap_6
XFILLER_60_643 VGND VGND VPWR VPWR sky130_fd_sc_hd__fill_1
XTAP_TAPCELL_ROW_15_521 VGND VPWR sky130_fd_sc_hd__tapvpwrvgnd_1
X_10829_ clknet_leaf_0_clk _00680_ VGND VGND VPWR VPWR picorv32_core.cpuregs\[17\]\[6\]
+ sky130_fd_sc_hd__dfxtp_1
X_06020_ _02176_ _02483_ _02482_ _02481_ VGND VGND VPWR VPWR picorv32_core.alu_out\[20\]
+ sky130_fd_sc_hd__a211o_1
XFILLER_141_453 VGND VGND VPWR VPWR sky130_fd_sc_hd__decap_3
X_07971_ picorv32_core.cpuregs\[16\]\[25\] picorv32_core.cpuregs\[17\]\[25\] picorv32_core.cpuregs\[18\]\[25\]
+ picorv32_core.cpuregs\[19\]\[25\] net761 net728 VGND VGND VPWR VPWR _04051_ sky130_fd_sc_hd__mux4_1
X_09710_ net774 net280 VGND VGND VPWR VPWR _04885_ sky130_fd_sc_hd__and2_1
XFILLER_101_306 VGND VGND VPWR VPWR sky130_fd_sc_hd__decap_4
X_06922_ net667 picorv32_core.reg_next_pc\[18\] _02930_ net490 VGND VGND VPWR VPWR
+ _03140_ sky130_fd_sc_hd__a22o_1
XFILLER_68_710 VGND VGND VPWR VPWR sky130_fd_sc_hd__fill_2
XFILLER_68_743 VGND VGND VPWR VPWR sky130_fd_sc_hd__decap_8
X_09641_ picorv32_core.reg_pc\[20\] net537 _04819_ net484 VGND VGND VPWR VPWR _04820_
+ sky130_fd_sc_hd__a211o_1
X_06853_ _03072_ _03074_ _03069_ VGND VGND VPWR VPWR _03076_ sky130_fd_sc_hd__o21ai_1
XFILLER_55_404 VPWR VGND VPWR VGND sky130_ef_sc_hd__decap_12
XFILLER_83_735 VGND VGND VPWR VPWR sky130_fd_sc_hd__fill_1
X_09572_ net828 _04750_ _04753_ net480 VGND VGND VPWR VPWR _04754_ sky130_fd_sc_hd__o211a_1
X_06784_ _02920_ _03007_ VGND VGND VPWR VPWR _03012_ sky130_fd_sc_hd__and2_1
X_05804_ _02280_ _02282_ _02279_ VGND VGND VPWR VPWR _02284_ sky130_fd_sc_hd__a21bo_1
X_05735_ net795 _01606_ _02218_ VGND VGND VPWR VPWR _02219_ sky130_fd_sc_hd__o21a_1
XFILLER_24_813 VGND VGND VPWR VPWR sky130_fd_sc_hd__fill_1
X_08523_ net1495 net426 net402 VGND VGND VPWR VPWR _00650_ sky130_fd_sc_hd__mux2_1
XTAP_TAPCELL_ROW_124_2099 VGND VPWR sky130_fd_sc_hd__tapvpwrvgnd_1
X_05666_ net787 net181 VGND VGND VPWR VPWR _02150_ sky130_fd_sc_hd__xnor2_1
X_08454_ net675 picorv32_core.decoded_imm_j\[10\] _04283_ picorv32_core.mem_rdata_q\[30\]
+ net524 VGND VGND VPWR VPWR _04308_ sky130_fd_sc_hd__a221o_1
XFILLER_51_654 VGND VGND VPWR VPWR sky130_fd_sc_hd__fill_2
X_07405_ picorv32_core.cpuregs\[12\]\[31\] picorv32_core.cpuregs\[13\]\[31\] picorv32_core.cpuregs\[14\]\[31\]
+ picorv32_core.cpuregs\[15\]\[31\] net902 net868 VGND VGND VPWR VPWR _03545_ sky130_fd_sc_hd__mux4_1
X_08385_ net1185 net455 _04267_ VGND VGND VPWR VPWR _00571_ sky130_fd_sc_hd__o21a_1
X_05597_ net24 net585 net575 VGND VGND VPWR VPWR _02085_ sky130_fd_sc_hd__a21o_1
XFILLER_50_197 VGND VGND VPWR VPWR sky130_fd_sc_hd__decap_4
X_07336_ net809 picorv32_core.decoded_imm\[6\] _03447_ _03449_ VGND VGND VPWR VPWR
+ _03476_ sky130_fd_sc_hd__a31o_1
X_07267_ _03405_ _03406_ VGND VGND VPWR VPWR _03407_ sky130_fd_sc_hd__nand2_1
X_09006_ net253 net2111 net346 VGND VGND VPWR VPWR _01176_ sky130_fd_sc_hd__mux2_1
XFILLER_136_269 VGND VGND VPWR VPWR sky130_fd_sc_hd__decap_6
X_07198_ picorv32_core.count_cycle\[46\] _03354_ net976 VGND VGND VPWR VPWR _03356_
+ sky130_fd_sc_hd__a21oi_1
X_06218_ picorv32_core.cpuregs\[8\]\[4\] picorv32_core.cpuregs\[9\]\[4\] picorv32_core.cpuregs\[10\]\[4\]
+ picorv32_core.cpuregs\[11\]\[4\] net744 net711 VGND VGND VPWR VPWR _02648_ sky130_fd_sc_hd__mux4_1
X_06149_ net2325 net10 net521 VGND VGND VPWR VPWR _00756_ sky130_fd_sc_hd__mux2_1
XTAP_TAPCELL_ROW_57_1131 VGND VPWR sky130_fd_sc_hd__tapvpwrvgnd_1
XFILLER_132_497 VGND VGND VPWR VPWR sky130_fd_sc_hd__decap_4
Xfanout542 net543 VGND VGND VPWR VPWR net542 sky130_fd_sc_hd__buf_2
XFILLER_78_529 VGND VGND VPWR VPWR sky130_fd_sc_hd__decap_3
XTAP_TAPCELL_ROW_70_1320 VGND VPWR sky130_fd_sc_hd__tapvpwrvgnd_1
Xfanout520 _01626_ VGND VGND VPWR VPWR net520 sky130_fd_sc_hd__clkbuf_4
Xfanout531 _04177_ VGND VGND VPWR VPWR net531 sky130_fd_sc_hd__clkbuf_2
Xfanout564 net565 VGND VGND VPWR VPWR net564 sky130_fd_sc_hd__clkbuf_4
Xfanout553 net554 VGND VGND VPWR VPWR net553 sky130_fd_sc_hd__clkbuf_4
Xfanout575 _01821_ VGND VGND VPWR VPWR net575 sky130_fd_sc_hd__buf_2
X_09908_ net427 net1791 net320 VGND VGND VPWR VPWR _01392_ sky130_fd_sc_hd__mux2_1
X_09839_ net765 _05008_ net285 VGND VGND VPWR VPWR _01348_ sky130_fd_sc_hd__mux2_1
Xfanout597 net598 VGND VGND VPWR VPWR net597 sky130_fd_sc_hd__clkbuf_2
Xfanout586 _01715_ VGND VGND VPWR VPWR net586 sky130_fd_sc_hd__buf_2
XFILLER_132_53 VPWR VGND VPWR VGND sky130_ef_sc_hd__decap_12
XFILLER_100_394 VGND VGND VPWR VPWR sky130_fd_sc_hd__decap_4
XFILLER_74_757 VGND VGND VPWR VPWR sky130_fd_sc_hd__decap_8
XFILLER_73_245 VGND VGND VPWR VPWR sky130_fd_sc_hd__fill_1
XFILLER_132_97 VPWR VGND VPWR VGND sky130_ef_sc_hd__decap_12
XFILLER_82_790 VGND VGND VPWR VPWR sky130_fd_sc_hd__fill_1
XTAP_TAPCELL_ROW_68_1293 VGND VPWR sky130_fd_sc_hd__tapvpwrvgnd_1
XFILLER_30_805 VGND VGND VPWR VPWR sky130_fd_sc_hd__decap_6
X_11663_ clknet_leaf_8_clk _01494_ VGND VGND VPWR VPWR picorv32_core.cpuregs\[26\]\[12\]
+ sky130_fd_sc_hd__dfxtp_1
XTAP_TAPCELL_ROW_81_1482 VGND VPWR sky130_fd_sc_hd__tapvpwrvgnd_1
X_10614_ clknet_leaf_92_clk _00468_ VGND VGND VPWR VPWR picorv32_core.instr_srai sky130_fd_sc_hd__dfxtp_1
XFILLER_128_748 VGND VGND VPWR VPWR sky130_fd_sc_hd__decap_8
X_11594_ clknet_leaf_130_clk _01425_ VGND VGND VPWR VPWR picorv32_core.cpuregs\[23\]\[7\]
+ sky130_fd_sc_hd__dfxtp_1
XTAP_TAPCELL_ROW_40_888 VGND VPWR sky130_fd_sc_hd__tapvpwrvgnd_1
XFILLER_127_225 VGND VGND VPWR VPWR sky130_fd_sc_hd__decap_4
XFILLER_6_533 VGND VGND VPWR VPWR sky130_fd_sc_hd__decap_4
X_10545_ clknet_leaf_111_clk _00399_ VGND VGND VPWR VPWR picorv32_core.cpuregs\[25\]\[1\]
+ sky130_fd_sc_hd__dfxtp_1
Xclkbuf_leaf_130_clk clknet_4_3_0_clk VGND VGND VPWR VPWR clknet_leaf_130_clk sky130_fd_sc_hd__clkbuf_8
XTAP_TAPCELL_ROW_20_590 VGND VPWR sky130_fd_sc_hd__tapvpwrvgnd_1
X_10476_ clknet_leaf_132_clk _00362_ VGND VGND VPWR VPWR picorv32_core.mem_la_wdata\[2\]
+ sky130_fd_sc_hd__dfxtp_1
XFILLER_136_781 VPWR VGND VPWR VGND sky130_ef_sc_hd__decap_12
XFILLER_135_291 VGND VGND VPWR VPWR sky130_fd_sc_hd__fill_1
XFILLER_110_136 VGND VGND VPWR VPWR sky130_fd_sc_hd__decap_4
XFILLER_1_293 VGND VGND VPWR VPWR sky130_fd_sc_hd__fill_1
XFILLER_49_264 VGND VGND VPWR VPWR sky130_fd_sc_hd__decap_3
XFILLER_2_77 VGND VGND VPWR VPWR sky130_fd_sc_hd__decap_6
X_11028_ clknet_leaf_2_clk _00879_ VGND VGND VPWR VPWR picorv32_core.cpuregs\[11\]\[10\]
+ sky130_fd_sc_hd__dfxtp_1
XFILLER_65_746 VGND VGND VPWR VPWR sky130_fd_sc_hd__decap_4
XFILLER_92_554 VPWR VGND VPWR VGND sky130_ef_sc_hd__decap_12
XFILLER_52_418 VGND VGND VPWR VPWR sky130_fd_sc_hd__fill_2
XTAP_TAPCELL_ROW_48_999 VGND VPWR sky130_fd_sc_hd__tapvpwrvgnd_1
X_05520_ picorv32_core.count_cycle\[22\] net600 VGND VGND VPWR VPWR _02014_ sky130_fd_sc_hd__or2_1
X_05451_ net12 net584 net575 VGND VGND VPWR VPWR _01950_ sky130_fd_sc_hd__a21o_1
XFILLER_60_451 VPWR VGND VPWR VGND sky130_ef_sc_hd__decap_12
XPHY_EDGE_ROW_120_Right_120 VGND VGND VPWR VPWR sky130_fd_sc_hd__decap_3
XANTENNA_38 picorv32_core.mem_la_wdata\[4\] VGND VGND VPWR VPWR sky130_fd_sc_hd__diode_2
X_08170_ net441 _00747_ _04190_ VGND VGND VPWR VPWR _04191_ sky130_fd_sc_hd__and3_1
XANTENNA_16 _03802_ VGND VGND VPWR VPWR sky130_fd_sc_hd__diode_2
XANTENNA_27 _04587_ VGND VGND VPWR VPWR sky130_fd_sc_hd__diode_2
XFILLER_32_197 VGND VGND VPWR VPWR sky130_fd_sc_hd__decap_3
XANTENNA_49 net351 VGND VGND VPWR VPWR sky130_fd_sc_hd__diode_2
XFILLER_119_726 VGND VGND VPWR VPWR sky130_fd_sc_hd__fill_2
XTAP_TAPCELL_ROW_99_1743 VGND VPWR sky130_fd_sc_hd__tapvpwrvgnd_1
X_07121_ picorv32_core.count_cycle\[16\] picorv32_core.count_cycle\[17\] _03304_ VGND
+ VGND VPWR VPWR _03308_ sky130_fd_sc_hd__and3_1
X_05382_ _01883_ _01885_ VGND VGND VPWR VPWR _01886_ sky130_fd_sc_hd__nor2_1
XFILLER_9_393 VGND VGND VPWR VPWR sky130_fd_sc_hd__decap_3
Xclkbuf_leaf_121_clk clknet_4_8_0_clk VGND VGND VPWR VPWR clknet_leaf_121_clk sky130_fd_sc_hd__clkbuf_8
XFILLER_134_718 VPWR VGND VPWR VGND sky130_ef_sc_hd__decap_12
X_07052_ net679 _03258_ VGND VGND VPWR VPWR _03259_ sky130_fd_sc_hd__nand2_1
Xoutput101 net101 VGND VGND VPWR VPWR mem_axi_awvalid sky130_fd_sc_hd__buf_2
XFILLER_127_781 VGND VGND VPWR VPWR sky130_fd_sc_hd__decap_3
X_06003_ net609 _02143_ _02144_ net571 _02467_ VGND VGND VPWR VPWR _02468_ sky130_fd_sc_hd__a221o_1
Xoutput123 net123 VGND VGND VPWR VPWR mem_axi_wdata[27] sky130_fd_sc_hd__buf_2
Xoutput134 net134 VGND VGND VPWR VPWR mem_axi_wdata[8] sky130_fd_sc_hd__buf_2
Xoutput112 net112 VGND VGND VPWR VPWR mem_axi_wdata[17] sky130_fd_sc_hd__buf_2
Xoutput156 net156 VGND VGND VPWR VPWR pcpi_rs1[23] sky130_fd_sc_hd__buf_2
XFILLER_126_291 VGND VGND VPWR VPWR sky130_fd_sc_hd__fill_1
Xoutput145 net796 VGND VGND VPWR VPWR pcpi_rs1[13] sky130_fd_sc_hd__buf_2
Xoutput167 net167 VGND VGND VPWR VPWR pcpi_rs1[4] sky130_fd_sc_hd__buf_2
Xoutput189 net189 VGND VGND VPWR VPWR pcpi_rs2[24] sky130_fd_sc_hd__buf_2
XFILLER_114_475 VGND VGND VPWR VPWR sky130_fd_sc_hd__fill_1
Xoutput178 net178 VGND VGND VPWR VPWR pcpi_rs2[14] sky130_fd_sc_hd__buf_2
X_07954_ picorv32_core.cpuregs\[8\]\[24\] picorv32_core.cpuregs\[9\]\[24\] picorv32_core.cpuregs\[10\]\[24\]
+ picorv32_core.cpuregs\[11\]\[24\] net752 net719 VGND VGND VPWR VPWR _04035_ sky130_fd_sc_hd__mux4_1
XFILLER_101_136 VGND VGND VPWR VPWR sky130_fd_sc_hd__decap_3
XFILLER_87_337 VGND VGND VPWR VPWR sky130_fd_sc_hd__decap_4
XTAP_TAPCELL_ROW_126_2139 VGND VPWR sky130_fd_sc_hd__tapvpwrvgnd_1
XTAP_TAPCELL_ROW_126_2128 VGND VPWR sky130_fd_sc_hd__tapvpwrvgnd_1
X_07885_ _03963_ _03968_ _03969_ net684 net689 VGND VGND VPWR VPWR _03970_ sky130_fd_sc_hd__a221o_1
XFILLER_110_670 VGND VGND VPWR VPWR sky130_fd_sc_hd__decap_8
X_06905_ _03118_ _03121_ VGND VGND VPWR VPWR _03124_ sky130_fd_sc_hd__or2_1
XTAP_TAPCELL_ROW_52_1061 VGND VPWR sky130_fd_sc_hd__tapvpwrvgnd_1
X_09624_ net784 net544 _04738_ net470 VGND VGND VPWR VPWR _04803_ sky130_fd_sc_hd__o211a_1
X_06836_ _03047_ _03050_ _03046_ VGND VGND VPWR VPWR _03060_ sky130_fd_sc_hd__o21ba_1
XFILLER_56_746 VGND VGND VPWR VPWR sky130_fd_sc_hd__fill_1
XFILLER_83_565 VPWR VGND VPWR VGND sky130_ef_sc_hd__decap_12
XTAP_TAPCELL_ROW_108_1872 VGND VPWR sky130_fd_sc_hd__tapvpwrvgnd_1
X_09555_ _03499_ _03501_ _04736_ VGND VGND VPWR VPWR _04737_ sky130_fd_sc_hd__a21oi_1
XFILLER_55_289 VGND VGND VPWR VPWR sky130_fd_sc_hd__fill_2
X_06767_ net665 picorv32_core.reg_next_pc\[6\] _02918_ net491 VGND VGND VPWR VPWR
+ _02997_ sky130_fd_sc_hd__a22o_1
X_08506_ net1648 net226 net409 VGND VGND VPWR VPWR _00636_ sky130_fd_sc_hd__mux2_1
X_06698_ net2339 net553 _02938_ net516 VGND VGND VPWR VPWR _00224_ sky130_fd_sc_hd__a22o_1
X_09486_ net488 _04655_ _04658_ _04671_ VGND VGND VPWR VPWR _04672_ sky130_fd_sc_hd__o31a_1
X_05718_ _02193_ _02199_ _02200_ _02201_ VGND VGND VPWR VPWR _02202_ sky130_fd_sc_hd__and4b_1
X_08437_ net676 picorv32_core.decoded_imm_j\[18\] net616 picorv32_core.mem_rdata_q\[18\]
+ VGND VGND VPWR VPWR _04299_ sky130_fd_sc_hd__a22o_1
XFILLER_12_805 VGND VGND VPWR VPWR sky130_fd_sc_hd__decap_6
X_05649_ _02131_ _02132_ VGND VGND VPWR VPWR _02133_ sky130_fd_sc_hd__nand2_1
XFILLER_11_337 VGND VGND VPWR VPWR sky130_fd_sc_hd__fill_2
X_08368_ net963 net187 net581 VGND VGND VPWR VPWR _04259_ sky130_fd_sc_hd__mux2_1
Xclkbuf_leaf_112_clk clknet_4_8_0_clk VGND VGND VPWR VPWR clknet_leaf_112_clk sky130_fd_sc_hd__clkbuf_8
X_07319_ net819 picorv32_core.decoded_imm\[1\] VGND VGND VPWR VPWR _03459_ sky130_fd_sc_hd__nand2_1
X_08299_ net1139 _00750_ net437 VGND VGND VPWR VPWR _00520_ sky130_fd_sc_hd__mux2_1
XFILLER_125_729 VPWR VGND VPWR VGND sky130_ef_sc_hd__decap_12
X_10330_ clknet_leaf_86_clk _00249_ VGND VGND VPWR VPWR picorv32_core.reg_next_pc\[20\]
+ sky130_fd_sc_hd__dfxtp_1
XFILLER_11_42 VPWR VGND VPWR VGND sky130_ef_sc_hd__decap_12
XFILLER_118_781 VPWR VGND VPWR VGND sky130_ef_sc_hd__decap_12
X_10261_ clknet_leaf_81_clk _00180_ VGND VGND VPWR VPWR picorv32_core.count_instr\[45\]
+ sky130_fd_sc_hd__dfxtp_1
XFILLER_3_514 VGND VGND VPWR VPWR sky130_fd_sc_hd__decap_6
XFILLER_105_442 VGND VGND VPWR VPWR sky130_fd_sc_hd__decap_6
XFILLER_105_431 VGND VGND VPWR VPWR sky130_fd_sc_hd__decap_3
X_10192_ clknet_leaf_13_clk _00111_ VGND VGND VPWR VPWR picorv32_core.cpuregs\[9\]\[8\]
+ sky130_fd_sc_hd__dfxtp_1
Xfanout350 net351 VGND VGND VPWR VPWR net350 sky130_fd_sc_hd__clkbuf_8
Xfanout361 _04343_ VGND VGND VPWR VPWR net361 sky130_fd_sc_hd__buf_4
Xfanout372 net373 VGND VGND VPWR VPWR net372 sky130_fd_sc_hd__clkbuf_8
Xfanout383 _04336_ VGND VGND VPWR VPWR net383 sky130_fd_sc_hd__buf_4
XTAP_TAPCELL_ROW_6_385 VGND VPWR sky130_fd_sc_hd__tapvpwrvgnd_1
XTAP_TAPCELL_ROW_6_396 VGND VPWR sky130_fd_sc_hd__tapvpwrvgnd_1
Xfanout394 net395 VGND VGND VPWR VPWR net394 sky130_fd_sc_hd__clkbuf_8
XFILLER_74_554 VGND VGND VPWR VPWR sky130_fd_sc_hd__decap_8
XTAP_TAPCELL_ROW_83_1511 VGND VPWR sky130_fd_sc_hd__tapvpwrvgnd_1
XFILLER_61_215 VGND VGND VPWR VPWR sky130_fd_sc_hd__fill_1
XFILLER_14_131 VGND VGND VPWR VPWR sky130_fd_sc_hd__fill_1
XTAP_TAPCELL_ROW_45_958 VGND VPWR sky130_fd_sc_hd__tapvpwrvgnd_1
X_11715_ clknet_leaf_98_clk _01546_ VGND VGND VPWR VPWR picorv32_core.instr_jal sky130_fd_sc_hd__dfxtp_1
XFILLER_14_175 VGND VGND VPWR VPWR sky130_fd_sc_hd__fill_1
XFILLER_14_197 VGND VGND VPWR VPWR sky130_fd_sc_hd__fill_1
XTAP_TAPCELL_ROW_25_671 VGND VPWR sky130_fd_sc_hd__tapvpwrvgnd_1
X_11646_ clknet_leaf_41_clk _01477_ VGND VGND VPWR VPWR picorv32_core.cpuregs\[28\]\[27\]
+ sky130_fd_sc_hd__dfxtp_1
X_11577_ clknet_leaf_34_clk _01408_ VGND VGND VPWR VPWR picorv32_core.cpuregs\[2\]\[24\]
+ sky130_fd_sc_hd__dfxtp_1
Xinput14 mem_axi_rdata[19] VGND VGND VPWR VPWR net14 sky130_fd_sc_hd__clkbuf_2
Xinput25 mem_axi_rdata[29] VGND VGND VPWR VPWR net25 sky130_fd_sc_hd__buf_1
Xinput36 mem_axi_rvalid VGND VGND VPWR VPWR net36 sky130_fd_sc_hd__clkbuf_1
Xclkbuf_leaf_103_clk clknet_4_11_0_clk VGND VGND VPWR VPWR clknet_leaf_103_clk sky130_fd_sc_hd__clkbuf_8
Xhold809 picorv32_core.cpuregs\[29\]\[27\] VGND VGND VPWR VPWR net1918 sky130_fd_sc_hd__dlygate4sd3_1
X_10528_ clknet_leaf_89_clk picorv32_core.alu_out\[16\] VGND VGND VPWR VPWR picorv32_core.alu_out_q\[16\]
+ sky130_fd_sc_hd__dfxtp_1
X_10459_ clknet_leaf_64_clk _00346_ VGND VGND VPWR VPWR net51 sky130_fd_sc_hd__dfxtp_1
XTAP_TAPCELL_ROW_94_1673 VGND VPWR sky130_fd_sc_hd__tapvpwrvgnd_1
XTAP_TAPCELL_ROW_94_1662 VGND VPWR sky130_fd_sc_hd__tapvpwrvgnd_1
XFILLER_97_624 VGND VGND VPWR VPWR sky130_fd_sc_hd__decap_8
XFILLER_96_123 VGND VGND VPWR VPWR sky130_fd_sc_hd__fill_1
XFILLER_69_359 VGND VGND VPWR VPWR sky130_fd_sc_hd__fill_2
XFILLER_69_337 VGND VGND VPWR VPWR sky130_fd_sc_hd__fill_2
XFILLER_84_307 VGND VGND VPWR VPWR sky130_fd_sc_hd__fill_1
XFILLER_28_3 VPWR VGND VPWR VGND sky130_ef_sc_hd__decap_12
XFILLER_37_223 VGND VGND VPWR VPWR sky130_fd_sc_hd__fill_1
XFILLER_38_746 VGND VGND VPWR VPWR sky130_fd_sc_hd__decap_6
X_07670_ picorv32_core.decoded_imm\[8\] net590 net594 VGND VGND VPWR VPWR _03767_
+ sky130_fd_sc_hd__a21o_1
X_06621_ _02894_ _02895_ VGND VGND VPWR VPWR _00190_ sky130_fd_sc_hd__nor2_1
XFILLER_80_524 VGND VGND VPWR VPWR sky130_fd_sc_hd__decap_8
XFILLER_53_727 VGND VGND VPWR VPWR sky130_fd_sc_hd__fill_1
XTAP_TAPCELL_ROW_121_2058 VGND VPWR sky130_fd_sc_hd__tapvpwrvgnd_1
X_06552_ net2360 _02849_ _02851_ VGND VGND VPWR VPWR _00165_ sky130_fd_sc_hd__o21a_1
X_09340_ picorv32_core.cpuregs\[20\]\[7\] picorv32_core.cpuregs\[21\]\[7\] picorv32_core.cpuregs\[22\]\[7\]
+ picorv32_core.cpuregs\[23\]\[7\] net877 net844 VGND VGND VPWR VPWR _04532_ sky130_fd_sc_hd__mux4_1
X_05503_ _01995_ _01996_ VGND VGND VPWR VPWR _01998_ sky130_fd_sc_hd__nand2_1
XFILLER_80_579 VGND VGND VPWR VPWR sky130_fd_sc_hd__fill_1
X_09271_ _04464_ _04465_ net837 VGND VGND VPWR VPWR _04466_ sky130_fd_sc_hd__mux2_1
X_08222_ net2196 net475 _04189_ _04208_ VGND VGND VPWR VPWR _00467_ sky130_fd_sc_hd__a22o_1
X_06483_ net2356 _02805_ _02807_ VGND VGND VPWR VPWR _00140_ sky130_fd_sc_hd__o21a_1
X_05434_ _01932_ _01933_ VGND VGND VPWR VPWR _01934_ sky130_fd_sc_hd__nor2_1
X_08153_ picorv32_core.mem_rdata_q\[12\] picorv32_core.mem_rdata_q\[13\] net929 VGND
+ VGND VPWR VPWR _04180_ sky130_fd_sc_hd__nor3_2
X_05365_ picorv32_core.count_cycle\[11\] _01652_ net576 _01869_ VGND VGND VPWR VPWR
+ _01870_ sky130_fd_sc_hd__o211a_1
X_08084_ net640 _04147_ _04149_ net686 VGND VGND VPWR VPWR _04158_ sky130_fd_sc_hd__o211a_1
XFILLER_107_729 VGND VGND VPWR VPWR sky130_fd_sc_hd__fill_1
X_07104_ picorv32_core.count_cycle\[10\] _03294_ picorv32_core.count_cycle\[11\] VGND
+ VGND VPWR VPWR _03297_ sky130_fd_sc_hd__a21o_1
X_07035_ net932 _02940_ VGND VGND VPWR VPWR _03243_ sky130_fd_sc_hd__xnor2_1
X_05296_ picorv32_core.reg_pc\[7\] picorv32_core.decoded_imm\[7\] VGND VGND VPWR VPWR
+ _01805_ sky130_fd_sc_hd__nor2_1
XFILLER_114_283 VGND VGND VPWR VPWR sky130_fd_sc_hd__fill_1
X_08986_ _02795_ _04346_ VGND VGND VPWR VPWR _04347_ sky130_fd_sc_hd__or2_2
X_07937_ picorv32_core.cpuregs\[16\]\[23\] picorv32_core.cpuregs\[17\]\[23\] picorv32_core.cpuregs\[18\]\[23\]
+ picorv32_core.cpuregs\[19\]\[23\] net757 net724 VGND VGND VPWR VPWR _04019_ sky130_fd_sc_hd__mux4_1
XTAP_TAPCELL_ROW_3_344 VGND VPWR sky130_fd_sc_hd__tapvpwrvgnd_1
X_07868_ net696 _03949_ _03948_ net620 VGND VGND VPWR VPWR _03954_ sky130_fd_sc_hd__o211a_1
XTAP_TAPCELL_ROW_3_355 VGND VPWR sky130_fd_sc_hd__tapvpwrvgnd_1
XFILLER_113_66 VGND VGND VPWR VPWR sky130_fd_sc_hd__fill_1
X_07799_ picorv32_core.cpuregs\[16\]\[16\] picorv32_core.cpuregs\[17\]\[16\] picorv32_core.cpuregs\[18\]\[16\]
+ picorv32_core.cpuregs\[19\]\[16\] net750 net717 VGND VGND VPWR VPWR _03888_ sky130_fd_sc_hd__mux4_1
X_09607_ net611 _04781_ _04782_ _04786_ VGND VGND VPWR VPWR _04787_ sky130_fd_sc_hd__a31o_1
XFILLER_73_37 VGND VGND VPWR VPWR sky130_fd_sc_hd__decap_8
X_06819_ net588 _03043_ _03044_ VGND VGND VPWR VPWR _03045_ sky130_fd_sc_hd__a21o_1
XFILLER_113_99 VGND VGND VPWR VPWR sky130_fd_sc_hd__decap_3
X_09538_ picorv32_core.cpuregs\[16\]\[16\] picorv32_core.cpuregs\[17\]\[16\] picorv32_core.cpuregs\[18\]\[16\]
+ picorv32_core.cpuregs\[19\]\[16\] net892 net858 VGND VGND VPWR VPWR _04721_ sky130_fd_sc_hd__mux4_1
XTAP_TAPCELL_ROW_65_1241 VGND VPWR sky130_fd_sc_hd__tapvpwrvgnd_1
XTAP_TAPCELL_ROW_139_2319 VGND VPWR sky130_fd_sc_hd__tapvpwrvgnd_1
XTAP_TAPCELL_ROW_65_1252 VGND VPWR sky130_fd_sc_hd__tapvpwrvgnd_1
XTAP_TAPCELL_ROW_42_917 VGND VPWR sky130_fd_sc_hd__tapvpwrvgnd_1
X_11500_ clknet_leaf_55_clk _01336_ VGND VGND VPWR VPWR net149 sky130_fd_sc_hd__dfxtp_1
X_09469_ _04653_ _04654_ VGND VGND VPWR VPWR _04655_ sky130_fd_sc_hd__nor2_1
XFILLER_51_281 VGND VGND VPWR VPWR sky130_fd_sc_hd__fill_1
XFILLER_132_3 VPWR VGND VPWR VGND sky130_ef_sc_hd__decap_12
XFILLER_11_134 VGND VGND VPWR VPWR sky130_fd_sc_hd__decap_3
XFILLER_7_105 VGND VGND VPWR VPWR sky130_fd_sc_hd__decap_6
XTAP_TAPCELL_ROW_22_630 VGND VPWR sky130_fd_sc_hd__tapvpwrvgnd_1
X_11431_ clknet_leaf_6_clk _01267_ VGND VGND VPWR VPWR picorv32_core.cpuregs\[1\]\[14\]
+ sky130_fd_sc_hd__dfxtp_1
XFILLER_22_41 VPWR VGND VPWR VGND sky130_ef_sc_hd__decap_12
XFILLER_138_41 VPWR VGND VPWR VGND sky130_ef_sc_hd__decap_12
X_11362_ clknet_leaf_8_clk _01203_ VGND VGND VPWR VPWR picorv32_core.cpuregs\[18\]\[14\]
+ sky130_fd_sc_hd__dfxtp_1
XFILLER_7_149 VPWR VGND VPWR VGND sky130_ef_sc_hd__decap_12
XFILLER_138_85 VPWR VGND VPWR VGND sky130_ef_sc_hd__decap_12
X_10313_ clknet_leaf_122_clk _00232_ VGND VGND VPWR VPWR picorv32_core.reg_next_pc\[3\]
+ sky130_fd_sc_hd__dfxtp_1
XFILLER_125_559 VGND VGND VPWR VPWR sky130_fd_sc_hd__fill_1
XFILLER_98_67 VGND VGND VPWR VPWR sky130_fd_sc_hd__fill_1
X_11293_ clknet_leaf_22_clk _01141_ VGND VGND VPWR VPWR picorv32_core.cpuregs\[3\]\[16\]
+ sky130_fd_sc_hd__dfxtp_1
X_10244_ clknet_leaf_78_clk _00163_ VGND VGND VPWR VPWR picorv32_core.count_instr\[28\]
+ sky130_fd_sc_hd__dfxtp_1
X_10175_ clknet_leaf_45_clk _00094_ VGND VGND VPWR VPWR picorv32_core.cpuregs\[21\]\[23\]
+ sky130_fd_sc_hd__dfxtp_1
XFILLER_121_765 VPWR VGND VPWR VGND sky130_ef_sc_hd__decap_12
XFILLER_120_253 VGND VGND VPWR VPWR sky130_fd_sc_hd__decap_4
XFILLER_78_156 VGND VGND VPWR VPWR sky130_fd_sc_hd__fill_2
XFILLER_90_811 VGND VGND VPWR VPWR sky130_fd_sc_hd__fill_1
XFILLER_19_278 VGND VGND VPWR VPWR sky130_fd_sc_hd__fill_2
XFILLER_62_557 VGND VGND VPWR VPWR sky130_fd_sc_hd__decap_8
XFILLER_30_421 VGND VGND VPWR VPWR sky130_fd_sc_hd__fill_2
XFILLER_129_821 VPWR VGND VPWR VGND sky130_ef_sc_hd__decap_12
XFILLER_30_443 VGND VGND VPWR VPWR sky130_fd_sc_hd__decap_3
XTAP_TAPCELL_ROW_96_1702 VGND VPWR sky130_fd_sc_hd__tapvpwrvgnd_1
XFILLER_8_65 VPWR VGND VPWR VGND sky130_ef_sc_hd__decap_12
X_11629_ clknet_leaf_12_clk _01460_ VGND VGND VPWR VPWR picorv32_core.cpuregs\[28\]\[10\]
+ sky130_fd_sc_hd__dfxtp_1
X_05150_ net595 _01672_ VGND VGND VPWR VPWR _01678_ sky130_fd_sc_hd__nor2_1
Xhold606 picorv32_core.cpuregs\[7\]\[30\] VGND VGND VPWR VPWR net1715 sky130_fd_sc_hd__dlygate4sd3_1
XFILLER_116_515 VGND VGND VPWR VPWR sky130_fd_sc_hd__fill_2
Xhold617 picorv32_core.cpuregs\[2\]\[5\] VGND VGND VPWR VPWR net1726 sky130_fd_sc_hd__dlygate4sd3_1
Xhold628 picorv32_core.cpuregs\[6\]\[26\] VGND VGND VPWR VPWR net1737 sky130_fd_sc_hd__dlygate4sd3_1
X_05081_ net835 VGND VGND VPWR VPWR _01616_ sky130_fd_sc_hd__inv_2
Xhold639 picorv32_core.cpuregs\[6\]\[10\] VGND VGND VPWR VPWR net1748 sky130_fd_sc_hd__dlygate4sd3_1
XFILLER_112_754 VGND VGND VPWR VPWR sky130_fd_sc_hd__fill_2
X_08840_ net1928 net251 net367 VGND VGND VPWR VPWR _01016_ sky130_fd_sc_hd__mux2_1
XFILLER_69_134 VGND VGND VPWR VPWR sky130_fd_sc_hd__fill_2
XFILLER_111_253 VGND VGND VPWR VPWR sky130_fd_sc_hd__decap_3
X_08771_ net260 net2130 net375 VGND VGND VPWR VPWR _00918_ sky130_fd_sc_hd__mux2_1
X_05983_ net182 _02448_ VGND VGND VPWR VPWR _02449_ sky130_fd_sc_hd__xnor2_1
XTAP_TAPCELL_ROW_0_303 VGND VPWR sky130_fd_sc_hd__tapvpwrvgnd_1
X_07722_ _03810_ _03814_ _03815_ net682 net687 VGND VGND VPWR VPWR _03816_ sky130_fd_sc_hd__a221o_1
XFILLER_38_576 VGND VGND VPWR VPWR sky130_fd_sc_hd__decap_4
X_07653_ picorv32_core.cpuregs\[24\]\[8\] picorv32_core.cpuregs\[25\]\[8\] picorv32_core.cpuregs\[26\]\[8\]
+ picorv32_core.cpuregs\[27\]\[8\] net739 net706 VGND VGND VPWR VPWR _03750_ sky130_fd_sc_hd__mux4_1
XTAP_TAPCELL_ROW_105_1831 VGND VPWR sky130_fd_sc_hd__tapvpwrvgnd_1
XFILLER_92_192 VGND VGND VPWR VPWR sky130_fd_sc_hd__decap_4
X_06604_ net993 _02883_ _02884_ VGND VGND VPWR VPWR _00184_ sky130_fd_sc_hd__and3_1
X_09323_ picorv32_core.cpuregs\[8\]\[6\] picorv32_core.cpuregs\[9\]\[6\] picorv32_core.cpuregs\[10\]\[6\]
+ picorv32_core.cpuregs\[11\]\[6\] net874 net841 VGND VGND VPWR VPWR _04516_ sky130_fd_sc_hd__mux4_1
X_07584_ net624 _03683_ _03687_ VGND VGND VPWR VPWR _03688_ sky130_fd_sc_hd__a21oi_1
X_06535_ picorv32_core.count_instr\[24\] _02839_ net978 VGND VGND VPWR VPWR _02841_
+ sky130_fd_sc_hd__a21oi_1
X_06466_ net213 net1724 net420 VGND VGND VPWR VPWR _00132_ sky130_fd_sc_hd__mux2_1
X_09254_ net913 net808 net540 net469 VGND VGND VPWR VPWR _04450_ sky130_fd_sc_hd__a31o_1
XFILLER_138_139 VGND VGND VPWR VPWR sky130_fd_sc_hd__fill_1
X_05417_ _01916_ _01917_ VGND VGND VPWR VPWR _01918_ sky130_fd_sc_hd__xnor2_1
XTAP_TAPCELL_ROW_60_1171 VGND VPWR sky130_fd_sc_hd__tapvpwrvgnd_1
X_09185_ _04380_ _04382_ _04379_ _04381_ net656 net853 VGND VGND VPWR VPWR _04383_
+ sky130_fd_sc_hd__mux4_1
X_08205_ net949 _04205_ _04206_ net1139 VGND VGND VPWR VPWR _00454_ sky130_fd_sc_hd__a22o_1
Xpicorv32_axi_1027 VGND VGND VPWR VPWR picorv32_axi_1027/HI eoi[28] sky130_fd_sc_hd__conb_1
Xpicorv32_axi_1016 VGND VGND VPWR VPWR picorv32_axi_1016/HI eoi[17] sky130_fd_sc_hd__conb_1
XTAP_TAPCELL_ROW_134_2249 VGND VPWR sky130_fd_sc_hd__tapvpwrvgnd_1
X_08136_ net207 net2035 net417 VGND VGND VPWR VPWR _00429_ sky130_fd_sc_hd__mux2_1
X_06397_ picorv32_core.reg_out\[31\] picorv32_core.alu_out_q\[31\] net953 VGND VGND
+ VPWR VPWR _02792_ sky130_fd_sc_hd__mux2_1
XTAP_TAPCELL_ROW_60_1182 VGND VPWR sky130_fd_sc_hd__tapvpwrvgnd_1
Xpicorv32_axi_1005 VGND VGND VPWR VPWR picorv32_axi_1005/HI eoi[6] sky130_fd_sc_hd__conb_1
Xpicorv32_axi_1049 VGND VGND VPWR VPWR picorv32_axi_1049/HI pcpi_insn[9] sky130_fd_sc_hd__conb_1
XFILLER_107_537 VGND VGND VPWR VPWR sky130_fd_sc_hd__fill_2
X_05348_ picorv32_core.reg_pc\[10\] picorv32_core.decoded_imm\[10\] VGND VGND VPWR
+ VPWR _01854_ sky130_fd_sc_hd__or2_1
Xpicorv32_axi_1038 VGND VGND VPWR VPWR picorv32_axi_1038/HI mem_axi_awprot[1] sky130_fd_sc_hd__conb_1
X_08067_ net686 _04140_ net626 VGND VGND VPWR VPWR _04142_ sky130_fd_sc_hd__a21o_1
X_05279_ _01781_ _01782_ _01789_ VGND VGND VPWR VPWR _01574_ sky130_fd_sc_hd__a21o_1
XTAP_TAPCELL_ROW_116_1993 VGND VPWR sky130_fd_sc_hd__tapvpwrvgnd_1
XTAP_TAPCELL_ROW_116_1982 VGND VPWR sky130_fd_sc_hd__tapvpwrvgnd_1
X_07018_ net587 _03227_ VGND VGND VPWR VPWR _03228_ sky130_fd_sc_hd__nor2_1
XTAP_TAPCELL_ROW_8_425 VGND VPWR sky130_fd_sc_hd__tapvpwrvgnd_1
XTAP_TAPCELL_ROW_8_414 VGND VPWR sky130_fd_sc_hd__tapvpwrvgnd_1
XFILLER_88_421 VGND VGND VPWR VPWR sky130_fd_sc_hd__fill_1
XFILLER_102_242 VGND VGND VPWR VPWR sky130_fd_sc_hd__fill_2
X_08969_ net1935 net266 net350 VGND VGND VPWR VPWR _01141_ sky130_fd_sc_hd__mux2_1
XFILLER_69_690 VGND VGND VPWR VPWR sky130_fd_sc_hd__decap_3
XFILLER_75_159 VGND VGND VPWR VPWR sky130_fd_sc_hd__fill_1
XFILLER_29_543 VGND VGND VPWR VPWR sky130_fd_sc_hd__fill_1
XFILLER_17_30 VPWR VGND VPWR VGND sky130_ef_sc_hd__decap_12
XTAP_TAPCELL_ROW_27_700 VGND VPWR sky130_fd_sc_hd__tapvpwrvgnd_1
XFILLER_29_598 VGND VGND VPWR VPWR sky130_fd_sc_hd__fill_1
X_10931_ clknet_leaf_144_clk _00782_ VGND VGND VPWR VPWR picorv32_core.cpuregs\[19\]\[9\]
+ sky130_fd_sc_hd__dfxtp_1
XFILLER_140_53 VPWR VGND VPWR VGND sky130_ef_sc_hd__decap_12
X_10862_ clknet_leaf_0_clk _00713_ VGND VGND VPWR VPWR picorv32_core.cpuregs\[16\]\[6\]
+ sky130_fd_sc_hd__dfxtp_1
XFILLER_140_97 VPWR VGND VPWR VGND sky130_ef_sc_hd__decap_12
X_10793_ clknet_leaf_136_clk _00644_ VGND VGND VPWR VPWR picorv32_core.cpuregs\[15\]\[2\]
+ sky130_fd_sc_hd__dfxtp_1
XFILLER_40_730 VGND VGND VPWR VPWR sky130_fd_sc_hd__decap_8
XFILLER_129_117 VGND VGND VPWR VPWR sky130_fd_sc_hd__fill_1
XFILLER_126_813 VPWR VGND VPWR VGND sky130_ef_sc_hd__decap_12
X_11414_ clknet_leaf_70_clk _01250_ VGND VGND VPWR VPWR picorv32_core.cpuregs\[31\]\[29\]
+ sky130_fd_sc_hd__dfxtp_1
XTAP_TAPCELL_ROW_78_1443 VGND VPWR sky130_fd_sc_hd__tapvpwrvgnd_1
XTAP_TAPCELL_ROW_78_1432 VGND VPWR sky130_fd_sc_hd__tapvpwrvgnd_1
X_11345_ clknet_leaf_75_clk _01186_ VGND VGND VPWR VPWR picorv32_core.cpuregs\[29\]\[29\]
+ sky130_fd_sc_hd__dfxtp_1
XFILLER_99_719 VGND VGND VPWR VPWR sky130_fd_sc_hd__decap_3
X_11276_ clknet_leaf_68_clk _01124_ VGND VGND VPWR VPWR picorv32_core.cpuregs\[4\]\[31\]
+ sky130_fd_sc_hd__dfxtp_1
XTAP_TAPCELL_ROW_91_1621 VGND VPWR sky130_fd_sc_hd__tapvpwrvgnd_1
XPHY_EDGE_ROW_18_Left_160 VGND VGND VPWR VPWR sky130_fd_sc_hd__decap_3
X_10227_ clknet_leaf_100_clk _00146_ VGND VGND VPWR VPWR picorv32_core.count_instr\[11\]
+ sky130_fd_sc_hd__dfxtp_1
XFILLER_4_697 VGND VGND VPWR VPWR sky130_fd_sc_hd__decap_3
Xhold3 picorv32_core.cpuregs\[0\]\[1\] VGND VGND VPWR VPWR net1112 sky130_fd_sc_hd__dlygate4sd3_1
X_10158_ clknet_leaf_141_clk _00077_ VGND VGND VPWR VPWR picorv32_core.cpuregs\[21\]\[6\]
+ sky130_fd_sc_hd__dfxtp_1
XFILLER_12_6 VPWR VGND VPWR VGND sky130_ef_sc_hd__decap_12
X_10089_ net1118 VGND VGND VPWR VPWR _00939_ sky130_fd_sc_hd__clkbuf_1
XTAP_TAPCELL_ROW_89_1594 VGND VPWR sky130_fd_sc_hd__tapvpwrvgnd_1
XFILLER_95_3 VPWR VGND VPWR VGND sky130_ef_sc_hd__decap_12
XFILLER_16_793 VPWR VGND VPWR VGND sky130_ef_sc_hd__decap_12
X_06320_ picorv32_core.reg_pc\[16\] _02726_ VGND VGND VPWR VPWR _02730_ sky130_fd_sc_hd__xor2_1
XFILLER_15_281 VGND VGND VPWR VPWR sky130_fd_sc_hd__decap_3
XFILLER_15_292 VGND VGND VPWR VPWR sky130_fd_sc_hd__fill_2
XTAP_TAPCELL_ROW_100_1761 VGND VPWR sky130_fd_sc_hd__tapvpwrvgnd_1
XTAP_TAPCELL_ROW_100_1750 VGND VPWR sky130_fd_sc_hd__tapvpwrvgnd_1
X_06251_ net1617 net497 net434 VGND VGND VPWR VPWR _00041_ sky130_fd_sc_hd__mux2_1
XFILLER_30_251 VGND VGND VPWR VPWR sky130_fd_sc_hd__fill_1
XFILLER_31_785 VPWR VGND VPWR VGND sky130_ef_sc_hd__decap_12
Xclkbuf_4_4_0_clk clknet_0_clk VGND VGND VPWR VPWR clknet_4_4_0_clk sky130_fd_sc_hd__clkbuf_8
X_05202_ _01595_ _01596_ VGND VGND VPWR VPWR _01718_ sky130_fd_sc_hd__nor2_2
XTAP_TAPCELL_ROW_13_493 VGND VPWR sky130_fd_sc_hd__tapvpwrvgnd_1
X_06182_ _02612_ _02613_ net631 VGND VGND VPWR VPWR _02614_ sky130_fd_sc_hd__mux2_1
Xhold425 picorv32_core.cpuregs\[15\]\[27\] VGND VGND VPWR VPWR net1534 sky130_fd_sc_hd__dlygate4sd3_1
XFILLER_132_805 VGND VGND VPWR VPWR sky130_fd_sc_hd__decap_6
Xhold436 picorv32_core.cpuregs\[11\]\[24\] VGND VGND VPWR VPWR net1545 sky130_fd_sc_hd__dlygate4sd3_1
Xhold403 picorv32_core.cpuregs\[22\]\[4\] VGND VGND VPWR VPWR net1512 sky130_fd_sc_hd__dlygate4sd3_1
Xhold414 picorv32_core.cpuregs\[27\]\[3\] VGND VGND VPWR VPWR net1523 sky130_fd_sc_hd__dlygate4sd3_1
X_05133_ net975 _01590_ VGND VGND VPWR VPWR _01664_ sky130_fd_sc_hd__nor2_1
X_05064_ net768 VGND VGND VPWR VPWR _01599_ sky130_fd_sc_hd__inv_2
Xhold447 picorv32_core.cpuregs\[1\]\[3\] VGND VGND VPWR VPWR net1556 sky130_fd_sc_hd__dlygate4sd3_1
X_09941_ net1513 net499 net317 VGND VGND VPWR VPWR _01419_ sky130_fd_sc_hd__mux2_1
Xhold458 picorv32_core.cpuregs\[31\]\[9\] VGND VGND VPWR VPWR net1567 sky130_fd_sc_hd__dlygate4sd3_1
Xhold469 picorv32_core.cpuregs\[28\]\[10\] VGND VGND VPWR VPWR net1578 sky130_fd_sc_hd__dlygate4sd3_1
XFILLER_131_337 VGND VGND VPWR VPWR sky130_fd_sc_hd__fill_1
Xfanout905 net906 VGND VGND VPWR VPWR net905 sky130_fd_sc_hd__buf_2
Xfanout916 net918 VGND VGND VPWR VPWR net916 sky130_fd_sc_hd__clkbuf_4
Xfanout938 picorv32_core.instr_rdinstrh VGND VGND VPWR VPWR net938 sky130_fd_sc_hd__buf_2
Xfanout927 picorv32_core.mem_wordsize\[2\] VGND VGND VPWR VPWR net927 sky130_fd_sc_hd__clkbuf_4
Xfanout949 picorv32_core.latched_rd\[2\] VGND VGND VPWR VPWR net949 sky130_fd_sc_hd__clkbuf_4
X_09872_ net1366 net296 net324 VGND VGND VPWR VPWR _01360_ sky130_fd_sc_hd__mux2_1
X_08823_ net1388 net496 net369 VGND VGND VPWR VPWR _00999_ sky130_fd_sc_hd__mux2_1
Xhold1114 picorv32_core.cpuregs\[25\]\[1\] VGND VGND VPWR VPWR net2223 sky130_fd_sc_hd__dlygate4sd3_1
XFILLER_38_29 VGND VGND VPWR VPWR sky130_fd_sc_hd__decap_6
Xhold1103 picorv32_core.cpuregs\[16\]\[10\] VGND VGND VPWR VPWR net2212 sky130_fd_sc_hd__dlygate4sd3_1
Xhold1125 picorv32_core.cpuregs\[16\]\[23\] VGND VGND VPWR VPWR net2234 sky130_fd_sc_hd__dlygate4sd3_1
Xhold1158 picorv32_core.count_instr\[29\] VGND VGND VPWR VPWR net2267 sky130_fd_sc_hd__dlygate4sd3_1
Xhold1147 picorv32_core.count_instr\[55\] VGND VGND VPWR VPWR net2256 sky130_fd_sc_hd__dlygate4sd3_1
X_05966_ _02432_ _02433_ VGND VGND VPWR VPWR _02434_ sky130_fd_sc_hd__and2_1
Xhold1136 picorv32_core.instr_lw VGND VGND VPWR VPWR net2245 sky130_fd_sc_hd__dlygate4sd3_1
X_08754_ net503 net1897 net377 VGND VGND VPWR VPWR _00901_ sky130_fd_sc_hd__mux2_1
XFILLER_72_107 VGND VGND VPWR VPWR sky130_fd_sc_hd__fill_2
Xhold1169 picorv32_core.instr_bge VGND VGND VPWR VPWR net2278 sky130_fd_sc_hd__dlygate4sd3_1
XTAP_TAPCELL_ROW_49_1011 VGND VPWR sky130_fd_sc_hd__tapvpwrvgnd_1
XFILLER_26_513 VGND VGND VPWR VPWR sky130_fd_sc_hd__fill_2
X_07705_ net692 _03795_ _03794_ net617 VGND VGND VPWR VPWR _03800_ sky130_fd_sc_hd__o211a_1
X_08685_ net210 net1872 net389 VGND VGND VPWR VPWR _00835_ sky130_fd_sc_hd__mux2_1
XFILLER_72_129 VGND VGND VPWR VPWR sky130_fd_sc_hd__decap_3
Xclkbuf_leaf_92_clk clknet_4_9_0_clk VGND VGND VPWR VPWR clknet_leaf_92_clk sky130_fd_sc_hd__clkbuf_8
X_05897_ _02367_ _02369_ VGND VGND VPWR VPWR _02370_ sky130_fd_sc_hd__nand2_1
XTAP_TAPCELL_ROW_49_1022 VGND VPWR sky130_fd_sc_hd__tapvpwrvgnd_1
XFILLER_53_354 VGND VGND VPWR VPWR sky130_fd_sc_hd__decap_8
X_07636_ picorv32_core.cpuregs\[28\]\[7\] picorv32_core.cpuregs\[29\]\[7\] picorv32_core.cpuregs\[30\]\[7\]
+ picorv32_core.cpuregs\[31\]\[7\] net734 net701 VGND VGND VPWR VPWR _03734_ sky130_fd_sc_hd__mux4_1
XFILLER_41_505 VGND VGND VPWR VPWR sky130_fd_sc_hd__fill_2
XTAP_TAPCELL_ROW_62_1211 VGND VPWR sky130_fd_sc_hd__tapvpwrvgnd_1
XTAP_TAPCELL_ROW_62_1200 VGND VPWR sky130_fd_sc_hd__tapvpwrvgnd_1
X_07567_ picorv32_core.decoded_imm\[0\] _03671_ _01682_ VGND VGND VPWR VPWR _03672_
+ sky130_fd_sc_hd__mux2_1
X_06518_ net2333 _02828_ net991 VGND VGND VPWR VPWR _02830_ sky130_fd_sc_hd__o21ai_1
XFILLER_22_730 VPWR VGND VPWR VGND sky130_ef_sc_hd__decap_12
X_09306_ picorv32_core.reg_pc\[5\] net536 _04499_ net482 VGND VGND VPWR VPWR _04500_
+ sky130_fd_sc_hd__a211o_1
X_07498_ net784 _03619_ net534 VGND VGND VPWR VPWR _03620_ sky130_fd_sc_hd__mux2_1
X_09237_ net656 _04432_ VGND VGND VPWR VPWR _04433_ sky130_fd_sc_hd__and2_1
X_06449_ net288 net1834 net418 VGND VGND VPWR VPWR _00115_ sky130_fd_sc_hd__mux2_1
XFILLER_108_835 VGND VGND VPWR VPWR sky130_fd_sc_hd__fill_2
XFILLER_108_813 VGND VGND VPWR VPWR sky130_fd_sc_hd__decap_8
X_09168_ net649 _04366_ VGND VGND VPWR VPWR _04367_ sky130_fd_sc_hd__nand2_1
X_08119_ net274 net2074 net416 VGND VGND VPWR VPWR _00412_ sky130_fd_sc_hd__mux2_1
X_09099_ net276 net2227 net332 VGND VGND VPWR VPWR _01266_ sky130_fd_sc_hd__mux2_1
XFILLER_135_698 VPWR VGND VPWR VGND sky130_ef_sc_hd__decap_12
XFILLER_107_389 VGND VGND VPWR VPWR sky130_fd_sc_hd__decap_3
X_11130_ clknet_leaf_19_clk _00981_ VGND VGND VPWR VPWR picorv32_core.cpuregs\[8\]\[16\]
+ sky130_fd_sc_hd__dfxtp_1
XFILLER_1_601 VPWR VGND VPWR VGND sky130_ef_sc_hd__decap_12
Xhold981 picorv32_core.cpuregs\[17\]\[20\] VGND VGND VPWR VPWR net2090 sky130_fd_sc_hd__dlygate4sd3_1
Xhold970 picorv32_core.cpuregs\[21\]\[4\] VGND VGND VPWR VPWR net2079 sky130_fd_sc_hd__dlygate4sd3_1
Xhold992 picorv32_core.cpuregs\[18\]\[17\] VGND VGND VPWR VPWR net2101 sky130_fd_sc_hd__dlygate4sd3_1
XTAP_TAPCELL_ROW_73_1362 VGND VPWR sky130_fd_sc_hd__tapvpwrvgnd_1
X_11061_ clknet_leaf_2_clk _00912_ VGND VGND VPWR VPWR picorv32_core.cpuregs\[10\]\[11\]
+ sky130_fd_sc_hd__dfxtp_1
XFILLER_76_435 VGND VGND VPWR VPWR sky130_fd_sc_hd__decap_8
X_10012_ net1549 net446 net308 VGND VGND VPWR VPWR _01488_ sky130_fd_sc_hd__mux2_1
XFILLER_130_392 VGND VGND VPWR VPWR sky130_fd_sc_hd__fill_1
XFILLER_91_427 VGND VGND VPWR VPWR sky130_fd_sc_hd__decap_4
XFILLER_57_671 VGND VGND VPWR VPWR sky130_fd_sc_hd__fill_1
Xclkbuf_leaf_83_clk clknet_4_14_0_clk VGND VGND VPWR VPWR clknet_leaf_83_clk sky130_fd_sc_hd__clkbuf_8
XFILLER_17_557 VGND VGND VPWR VPWR sky130_fd_sc_hd__decap_3
X_10914_ clknet_leaf_94_clk _00765_ VGND VGND VPWR VPWR picorv32_core.mem_rdata_q\[24\]
+ sky130_fd_sc_hd__dfxtp_1
X_10845_ clknet_leaf_34_clk _00696_ VGND VGND VPWR VPWR picorv32_core.cpuregs\[17\]\[22\]
+ sky130_fd_sc_hd__dfxtp_1
XFILLER_13_741 VPWR VGND VPWR VGND sky130_ef_sc_hd__decap_12
X_10776_ clknet_leaf_25_clk _00627_ VGND VGND VPWR VPWR picorv32_core.cpuregs\[14\]\[17\]
+ sky130_fd_sc_hd__dfxtp_1
XFILLER_13_785 VPWR VGND VPWR VGND sky130_ef_sc_hd__decap_12
XTAP_TAPCELL_ROW_30_739 VGND VPWR sky130_fd_sc_hd__tapvpwrvgnd_1
XFILLER_40_582 VGND VGND VPWR VPWR sky130_fd_sc_hd__fill_2
XFILLER_117_109 VGND VGND VPWR VPWR sky130_fd_sc_hd__decap_3
XTAP_TAPCELL_ROW_10_452 VGND VPWR sky130_fd_sc_hd__tapvpwrvgnd_1
XFILLER_138_492 VGND VGND VPWR VPWR sky130_fd_sc_hd__fill_2
XFILLER_126_643 VGND VGND VPWR VPWR sky130_fd_sc_hd__fill_1
XFILLER_114_805 VGND VGND VPWR VPWR sky130_fd_sc_hd__decap_6
X_11328_ clknet_leaf_10_clk _01169_ VGND VGND VPWR VPWR picorv32_core.cpuregs\[29\]\[12\]
+ sky130_fd_sc_hd__dfxtp_1
XFILLER_113_337 VGND VGND VPWR VPWR sky130_fd_sc_hd__decap_4
X_11259_ clknet_leaf_25_clk _01107_ VGND VGND VPWR VPWR picorv32_core.cpuregs\[4\]\[14\]
+ sky130_fd_sc_hd__dfxtp_1
XFILLER_140_189 VGND VGND VPWR VPWR sky130_fd_sc_hd__decap_6
XFILLER_67_413 VGND VGND VPWR VPWR sky130_fd_sc_hd__decap_8
XFILLER_95_755 VGND VGND VPWR VPWR sky130_fd_sc_hd__fill_1
XFILLER_94_243 VGND VGND VPWR VPWR sky130_fd_sc_hd__fill_1
X_05820_ _02288_ _02290_ _02298_ VGND VGND VPWR VPWR _02299_ sky130_fd_sc_hd__a21bo_1
XFILLER_82_427 VGND VGND VPWR VPWR sky130_fd_sc_hd__decap_8
XFILLER_36_811 VGND VGND VPWR VPWR sky130_fd_sc_hd__fill_1
Xclkbuf_leaf_74_clk clknet_4_15_0_clk VGND VGND VPWR VPWR clknet_leaf_74_clk sky130_fd_sc_hd__clkbuf_8
XFILLER_35_321 VGND VGND VPWR VPWR sky130_fd_sc_hd__decap_3
XFILLER_35_332 VGND VGND VPWR VPWR sky130_fd_sc_hd__decap_4
X_05751_ _02213_ _02217_ _02202_ VGND VGND VPWR VPWR _02235_ sky130_fd_sc_hd__a21bo_1
X_05682_ net764 net196 VGND VGND VPWR VPWR _02166_ sky130_fd_sc_hd__or2_1
X_08470_ net673 picorv32_core.decoded_imm_j\[3\] _04227_ picorv32_core.mem_rdata_q\[23\]
+ net525 VGND VGND VPWR VPWR _04317_ sky130_fd_sc_hd__a221o_1
X_07421_ net902 picorv32_core.cpuregs\[26\]\[31\] VGND VGND VPWR VPWR _03561_ sky130_fd_sc_hd__and2b_1
XTAP_TAPCELL_ROW_18_563 VGND VPWR sky130_fd_sc_hd__tapvpwrvgnd_1
XFILLER_35_387 VGND VGND VPWR VPWR sky130_fd_sc_hd__decap_4
X_07352_ _03429_ _03491_ _03490_ VGND VGND VPWR VPWR _03492_ sky130_fd_sc_hd__a21bo_1
XTAP_TAPCELL_ROW_118_2019 VGND VPWR sky130_fd_sc_hd__tapvpwrvgnd_1
X_06303_ picorv32_core.reg_out\[13\] picorv32_core.alu_out_q\[13\] net951 VGND VGND
+ VPWR VPWR _02716_ sky130_fd_sc_hd__mux2_1
X_07283_ net791 picorv32_core.decoded_imm\[15\] VGND VGND VPWR VPWR _03423_ sky130_fd_sc_hd__and2_1
XFILLER_136_429 VPWR VGND VPWR VGND sky130_ef_sc_hd__decap_12
X_09022_ net495 net1864 net340 VGND VGND VPWR VPWR _01191_ sky130_fd_sc_hd__mux2_1
X_06234_ net981 net613 _01675_ VGND VGND VPWR VPWR _00395_ sky130_fd_sc_hd__and3_1
Xhold200 picorv32_core.cpuregs\[23\]\[27\] VGND VGND VPWR VPWR net1309 sky130_fd_sc_hd__dlygate4sd3_1
XTAP_TAPCELL_ROW_131_2208 VGND VPWR sky130_fd_sc_hd__tapvpwrvgnd_1
Xhold211 picorv32_core.cpuregs\[11\]\[0\] VGND VGND VPWR VPWR net1320 sky130_fd_sc_hd__dlygate4sd3_1
X_06165_ picorv32_core.mem_rdata_q\[23\] net19 net518 VGND VGND VPWR VPWR _00764_
+ sky130_fd_sc_hd__mux2_1
Xhold233 picorv32_core.cpuregs\[24\]\[15\] VGND VGND VPWR VPWR net1342 sky130_fd_sc_hd__dlygate4sd3_1
X_05116_ _01639_ _01641_ _01647_ VGND VGND VPWR VPWR _00018_ sky130_fd_sc_hd__a21o_1
Xhold222 picorv32_core.cpuregs\[22\]\[6\] VGND VGND VPWR VPWR net1331 sky130_fd_sc_hd__dlygate4sd3_1
Xhold244 picorv32_core.cpuregs\[11\]\[9\] VGND VGND VPWR VPWR net1353 sky130_fd_sc_hd__dlygate4sd3_1
Xhold277 picorv32_core.cpuregs\[27\]\[21\] VGND VGND VPWR VPWR net1386 sky130_fd_sc_hd__dlygate4sd3_1
XFILLER_116_197 VGND VGND VPWR VPWR sky130_fd_sc_hd__fill_2
XTAP_TAPCELL_ROW_113_1941 VGND VPWR sky130_fd_sc_hd__tapvpwrvgnd_1
X_06096_ _01599_ _02551_ VGND VGND VPWR VPWR _02553_ sky130_fd_sc_hd__nand2_1
Xhold266 picorv32_core.cpuregs\[29\]\[15\] VGND VGND VPWR VPWR net1375 sky130_fd_sc_hd__dlygate4sd3_1
Xhold255 picorv32_core.cpuregs\[26\]\[2\] VGND VGND VPWR VPWR net1364 sky130_fd_sc_hd__dlygate4sd3_1
Xhold288 picorv32_core.cpuregs\[15\]\[30\] VGND VGND VPWR VPWR net1397 sky130_fd_sc_hd__dlygate4sd3_1
Xhold299 picorv32_core.cpuregs\[19\]\[24\] VGND VGND VPWR VPWR net1408 sky130_fd_sc_hd__dlygate4sd3_1
X_09924_ net232 net1862 net322 VGND VGND VPWR VPWR _01408_ sky130_fd_sc_hd__mux2_1
Xfanout724 net725 VGND VGND VPWR VPWR net724 sky130_fd_sc_hd__buf_2
Xfanout713 _00001_ VGND VGND VPWR VPWR net713 sky130_fd_sc_hd__clkbuf_2
Xfanout702 net708 VGND VGND VPWR VPWR net702 sky130_fd_sc_hd__clkbuf_2
X_05047_ picorv32_core.mem_do_rinst VGND VGND VPWR VPWR _01582_ sky130_fd_sc_hd__inv_2
X_09855_ _05020_ _05021_ net661 VGND VGND VPWR VPWR _05024_ sky130_fd_sc_hd__mux2_1
Xfanout757 net758 VGND VGND VPWR VPWR net757 sky130_fd_sc_hd__clkbuf_4
XFILLER_98_582 VGND VGND VPWR VPWR sky130_fd_sc_hd__decap_6
Xfanout746 _00000_ VGND VGND VPWR VPWR net746 sky130_fd_sc_hd__buf_2
Xfanout735 net741 VGND VGND VPWR VPWR net735 sky130_fd_sc_hd__clkbuf_2
Xfanout768 net160 VGND VGND VPWR VPWR net768 sky130_fd_sc_hd__clkbuf_4
X_08806_ net253 net1967 net373 VGND VGND VPWR VPWR _00984_ sky130_fd_sc_hd__mux2_1
Xfanout779 net780 VGND VGND VPWR VPWR net779 sky130_fd_sc_hd__buf_2
X_09786_ picorv32_core.cpuregs\[12\]\[27\] picorv32_core.cpuregs\[13\]\[27\] picorv32_core.cpuregs\[14\]\[27\]
+ picorv32_core.cpuregs\[15\]\[27\] net898 net864 VGND VGND VPWR VPWR _04958_ sky130_fd_sc_hd__mux4_1
X_06998_ _03165_ _03181_ _03208_ VGND VGND VPWR VPWR _03209_ sky130_fd_sc_hd__and3_1
XFILLER_65_38 VGND VGND VPWR VPWR sky130_fd_sc_hd__decap_3
XFILLER_39_671 VGND VGND VPWR VPWR sky130_fd_sc_hd__fill_1
XPHY_EDGE_ROW_134_Right_134 VGND VGND VPWR VPWR sky130_fd_sc_hd__decap_3
Xclkbuf_leaf_65_clk clknet_4_13_0_clk VGND VGND VPWR VPWR clknet_leaf_65_clk sky130_fd_sc_hd__clkbuf_8
X_08737_ net1371 net264 net379 VGND VGND VPWR VPWR _00885_ sky130_fd_sc_hd__mux2_1
XFILLER_73_449 VGND VGND VPWR VPWR sky130_fd_sc_hd__fill_2
X_05949_ _02415_ _02416_ VGND VGND VPWR VPWR _02418_ sky130_fd_sc_hd__nand2_1
X_08668_ net278 net2114 net386 VGND VGND VPWR VPWR _00818_ sky130_fd_sc_hd__mux2_1
XFILLER_38_192 VGND VGND VPWR VPWR sky130_fd_sc_hd__decap_4
XFILLER_81_482 VGND VGND VPWR VPWR sky130_fd_sc_hd__fill_1
X_07619_ picorv32_core.cpuregs\[24\]\[6\] picorv32_core.cpuregs\[25\]\[6\] picorv32_core.cpuregs\[26\]\[6\]
+ picorv32_core.cpuregs\[27\]\[6\] net732 net699 VGND VGND VPWR VPWR _03718_ sky130_fd_sc_hd__mux4_1
XFILLER_42_836 VGND VGND VPWR VPWR sky130_fd_sc_hd__fill_1
X_10630_ clknet_leaf_84_clk _00484_ VGND VGND VPWR VPWR picorv32_core.decoded_imm_j\[19\]
+ sky130_fd_sc_hd__dfxtp_1
X_08599_ net271 net1410 net396 VGND VGND VPWR VPWR _00722_ sky130_fd_sc_hd__mux2_1
XFILLER_14_549 VGND VGND VPWR VPWR sky130_fd_sc_hd__fill_1
XFILLER_14_53 VPWR VGND VPWR VGND sky130_ef_sc_hd__decap_12
X_10561_ clknet_leaf_22_clk _00415_ VGND VGND VPWR VPWR picorv32_core.cpuregs\[25\]\[17\]
+ sky130_fd_sc_hd__dfxtp_1
X_10492_ clknet_leaf_54_clk _00378_ VGND VGND VPWR VPWR net182 sky130_fd_sc_hd__dfxtp_2
XFILLER_6_737 VPWR VGND VPWR VGND sky130_ef_sc_hd__decap_12
XFILLER_5_225 VGND VGND VPWR VPWR sky130_fd_sc_hd__decap_4
XFILLER_135_462 VGND VGND VPWR VPWR sky130_fd_sc_hd__fill_1
XFILLER_123_635 VGND VGND VPWR VPWR sky130_fd_sc_hd__decap_4
X_11113_ clknet_leaf_68_clk _00964_ VGND VGND VPWR VPWR picorv32_core.cpuregs\[0\]\[31\]
+ sky130_fd_sc_hd__dfxtp_1
XFILLER_122_134 VGND VGND VPWR VPWR sky130_fd_sc_hd__decap_6
X_11044_ clknet_leaf_46_clk _00895_ VGND VGND VPWR VPWR picorv32_core.cpuregs\[11\]\[26\]
+ sky130_fd_sc_hd__dfxtp_1
XFILLER_77_744 VGND VGND VPWR VPWR sky130_fd_sc_hd__decap_8
XFILLER_92_714 VGND VGND VPWR VPWR sky130_fd_sc_hd__decap_8
XPHY_EDGE_ROW_101_Right_101 VGND VGND VPWR VPWR sky130_fd_sc_hd__decap_3
XFILLER_92_747 VGND VGND VPWR VPWR sky130_fd_sc_hd__fill_2
Xclkbuf_leaf_56_clk clknet_4_12_0_clk VGND VGND VPWR VPWR clknet_leaf_56_clk sky130_fd_sc_hd__clkbuf_8
XFILLER_45_630 VGND VGND VPWR VPWR sky130_fd_sc_hd__fill_1
XTAP_TAPCELL_ROW_86_1553 VGND VPWR sky130_fd_sc_hd__tapvpwrvgnd_1
XTAP_TAPCELL_ROW_35_809 VGND VPWR sky130_fd_sc_hd__tapvpwrvgnd_1
XFILLER_60_611 VGND VGND VPWR VPWR sky130_fd_sc_hd__decap_6
XFILLER_33_836 VGND VGND VPWR VPWR sky130_fd_sc_hd__fill_1
XTAP_TAPCELL_ROW_15_522 VGND VPWR sky130_fd_sc_hd__tapvpwrvgnd_1
XFILLER_32_324 VGND VGND VPWR VPWR sky130_fd_sc_hd__fill_1
XFILLER_60_699 VGND VGND VPWR VPWR sky130_fd_sc_hd__fill_1
X_10828_ clknet_leaf_138_clk _00679_ VGND VGND VPWR VPWR picorv32_core.cpuregs\[17\]\[5\]
+ sky130_fd_sc_hd__dfxtp_1
XFILLER_9_553 VGND VGND VPWR VPWR sky130_fd_sc_hd__decap_6
X_10759_ clknet_leaf_131_clk _00610_ VGND VGND VPWR VPWR picorv32_core.cpuregs\[14\]\[0\]
+ sky130_fd_sc_hd__dfxtp_1
XFILLER_118_418 VGND VGND VPWR VPWR sky130_fd_sc_hd__fill_2
X_07970_ picorv32_core.cpuregs\[20\]\[25\] picorv32_core.cpuregs\[21\]\[25\] picorv32_core.cpuregs\[22\]\[25\]
+ picorv32_core.cpuregs\[23\]\[25\] net762 net729 VGND VGND VPWR VPWR _04050_ sky130_fd_sc_hd__mux4_1
XFILLER_99_368 VGND VGND VPWR VPWR sky130_fd_sc_hd__fill_1
XFILLER_113_167 VGND VGND VPWR VPWR sky130_fd_sc_hd__fill_1
X_06921_ net587 _03138_ VGND VGND VPWR VPWR _03139_ sky130_fd_sc_hd__nor2_1
X_09640_ net833 _04815_ _04818_ net480 VGND VGND VPWR VPWR _04819_ sky130_fd_sc_hd__o211a_1
XFILLER_95_574 VGND VGND VPWR VPWR sky130_fd_sc_hd__decap_6
X_06852_ _03069_ _03072_ _03074_ VGND VGND VPWR VPWR _03075_ sky130_fd_sc_hd__or3_1
XFILLER_68_788 VGND VGND VPWR VPWR sky130_fd_sc_hd__fill_2
XFILLER_55_416 VGND VGND VPWR VPWR sky130_fd_sc_hd__decap_3
X_09571_ _04749_ _04751_ _04752_ net832 net645 VGND VGND VPWR VPWR _04753_ sky130_fd_sc_hd__a221o_1
XFILLER_82_224 VGND VGND VPWR VPWR sky130_fd_sc_hd__decap_3
X_05803_ net506 _02283_ _02276_ VGND VGND VPWR VPWR picorv32_core.alu_out\[3\] sky130_fd_sc_hd__a21o_1
X_06783_ _03010_ _03011_ net980 VGND VGND VPWR VPWR _00236_ sky130_fd_sc_hd__o21a_1
Xclkbuf_leaf_47_clk clknet_4_7_0_clk VGND VGND VPWR VPWR clknet_leaf_47_clk sky130_fd_sc_hd__clkbuf_8
XFILLER_83_769 VGND VGND VPWR VPWR sky130_fd_sc_hd__decap_8
X_05734_ net797 _02190_ net957 VGND VGND VPWR VPWR _02218_ sky130_fd_sc_hd__or3b_1
XFILLER_35_19 VGND VGND VPWR VPWR sky130_fd_sc_hd__fill_1
X_08522_ net1244 net431 net402 VGND VGND VPWR VPWR _00649_ sky130_fd_sc_hd__mux2_1
XTAP_TAPCELL_ROW_141_2370 VGND VPWR sky130_fd_sc_hd__tapvpwrvgnd_1
XFILLER_70_419 VGND VGND VPWR VPWR sky130_fd_sc_hd__fill_1
X_08453_ picorv32_core.decoded_imm\[11\] net527 _04306_ _04307_ VGND VGND VPWR VPWR
+ _00599_ sky130_fd_sc_hd__o22a_1
X_07404_ net484 _03543_ VGND VGND VPWR VPWR _03544_ sky130_fd_sc_hd__nand2_1
X_05665_ net789 net956 VGND VGND VPWR VPWR _02149_ sky130_fd_sc_hd__xnor2_1
X_05596_ _02079_ _02082_ VGND VGND VPWR VPWR _02084_ sky130_fd_sc_hd__or2_1
X_08384_ net196 net582 net452 _04249_ VGND VGND VPWR VPWR _04267_ sky130_fd_sc_hd__a211o_1
X_07335_ _03450_ _03474_ VGND VGND VPWR VPWR _03475_ sky130_fd_sc_hd__nand2_1
XFILLER_137_727 VGND VGND VPWR VPWR sky130_fd_sc_hd__fill_1
X_07266_ net769 picorv32_core.decoded_imm\[26\] VGND VGND VPWR VPWR _03406_ sky130_fd_sc_hd__or2_1
X_09005_ net255 net1637 net346 VGND VGND VPWR VPWR _01175_ sky130_fd_sc_hd__mux2_1
X_06217_ picorv32_core.cpuregs\[12\]\[4\] picorv32_core.cpuregs\[13\]\[4\] picorv32_core.cpuregs\[14\]\[4\]
+ picorv32_core.cpuregs\[15\]\[4\] net744 net711 VGND VGND VPWR VPWR _02647_ sky130_fd_sc_hd__mux4_1
X_07197_ _03354_ _03355_ VGND VGND VPWR VPWR _00306_ sky130_fd_sc_hd__nor2_1
XTAP_TAPCELL_ROW_57_1132 VGND VPWR sky130_fd_sc_hd__tapvpwrvgnd_1
XFILLER_3_729 VPWR VGND VPWR VGND sky130_ef_sc_hd__decap_12
X_06148_ _01582_ net972 _01630_ VGND VGND VPWR VPWR _02600_ sky130_fd_sc_hd__or3_4
X_06079_ net771 net190 net570 _02535_ _02537_ VGND VGND VPWR VPWR picorv32_core.alu_out\[25\]
+ sky130_fd_sc_hd__a311o_1
XFILLER_120_616 VGND VGND VPWR VPWR sky130_fd_sc_hd__decap_4
XTAP_TAPCELL_ROW_70_1321 VGND VPWR sky130_fd_sc_hd__tapvpwrvgnd_1
Xfanout521 _01626_ VGND VGND VPWR VPWR net521 sky130_fd_sc_hd__clkbuf_4
X_09907_ net429 net2214 net320 VGND VGND VPWR VPWR _01391_ sky130_fd_sc_hd__mux2_1
Xfanout510 net513 VGND VGND VPWR VPWR net510 sky130_fd_sc_hd__clkbuf_4
Xfanout532 _03580_ VGND VGND VPWR VPWR net532 sky130_fd_sc_hd__buf_4
Xfanout543 net544 VGND VGND VPWR VPWR net543 sky130_fd_sc_hd__clkbuf_2
Xfanout554 _02913_ VGND VGND VPWR VPWR net554 sky130_fd_sc_hd__clkbuf_4
XFILLER_76_26 VGND VGND VPWR VPWR sky130_fd_sc_hd__fill_2
Xfanout565 net566 VGND VGND VPWR VPWR net565 sky130_fd_sc_hd__buf_4
X_09838_ net488 _04990_ _04991_ _04992_ _05007_ VGND VGND VPWR VPWR _05008_ sky130_fd_sc_hd__o41a_1
XFILLER_86_563 VGND VGND VPWR VPWR sky130_fd_sc_hd__fill_1
Xfanout576 net577 VGND VGND VPWR VPWR net576 sky130_fd_sc_hd__buf_2
Xfanout587 _01701_ VGND VGND VPWR VPWR net587 sky130_fd_sc_hd__buf_4
Xfanout598 _01665_ VGND VGND VPWR VPWR net598 sky130_fd_sc_hd__clkbuf_4
XFILLER_46_416 VGND VGND VPWR VPWR sky130_fd_sc_hd__decap_4
X_09769_ _04937_ _04940_ _04941_ net647 net651 VGND VGND VPWR VPWR _04942_ sky130_fd_sc_hd__a221o_1
XFILLER_132_65 VPWR VGND VPWR VGND sky130_ef_sc_hd__decap_12
Xclkbuf_leaf_38_clk clknet_4_5_0_clk VGND VGND VPWR VPWR clknet_leaf_38_clk sky130_fd_sc_hd__clkbuf_8
XFILLER_27_663 VGND VGND VPWR VPWR sky130_fd_sc_hd__fill_2
XTAP_TAPCELL_ROW_68_1294 VGND VPWR sky130_fd_sc_hd__tapvpwrvgnd_1
X_11662_ clknet_leaf_11_clk _01493_ VGND VGND VPWR VPWR picorv32_core.cpuregs\[26\]\[11\]
+ sky130_fd_sc_hd__dfxtp_1
XFILLER_42_666 VGND VGND VPWR VPWR sky130_fd_sc_hd__decap_3
XTAP_TAPCELL_ROW_81_1483 VGND VPWR sky130_fd_sc_hd__tapvpwrvgnd_1
X_10613_ clknet_leaf_92_clk _00467_ VGND VGND VPWR VPWR picorv32_core.instr_and sky130_fd_sc_hd__dfxtp_1
X_11593_ clknet_leaf_0_clk _01424_ VGND VGND VPWR VPWR picorv32_core.cpuregs\[23\]\[6\]
+ sky130_fd_sc_hd__dfxtp_1
XFILLER_127_215 VGND VGND VPWR VPWR sky130_fd_sc_hd__fill_1
X_10544_ clknet_leaf_133_clk _00398_ VGND VGND VPWR VPWR picorv32_core.cpuregs\[25\]\[0\]
+ sky130_fd_sc_hd__dfxtp_1
XTAP_TAPCELL_ROW_40_878 VGND VPWR sky130_fd_sc_hd__tapvpwrvgnd_1
XFILLER_10_585 VGND VGND VPWR VPWR sky130_fd_sc_hd__decap_3
XTAP_TAPCELL_ROW_40_889 VGND VPWR sky130_fd_sc_hd__tapvpwrvgnd_1
XFILLER_127_259 VGND VGND VPWR VPWR sky130_fd_sc_hd__fill_1
XTAP_TAPCELL_ROW_20_591 VGND VPWR sky130_fd_sc_hd__tapvpwrvgnd_1
X_10475_ clknet_leaf_132_clk _00361_ VGND VGND VPWR VPWR picorv32_core.mem_la_wdata\[1\]
+ sky130_fd_sc_hd__dfxtp_1
XFILLER_41_95 VGND VGND VPWR VPWR sky130_fd_sc_hd__fill_2
XFILLER_136_793 VPWR VGND VPWR VGND sky130_ef_sc_hd__decap_12
XFILLER_135_281 VGND VGND VPWR VPWR sky130_fd_sc_hd__fill_1
XFILLER_1_261 VGND VGND VPWR VPWR sky130_fd_sc_hd__decap_3
X_11027_ clknet_leaf_1_clk _00878_ VGND VGND VPWR VPWR picorv32_core.cpuregs\[11\]\[9\]
+ sky130_fd_sc_hd__dfxtp_1
XFILLER_66_70 VGND VGND VPWR VPWR sky130_fd_sc_hd__decap_4
Xclkbuf_leaf_29_clk clknet_4_4_0_clk VGND VGND VPWR VPWR clknet_leaf_29_clk sky130_fd_sc_hd__clkbuf_8
XFILLER_45_471 VGND VGND VPWR VPWR sky130_fd_sc_hd__decap_8
X_05450_ net923 _01945_ _01948_ VGND VGND VPWR VPWR _01949_ sky130_fd_sc_hd__and3_1
XFILLER_60_463 VGND VGND VPWR VPWR sky130_fd_sc_hd__decap_4
XFILLER_21_828 VGND VGND VPWR VPWR sky130_fd_sc_hd__fill_1
XFILLER_60_485 VGND VGND VPWR VPWR sky130_fd_sc_hd__fill_2
XANTENNA_17 _03820_ VGND VGND VPWR VPWR sky130_fd_sc_hd__diode_2
XANTENNA_28 _04607_ VGND VGND VPWR VPWR sky130_fd_sc_hd__diode_2
X_05381_ _01836_ _01884_ _01861_ _01856_ VGND VGND VPWR VPWR _01885_ sky130_fd_sc_hd__a211oi_1
XANTENNA_39 picorv32_core.mem_la_wdata\[4\] VGND VGND VPWR VPWR sky130_fd_sc_hd__diode_2
XTAP_TAPCELL_ROW_99_1744 VGND VPWR sky130_fd_sc_hd__tapvpwrvgnd_1
X_07120_ picorv32_core.count_cycle\[16\] _03304_ picorv32_core.count_cycle\[17\] VGND
+ VGND VPWR VPWR _03307_ sky130_fd_sc_hd__a21o_1
X_07051_ _03254_ _03257_ VGND VGND VPWR VPWR _03258_ sky130_fd_sc_hd__xnor2_1
X_06002_ net783 net183 net569 VGND VGND VPWR VPWR _02467_ sky130_fd_sc_hd__and3_1
Xoutput113 net113 VGND VGND VPWR VPWR mem_axi_wdata[18] sky130_fd_sc_hd__buf_2
Xoutput124 net124 VGND VGND VPWR VPWR mem_axi_wdata[28] sky130_fd_sc_hd__buf_2
Xoutput102 net102 VGND VGND VPWR VPWR mem_axi_bready sky130_fd_sc_hd__buf_2
Xoutput157 net157 VGND VGND VPWR VPWR pcpi_rs1[24] sky130_fd_sc_hd__buf_2
XTAP_TAPCELL_ROW_110_1900 VGND VPWR sky130_fd_sc_hd__tapvpwrvgnd_1
Xoutput146 net794 VGND VGND VPWR VPWR pcpi_rs1[14] sky130_fd_sc_hd__buf_2
Xoutput135 net135 VGND VGND VPWR VPWR mem_axi_wdata[9] sky130_fd_sc_hd__buf_2
Xoutput168 net168 VGND VGND VPWR VPWR pcpi_rs1[5] sky130_fd_sc_hd__buf_2
Xoutput179 net179 VGND VGND VPWR VPWR pcpi_rs2[15] sky130_fd_sc_hd__buf_2
X_07953_ net637 _04033_ VGND VGND VPWR VPWR _04034_ sky130_fd_sc_hd__or2_1
XFILLER_68_530 VGND VGND VPWR VPWR sky130_fd_sc_hd__fill_2
XTAP_TAPCELL_ROW_126_2129 VGND VPWR sky130_fd_sc_hd__tapvpwrvgnd_1
X_07884_ _03960_ _03961_ net636 VGND VGND VPWR VPWR _03969_ sky130_fd_sc_hd__mux2_1
X_06904_ _03118_ _03121_ VGND VGND VPWR VPWR _03123_ sky130_fd_sc_hd__nor2_1
XTAP_TAPCELL_ROW_52_1062 VGND VPWR sky130_fd_sc_hd__tapvpwrvgnd_1
XFILLER_95_371 VGND VGND VPWR VPWR sky130_fd_sc_hd__fill_1
X_09623_ net611 _03514_ _04801_ VGND VGND VPWR VPWR _04802_ sky130_fd_sc_hd__and3_1
X_06835_ _03057_ _03058_ VGND VGND VPWR VPWR _03059_ sky130_fd_sc_hd__nand2_1
XFILLER_28_416 VGND VGND VPWR VPWR sky130_fd_sc_hd__decap_4
XFILLER_46_29 VGND VGND VPWR VPWR sky130_fd_sc_hd__decap_3
XFILLER_55_246 VGND VGND VPWR VPWR sky130_fd_sc_hd__decap_4
XTAP_TAPCELL_ROW_108_1873 VGND VPWR sky130_fd_sc_hd__tapvpwrvgnd_1
XFILLER_83_577 VGND VGND VPWR VPWR sky130_fd_sc_hd__decap_4
X_09554_ _03499_ _03501_ net612 VGND VGND VPWR VPWR _04736_ sky130_fd_sc_hd__o21ai_1
XFILLER_71_739 VGND VGND VPWR VPWR sky130_fd_sc_hd__decap_8
XFILLER_55_279 VGND VGND VPWR VPWR sky130_fd_sc_hd__fill_1
X_06766_ _02992_ _02993_ _02994_ _02995_ VGND VGND VPWR VPWR _02996_ sky130_fd_sc_hd__o22ai_1
X_08505_ net1303 net228 net409 VGND VGND VPWR VPWR _00635_ sky130_fd_sc_hd__mux2_1
X_06697_ _02771_ picorv32_core.reg_next_pc\[26\] net559 VGND VGND VPWR VPWR _02938_
+ sky130_fd_sc_hd__mux2_2
X_09485_ picorv32_core.reg_pc\[13\] net536 _04670_ net482 VGND VGND VPWR VPWR _04671_
+ sky130_fd_sc_hd__a211o_1
X_05717_ net805 net960 VGND VGND VPWR VPWR _02201_ sky130_fd_sc_hd__xnor2_1
X_08436_ picorv32_core.decoded_imm\[19\] net529 _04284_ _04298_ VGND VGND VPWR VPWR
+ _00591_ sky130_fd_sc_hd__o22a_1
X_05648_ _01596_ net969 VGND VGND VPWR VPWR _02132_ sky130_fd_sc_hd__or2_1
X_08367_ net1147 _04258_ net455 VGND VGND VPWR VPWR _00562_ sky130_fd_sc_hd__mux2_1
X_05579_ _02066_ _02067_ VGND VGND VPWR VPWR _02068_ sky130_fd_sc_hd__xnor2_1
X_07318_ net819 picorv32_core.decoded_imm\[1\] VGND VGND VPWR VPWR _03458_ sky130_fd_sc_hd__and2_1
X_08298_ net1192 net35 net518 VGND VGND VPWR VPWR _00750_ sky130_fd_sc_hd__mux2_1
X_07249_ picorv32_core.instr_sll picorv32_core.instr_slli _01693_ net541 VGND VGND
+ VPWR VPWR _03389_ sky130_fd_sc_hd__or4_1
XFILLER_118_793 VPWR VGND VPWR VGND sky130_ef_sc_hd__decap_12
X_10260_ clknet_leaf_100_clk _00179_ VGND VGND VPWR VPWR picorv32_core.count_instr\[44\]
+ sky130_fd_sc_hd__dfxtp_1
XFILLER_11_54 VGND VGND VPWR VPWR sky130_fd_sc_hd__fill_2
XFILLER_133_741 VPWR VGND VPWR VGND sky130_ef_sc_hd__decap_12
XFILLER_11_87 VGND VGND VPWR VPWR sky130_fd_sc_hd__fill_1
XFILLER_133_785 VPWR VGND VPWR VGND sky130_ef_sc_hd__decap_12
XFILLER_132_262 VGND VGND VPWR VPWR sky130_fd_sc_hd__decap_3
XFILLER_127_87 VGND VGND VPWR VPWR sky130_fd_sc_hd__fill_1
XFILLER_120_413 VGND VGND VPWR VPWR sky130_fd_sc_hd__decap_6
X_10191_ clknet_leaf_132_clk _00110_ VGND VGND VPWR VPWR picorv32_core.cpuregs\[9\]\[7\]
+ sky130_fd_sc_hd__dfxtp_1
XFILLER_132_295 VGND VGND VPWR VPWR sky130_fd_sc_hd__decap_4
Xfanout340 net341 VGND VGND VPWR VPWR net340 sky130_fd_sc_hd__buf_4
Xfanout373 _04339_ VGND VGND VPWR VPWR net373 sky130_fd_sc_hd__clkbuf_8
Xfanout384 net385 VGND VGND VPWR VPWR net384 sky130_fd_sc_hd__clkbuf_8
Xfanout351 net352 VGND VGND VPWR VPWR net351 sky130_fd_sc_hd__clkbuf_8
Xfanout362 net365 VGND VGND VPWR VPWR net362 sky130_fd_sc_hd__clkbuf_8
XTAP_TAPCELL_ROW_6_386 VGND VPWR sky130_fd_sc_hd__tapvpwrvgnd_1
XTAP_TAPCELL_ROW_6_397 VGND VPWR sky130_fd_sc_hd__tapvpwrvgnd_1
Xfanout395 _04330_ VGND VGND VPWR VPWR net395 sky130_fd_sc_hd__clkbuf_4
XFILLER_46_213 VGND VGND VPWR VPWR sky130_fd_sc_hd__decap_3
XFILLER_19_449 VGND VGND VPWR VPWR sky130_fd_sc_hd__decap_3
XTAP_TAPCELL_ROW_83_1512 VGND VPWR sky130_fd_sc_hd__tapvpwrvgnd_1
XTAP_TAPCELL_ROW_45_959 VGND VPWR sky130_fd_sc_hd__tapvpwrvgnd_1
X_11714_ clknet_leaf_60_clk _01545_ VGND VGND VPWR VPWR picorv32_core.cpuregs\[27\]\[31\]
+ sky130_fd_sc_hd__dfxtp_1
XTAP_TAPCELL_ROW_25_661 VGND VPWR sky130_fd_sc_hd__tapvpwrvgnd_1
XFILLER_30_603 VPWR VGND VPWR VGND sky130_ef_sc_hd__decap_12
XTAP_TAPCELL_ROW_25_672 VGND VPWR sky130_fd_sc_hd__tapvpwrvgnd_1
X_11645_ clknet_leaf_47_clk _01476_ VGND VGND VPWR VPWR picorv32_core.cpuregs\[28\]\[26\]
+ sky130_fd_sc_hd__dfxtp_1
X_11576_ clknet_leaf_43_clk _01407_ VGND VGND VPWR VPWR picorv32_core.cpuregs\[2\]\[23\]
+ sky130_fd_sc_hd__dfxtp_1
Xinput15 mem_axi_rdata[1] VGND VGND VPWR VPWR net15 sky130_fd_sc_hd__buf_1
Xinput26 mem_axi_rdata[2] VGND VGND VPWR VPWR net26 sky130_fd_sc_hd__buf_1
XFILLER_7_821 VPWR VGND VPWR VGND sky130_ef_sc_hd__decap_12
Xinput37 mem_axi_wready VGND VGND VPWR VPWR net37 sky130_fd_sc_hd__clkbuf_1
XFILLER_109_760 VGND VGND VPWR VPWR sky130_fd_sc_hd__fill_2
X_10527_ clknet_leaf_17_clk picorv32_core.alu_out\[15\] VGND VGND VPWR VPWR picorv32_core.alu_out_q\[15\]
+ sky130_fd_sc_hd__dfxtp_1
XFILLER_10_382 VGND VGND VPWR VPWR sky130_fd_sc_hd__fill_2
X_10458_ clknet_leaf_78_clk _00345_ VGND VGND VPWR VPWR net50 sky130_fd_sc_hd__dfxtp_1
XTAP_TAPCELL_ROW_94_1674 VGND VPWR sky130_fd_sc_hd__tapvpwrvgnd_1
XTAP_TAPCELL_ROW_94_1663 VGND VPWR sky130_fd_sc_hd__tapvpwrvgnd_1
XFILLER_97_614 VGND VGND VPWR VPWR sky130_fd_sc_hd__fill_2
X_10389_ clknet_leaf_82_clk _00308_ VGND VGND VPWR VPWR picorv32_core.count_cycle\[47\]
+ sky130_fd_sc_hd__dfxtp_1
XFILLER_111_446 VGND VGND VPWR VPWR sky130_fd_sc_hd__fill_2
XFILLER_85_809 VGND VGND VPWR VPWR sky130_fd_sc_hd__decap_4
XFILLER_2_581 VGND VGND VPWR VPWR sky130_fd_sc_hd__decap_6
X_06620_ net2256 _02892_ net996 VGND VGND VPWR VPWR _02895_ sky130_fd_sc_hd__o21ai_1
XFILLER_92_374 VGND VGND VPWR VPWR sky130_fd_sc_hd__fill_1
XFILLER_65_599 VGND VGND VPWR VPWR sky130_fd_sc_hd__fill_1
XFILLER_53_739 VGND VGND VPWR VPWR sky130_fd_sc_hd__fill_1
XTAP_TAPCELL_ROW_121_2059 VGND VPWR sky130_fd_sc_hd__tapvpwrvgnd_1
X_06551_ picorv32_core.count_instr\[30\] _02849_ net977 VGND VGND VPWR VPWR _02851_
+ sky130_fd_sc_hd__a21oi_1
XFILLER_92_396 VGND VGND VPWR VPWR sky130_fd_sc_hd__fill_1
XFILLER_46_791 VGND VGND VPWR VPWR sky130_fd_sc_hd__decap_6
X_05502_ _01995_ _01996_ VGND VGND VPWR VPWR _01997_ sky130_fd_sc_hd__or2_1
X_06482_ picorv32_core.count_instr\[5\] _02805_ net972 VGND VGND VPWR VPWR _02807_
+ sky130_fd_sc_hd__a21oi_1
X_09270_ picorv32_core.cpuregs\[4\]\[4\] picorv32_core.cpuregs\[5\]\[4\] picorv32_core.cpuregs\[6\]\[4\]
+ picorv32_core.cpuregs\[7\]\[4\] net887 net854 VGND VGND VPWR VPWR _04465_ sky130_fd_sc_hd__mux4_1
XFILLER_33_452 VGND VGND VPWR VPWR sky130_fd_sc_hd__decap_4
XFILLER_33_463 VGND VGND VPWR VPWR sky130_fd_sc_hd__fill_1
X_05433_ picorv32_core.reg_pc\[16\] picorv32_core.decoded_imm\[16\] VGND VGND VPWR
+ VPWR _01933_ sky130_fd_sc_hd__xnor2_1
X_08221_ net1161 net476 _04188_ _04208_ VGND VGND VPWR VPWR _00466_ sky130_fd_sc_hd__a22o_1
XFILLER_33_485 VGND VGND VPWR VPWR sky130_fd_sc_hd__decap_3
XTAP_TAPCELL_ROW_103_1792 VGND VPWR sky130_fd_sc_hd__tapvpwrvgnd_1
X_05364_ picorv32_core.count_instr\[11\] net940 net605 _01868_ VGND VGND VPWR VPWR
+ _01869_ sky130_fd_sc_hd__a211o_1
X_08152_ net975 net526 VGND VGND VPWR VPWR _04179_ sky130_fd_sc_hd__nor2_1
XFILLER_20_179 VGND VGND VPWR VPWR sky130_fd_sc_hd__fill_1
XTAP_TAPCELL_ROW_136_2280 VGND VPWR sky130_fd_sc_hd__tapvpwrvgnd_1
X_08083_ _04152_ _04155_ _04156_ net686 net690 VGND VGND VPWR VPWR _04157_ sky130_fd_sc_hd__a221o_1
XFILLER_107_708 VGND VGND VPWR VPWR sky130_fd_sc_hd__fill_2
Xclkbuf_leaf_9_clk clknet_4_1_0_clk VGND VGND VPWR VPWR clknet_leaf_9_clk sky130_fd_sc_hd__clkbuf_8
X_07103_ picorv32_core.count_cycle\[10\] _03294_ _03296_ VGND VGND VPWR VPWR _00271_
+ sky130_fd_sc_hd__o21a_1
X_05295_ picorv32_core.reg_pc\[7\] picorv32_core.decoded_imm\[7\] VGND VGND VPWR VPWR
+ _01804_ sky130_fd_sc_hd__and2_1
X_07034_ net979 _03242_ VGND VGND VPWR VPWR _00256_ sky130_fd_sc_hd__nor2_1
XFILLER_115_785 VPWR VGND VPWR VGND sky130_ef_sc_hd__decap_12
XFILLER_88_614 VGND VGND VPWR VPWR sky130_fd_sc_hd__decap_8
XFILLER_130_755 VGND VGND VPWR VPWR sky130_fd_sc_hd__fill_1
XFILLER_87_113 VGND VGND VPWR VPWR sky130_fd_sc_hd__decap_6
X_08985_ net947 net948 net949 VGND VGND VPWR VPWR _04346_ sky130_fd_sc_hd__nand3_2
X_07936_ picorv32_core.cpuregs\[20\]\[23\] picorv32_core.cpuregs\[21\]\[23\] picorv32_core.cpuregs\[22\]\[23\]
+ picorv32_core.cpuregs\[23\]\[23\] net757 net724 VGND VGND VPWR VPWR _04018_ sky130_fd_sc_hd__mux4_1
XFILLER_102_468 VGND VGND VPWR VPWR sky130_fd_sc_hd__fill_1
XFILLER_84_820 VGND VGND VPWR VPWR sky130_fd_sc_hd__fill_1
XFILLER_56_511 VGND VGND VPWR VPWR sky130_fd_sc_hd__decap_6
XTAP_TAPCELL_ROW_3_345 VGND VPWR sky130_fd_sc_hd__tapvpwrvgnd_1
XFILLER_95_190 VGND VGND VPWR VPWR sky130_fd_sc_hd__fill_1
X_07867_ _03943_ _03944_ net634 VGND VGND VPWR VPWR _03953_ sky130_fd_sc_hd__mux2_1
XFILLER_56_555 VGND VGND VPWR VPWR sky130_fd_sc_hd__fill_1
XFILLER_56_533 VGND VGND VPWR VPWR sky130_fd_sc_hd__decap_4
XFILLER_28_224 VGND VGND VPWR VPWR sky130_fd_sc_hd__fill_1
X_09606_ net470 _04785_ _04784_ net487 VGND VGND VPWR VPWR _04786_ sky130_fd_sc_hd__a211o_1
X_07798_ net635 _03886_ VGND VGND VPWR VPWR _03887_ sky130_fd_sc_hd__or2_1
X_06818_ net668 picorv32_core.reg_next_pc\[10\] _02922_ net491 VGND VGND VPWR VPWR
+ _03044_ sky130_fd_sc_hd__a22o_1
XFILLER_44_717 VGND VGND VPWR VPWR sky130_fd_sc_hd__decap_4
XFILLER_44_728 VGND VGND VPWR VPWR sky130_fd_sc_hd__decap_4
X_09537_ picorv32_core.cpuregs\[20\]\[16\] picorv32_core.cpuregs\[21\]\[16\] picorv32_core.cpuregs\[22\]\[16\]
+ picorv32_core.cpuregs\[23\]\[16\] net889 net857 VGND VGND VPWR VPWR _04720_ sky130_fd_sc_hd__mux4_1
XFILLER_71_558 VGND VGND VPWR VPWR sky130_fd_sc_hd__fill_2
XFILLER_71_547 VGND VGND VPWR VPWR sky130_fd_sc_hd__fill_1
X_06749_ _02964_ _02977_ _02978_ VGND VGND VPWR VPWR _02980_ sky130_fd_sc_hd__and3_1
XTAP_TAPCELL_ROW_65_1253 VGND VPWR sky130_fd_sc_hd__tapvpwrvgnd_1
XTAP_TAPCELL_ROW_65_1242 VGND VPWR sky130_fd_sc_hd__tapvpwrvgnd_1
XTAP_TAPCELL_ROW_42_907 VGND VPWR sky130_fd_sc_hd__tapvpwrvgnd_1
XTAP_TAPCELL_ROW_42_918 VGND VPWR sky130_fd_sc_hd__tapvpwrvgnd_1
X_09468_ _03428_ _03429_ _03487_ _01637_ VGND VGND VPWR VPWR _04654_ sky130_fd_sc_hd__a31o_1
XFILLER_138_811 VGND VGND VPWR VPWR sky130_fd_sc_hd__fill_1
X_08419_ picorv32_core.mem_rdata_q\[27\] net614 VGND VGND VPWR VPWR _04290_ sky130_fd_sc_hd__and2_1
X_09399_ net282 _04573_ _04588_ _04567_ VGND VGND VPWR VPWR _01328_ sky130_fd_sc_hd__a31o_1
XTAP_TAPCELL_ROW_22_620 VGND VPWR sky130_fd_sc_hd__tapvpwrvgnd_1
XTAP_TAPCELL_ROW_22_631 VGND VPWR sky130_fd_sc_hd__tapvpwrvgnd_1
X_11430_ clknet_leaf_14_clk _01266_ VGND VGND VPWR VPWR picorv32_core.cpuregs\[1\]\[13\]
+ sky130_fd_sc_hd__dfxtp_1
XFILLER_125_3 VPWR VGND VPWR VGND sky130_ef_sc_hd__decap_12
X_11361_ clknet_leaf_9_clk _01202_ VGND VGND VPWR VPWR picorv32_core.cpuregs\[18\]\[13\]
+ sky130_fd_sc_hd__dfxtp_1
XFILLER_22_53 VPWR VGND VPWR VGND sky130_ef_sc_hd__decap_12
XFILLER_138_53 VPWR VGND VPWR VGND sky130_ef_sc_hd__decap_12
XFILLER_4_813 VPWR VGND VPWR VGND sky130_ef_sc_hd__decap_12
XFILLER_3_301 VGND VGND VPWR VPWR sky130_fd_sc_hd__fill_2
X_10312_ clknet_leaf_121_clk _00231_ VGND VGND VPWR VPWR picorv32_core.reg_next_pc\[2\]
+ sky130_fd_sc_hd__dfxtp_1
XFILLER_138_97 VPWR VGND VPWR VGND sky130_ef_sc_hd__decap_12
XFILLER_98_57 VGND VGND VPWR VPWR sky130_fd_sc_hd__fill_2
X_11292_ clknet_leaf_18_clk _01140_ VGND VGND VPWR VPWR picorv32_core.cpuregs\[3\]\[15\]
+ sky130_fd_sc_hd__dfxtp_1
X_10243_ clknet_leaf_78_clk _00162_ VGND VGND VPWR VPWR picorv32_core.count_instr\[27\]
+ sky130_fd_sc_hd__dfxtp_1
XFILLER_3_356 VGND VGND VPWR VPWR sky130_fd_sc_hd__fill_2
X_10174_ clknet_leaf_33_clk _00093_ VGND VGND VPWR VPWR picorv32_core.cpuregs\[21\]\[22\]
+ sky130_fd_sc_hd__dfxtp_1
XFILLER_3_389 VGND VGND VPWR VPWR sky130_fd_sc_hd__decap_3
XFILLER_121_777 VGND VGND VPWR VPWR sky130_fd_sc_hd__decap_6
XFILLER_47_577 VGND VGND VPWR VPWR sky130_fd_sc_hd__fill_1
XFILLER_42_282 VGND VGND VPWR VPWR sky130_fd_sc_hd__decap_4
XFILLER_43_783 VGND VGND VPWR VPWR sky130_fd_sc_hd__fill_1
XFILLER_129_833 VGND VGND VPWR VPWR sky130_fd_sc_hd__fill_1
X_11628_ clknet_leaf_140_clk _01459_ VGND VGND VPWR VPWR picorv32_core.cpuregs\[28\]\[9\]
+ sky130_fd_sc_hd__dfxtp_1
XFILLER_128_343 VGND VGND VPWR VPWR sky130_fd_sc_hd__decap_4
XTAP_TAPCELL_ROW_96_1703 VGND VPWR sky130_fd_sc_hd__tapvpwrvgnd_1
XFILLER_8_77 VGND VGND VPWR VPWR sky130_fd_sc_hd__decap_6
XFILLER_128_365 VGND VGND VPWR VPWR sky130_fd_sc_hd__fill_2
X_11559_ clknet_leaf_143_clk _01390_ VGND VGND VPWR VPWR picorv32_core.cpuregs\[2\]\[6\]
+ sky130_fd_sc_hd__dfxtp_1
Xhold607 picorv32_core.cpuregs\[1\]\[6\] VGND VGND VPWR VPWR net1716 sky130_fd_sc_hd__dlygate4sd3_1
XFILLER_7_673 VGND VGND VPWR VPWR sky130_fd_sc_hd__decap_3
Xhold618 picorv32_core.cpuregs\[28\]\[2\] VGND VGND VPWR VPWR net1727 sky130_fd_sc_hd__dlygate4sd3_1
X_05080_ net197 VGND VGND VPWR VPWR _01615_ sky130_fd_sc_hd__inv_2
Xhold629 picorv32_core.cpuregs\[23\]\[17\] VGND VGND VPWR VPWR net1738 sky130_fd_sc_hd__dlygate4sd3_1
XFILLER_40_3 VGND VGND VPWR VPWR sky130_fd_sc_hd__decap_8
XFILLER_112_722 VPWR VGND VPWR VGND sky130_ef_sc_hd__decap_12
XFILLER_111_243 VGND VGND VPWR VPWR sky130_fd_sc_hd__fill_1
XFILLER_85_617 VGND VGND VPWR VPWR sky130_fd_sc_hd__decap_3
X_05982_ net956 net181 _02429_ net671 VGND VGND VPWR VPWR _02448_ sky130_fd_sc_hd__o31a_1
X_08770_ net264 net1875 net375 VGND VGND VPWR VPWR _00917_ sky130_fd_sc_hd__mux2_1
X_07721_ _03804_ _03805_ net629 VGND VGND VPWR VPWR _03815_ sky130_fd_sc_hd__mux2_1
XTAP_TAPCELL_ROW_0_304 VGND VPWR sky130_fd_sc_hd__tapvpwrvgnd_1
XFILLER_26_717 VPWR VGND VPWR VGND sky130_ef_sc_hd__decap_12
X_07652_ net962 net510 _03748_ _03749_ VGND VGND VPWR VPWR _00367_ sky130_fd_sc_hd__o22a_1
XTAP_TAPCELL_ROW_105_1832 VGND VPWR sky130_fd_sc_hd__tapvpwrvgnd_1
XTAP_TAPCELL_ROW_105_1821 VGND VPWR sky130_fd_sc_hd__tapvpwrvgnd_1
X_06603_ picorv32_core.count_instr\[49\] _02881_ VGND VGND VPWR VPWR _02884_ sky130_fd_sc_hd__nand2_1
X_07583_ net688 _03686_ net619 VGND VGND VPWR VPWR _03687_ sky130_fd_sc_hd__a21o_1
X_06534_ _02839_ _02840_ VGND VGND VPWR VPWR _00158_ sky130_fd_sc_hd__nor2_1
X_09322_ picorv32_core.cpuregs\[12\]\[6\] picorv32_core.cpuregs\[13\]\[6\] picorv32_core.cpuregs\[14\]\[6\]
+ picorv32_core.cpuregs\[15\]\[6\] net874 net841 VGND VGND VPWR VPWR _04515_ sky130_fd_sc_hd__mux4_1
XFILLER_18_290 VGND VGND VPWR VPWR sky130_fd_sc_hd__fill_2
X_06465_ net217 net1400 net420 VGND VGND VPWR VPWR _00131_ sky130_fd_sc_hd__mux2_1
XFILLER_21_444 VGND VGND VPWR VPWR sky130_fd_sc_hd__decap_4
X_09253_ _01689_ _04448_ VGND VGND VPWR VPWR _04449_ sky130_fd_sc_hd__or2_1
X_06396_ net1414 net212 net436 VGND VGND VPWR VPWR _00069_ sky130_fd_sc_hd__mux2_1
X_05416_ _01910_ _01912_ VGND VGND VPWR VPWR _01917_ sky130_fd_sc_hd__nand2_1
X_09184_ picorv32_core.cpuregs\[16\]\[1\] picorv32_core.cpuregs\[17\]\[1\] net888
+ VGND VGND VPWR VPWR _04382_ sky130_fd_sc_hd__mux2_1
XFILLER_21_466 VGND VGND VPWR VPWR sky130_fd_sc_hd__decap_6
X_08204_ picorv32_core.latched_rd\[1\] _04205_ _04206_ net1186 VGND VGND VPWR VPWR
+ _00453_ sky130_fd_sc_hd__a22o_1
Xpicorv32_axi_1017 VGND VGND VPWR VPWR picorv32_axi_1017/HI eoi[18] sky130_fd_sc_hd__conb_1
X_08135_ net211 net2181 net417 VGND VGND VPWR VPWR _00428_ sky130_fd_sc_hd__mux2_1
XFILLER_119_343 VGND VGND VPWR VPWR sky130_fd_sc_hd__fill_1
XTAP_TAPCELL_ROW_60_1172 VGND VPWR sky130_fd_sc_hd__tapvpwrvgnd_1
X_05347_ _01727_ _01852_ VGND VGND VPWR VPWR _01853_ sky130_fd_sc_hd__or2_1
Xpicorv32_axi_1028 VGND VGND VPWR VPWR picorv32_axi_1028/HI eoi[29] sky130_fd_sc_hd__conb_1
Xpicorv32_axi_1006 VGND VGND VPWR VPWR picorv32_axi_1006/HI eoi[7] sky130_fd_sc_hd__conb_1
Xpicorv32_axi_1039 VGND VGND VPWR VPWR picorv32_axi_1039/HI mem_axi_awprot[2] sky130_fd_sc_hd__conb_1
XFILLER_107_516 VGND VGND VPWR VPWR sky130_fd_sc_hd__decap_6
XFILLER_107_505 VGND VGND VPWR VPWR sky130_fd_sc_hd__fill_2
XFILLER_4_109 VPWR VGND VPWR VGND sky130_ef_sc_hd__decap_12
X_08066_ net697 _04136_ _04135_ net622 VGND VGND VPWR VPWR _04141_ sky130_fd_sc_hd__o211a_1
X_05278_ net913 net811 _01785_ net909 _01788_ VGND VGND VPWR VPWR _01789_ sky130_fd_sc_hd__a221o_1
XTAP_TAPCELL_ROW_116_1994 VGND VPWR sky130_fd_sc_hd__tapvpwrvgnd_1
XTAP_TAPCELL_ROW_116_1983 VGND VPWR sky130_fd_sc_hd__tapvpwrvgnd_1
X_07017_ _03224_ _03225_ _03226_ net678 VGND VGND VPWR VPWR _03227_ sky130_fd_sc_hd__o22a_1
XTAP_TAPCELL_ROW_8_426 VGND VPWR sky130_fd_sc_hd__tapvpwrvgnd_1
XTAP_TAPCELL_ROW_8_415 VGND VPWR sky130_fd_sc_hd__tapvpwrvgnd_1
XFILLER_130_530 VGND VGND VPWR VPWR sky130_fd_sc_hd__fill_2
XFILLER_102_232 VGND VGND VPWR VPWR sky130_fd_sc_hd__fill_1
XFILLER_88_488 VGND VGND VPWR VPWR sky130_fd_sc_hd__fill_1
XFILLER_76_628 VGND VGND VPWR VPWR sky130_fd_sc_hd__fill_1
X_08968_ net1214 net270 net350 VGND VGND VPWR VPWR _01140_ sky130_fd_sc_hd__mux2_1
XFILLER_29_500 VGND VGND VPWR VPWR sky130_fd_sc_hd__decap_4
X_07919_ net634 _04001_ VGND VGND VPWR VPWR _04002_ sky130_fd_sc_hd__or2_1
XFILLER_84_26 VGND VGND VPWR VPWR sky130_fd_sc_hd__fill_2
X_08899_ net286 net1721 net358 VGND VGND VPWR VPWR _01073_ sky130_fd_sc_hd__mux2_1
XFILLER_56_363 VGND VGND VPWR VPWR sky130_fd_sc_hd__fill_1
XTAP_TAPCELL_ROW_27_701 VGND VPWR sky130_fd_sc_hd__tapvpwrvgnd_1
X_10930_ clknet_leaf_12_clk _00781_ VGND VGND VPWR VPWR picorv32_core.cpuregs\[19\]\[8\]
+ sky130_fd_sc_hd__dfxtp_1
XFILLER_83_182 VGND VGND VPWR VPWR sky130_fd_sc_hd__fill_1
XFILLER_56_385 VGND VGND VPWR VPWR sky130_fd_sc_hd__fill_2
XFILLER_17_42 VPWR VGND VPWR VGND sky130_ef_sc_hd__decap_12
XFILLER_140_65 VPWR VGND VPWR VGND sky130_ef_sc_hd__decap_12
X_10861_ clknet_leaf_138_clk _00712_ VGND VGND VPWR VPWR picorv32_core.cpuregs\[16\]\[5\]
+ sky130_fd_sc_hd__dfxtp_1
X_10792_ clknet_leaf_114_clk _00643_ VGND VGND VPWR VPWR picorv32_core.cpuregs\[15\]\[1\]
+ sky130_fd_sc_hd__dfxtp_1
XFILLER_25_783 VGND VGND VPWR VPWR sky130_fd_sc_hd__fill_1
XFILLER_40_753 VGND VGND VPWR VPWR sky130_fd_sc_hd__decap_3
X_11413_ clknet_leaf_38_clk _01249_ VGND VGND VPWR VPWR picorv32_core.cpuregs\[31\]\[28\]
+ sky130_fd_sc_hd__dfxtp_1
XFILLER_138_696 VGND VGND VPWR VPWR sky130_fd_sc_hd__decap_4
XFILLER_126_825 VGND VGND VPWR VPWR sky130_fd_sc_hd__decap_8
XTAP_TAPCELL_ROW_78_1433 VGND VPWR sky130_fd_sc_hd__tapvpwrvgnd_1
X_11344_ clknet_leaf_37_clk _01185_ VGND VGND VPWR VPWR picorv32_core.cpuregs\[29\]\[28\]
+ sky130_fd_sc_hd__dfxtp_1
XFILLER_125_346 VGND VGND VPWR VPWR sky130_fd_sc_hd__fill_2
X_11275_ clknet_leaf_65_clk _01123_ VGND VGND VPWR VPWR picorv32_core.cpuregs\[4\]\[30\]
+ sky130_fd_sc_hd__dfxtp_1
XTAP_TAPCELL_ROW_91_1622 VGND VPWR sky130_fd_sc_hd__tapvpwrvgnd_1
X_10226_ clknet_leaf_100_clk _00145_ VGND VGND VPWR VPWR picorv32_core.count_instr\[10\]
+ sky130_fd_sc_hd__dfxtp_1
XFILLER_121_585 VGND VGND VPWR VPWR sky130_fd_sc_hd__fill_1
XFILLER_79_488 VPWR VGND VPWR VGND sky130_ef_sc_hd__decap_12
XFILLER_66_116 VGND VGND VPWR VPWR sky130_fd_sc_hd__fill_1
XFILLER_58_82 VGND VGND VPWR VPWR sky130_fd_sc_hd__fill_2
Xhold4 picorv32_core.cpuregs\[0\]\[4\] VGND VGND VPWR VPWR net1113 sky130_fd_sc_hd__dlygate4sd3_1
X_10157_ clknet_leaf_140_clk _00076_ VGND VGND VPWR VPWR picorv32_core.cpuregs\[21\]\[5\]
+ sky130_fd_sc_hd__dfxtp_1
XFILLER_66_138 VGND VGND VPWR VPWR sky130_fd_sc_hd__fill_2
X_10088_ net1127 VGND VGND VPWR VPWR _00938_ sky130_fd_sc_hd__clkbuf_1
XFILLER_63_823 VGND VGND VPWR VPWR sky130_fd_sc_hd__fill_2
XFILLER_35_503 VGND VGND VPWR VPWR sky130_fd_sc_hd__fill_1
XTAP_TAPCELL_ROW_89_1595 VGND VPWR sky130_fd_sc_hd__tapvpwrvgnd_1
XFILLER_35_525 VGND VGND VPWR VPWR sky130_fd_sc_hd__decap_3
XFILLER_62_355 VGND VGND VPWR VPWR sky130_fd_sc_hd__decap_3
XFILLER_50_506 VGND VGND VPWR VPWR sky130_fd_sc_hd__fill_1
XFILLER_62_399 VGND VGND VPWR VPWR sky130_fd_sc_hd__decap_4
XFILLER_31_753 VPWR VGND VPWR VGND sky130_ef_sc_hd__decap_12
XTAP_TAPCELL_ROW_100_1762 VGND VPWR sky130_fd_sc_hd__tapvpwrvgnd_1
XTAP_TAPCELL_ROW_100_1751 VGND VPWR sky130_fd_sc_hd__tapvpwrvgnd_1
XFILLER_88_3 VGND VGND VPWR VPWR sky130_fd_sc_hd__fill_1
XFILLER_31_797 VPWR VGND VPWR VGND sky130_ef_sc_hd__decap_12
X_06250_ _02673_ _01584_ net563 VGND VGND VPWR VPWR _02674_ sky130_fd_sc_hd__mux2_2
X_05201_ _01714_ net585 VGND VGND VPWR VPWR _01717_ sky130_fd_sc_hd__nor2_2
XTAP_TAPCELL_ROW_13_494 VGND VPWR sky130_fd_sc_hd__tapvpwrvgnd_1
XFILLER_30_274 VGND VGND VPWR VPWR sky130_fd_sc_hd__fill_1
X_06181_ picorv32_core.cpuregs\[16\]\[2\] picorv32_core.cpuregs\[17\]\[2\] picorv32_core.cpuregs\[18\]\[2\]
+ picorv32_core.cpuregs\[19\]\[2\] net733 net700 VGND VGND VPWR VPWR _02613_ sky130_fd_sc_hd__mux4_1
Xhold415 picorv32_core.cpuregs\[20\]\[24\] VGND VGND VPWR VPWR net1524 sky130_fd_sc_hd__dlygate4sd3_1
X_05132_ _01654_ _01662_ VGND VGND VPWR VPWR _01663_ sky130_fd_sc_hd__or2_1
Xhold426 picorv32_core.cpuregs\[28\]\[5\] VGND VGND VPWR VPWR net1535 sky130_fd_sc_hd__dlygate4sd3_1
XFILLER_7_470 VGND VGND VPWR VPWR sky130_fd_sc_hd__fill_1
Xhold404 picorv32_core.cpuregs\[23\]\[1\] VGND VGND VPWR VPWR net1513 sky130_fd_sc_hd__dlygate4sd3_1
XFILLER_116_357 VGND VGND VPWR VPWR sky130_fd_sc_hd__fill_1
Xhold459 picorv32_core.cpuregs\[12\]\[16\] VGND VGND VPWR VPWR net1568 sky130_fd_sc_hd__dlygate4sd3_1
Xhold437 picorv32_core.cpuregs\[29\]\[14\] VGND VGND VPWR VPWR net1546 sky130_fd_sc_hd__dlygate4sd3_1
X_05063_ net804 VGND VGND VPWR VPWR _01598_ sky130_fd_sc_hd__inv_2
Xhold448 picorv32_core.cpuregs\[9\]\[3\] VGND VGND VPWR VPWR net1557 sky130_fd_sc_hd__dlygate4sd3_1
X_09940_ net1225 net504 net317 VGND VGND VPWR VPWR _01418_ sky130_fd_sc_hd__mux2_1
Xfanout906 net907 VGND VGND VPWR VPWR net906 sky130_fd_sc_hd__clkbuf_4
XPHY_EDGE_ROW_115_Right_115 VGND VGND VPWR VPWR sky130_fd_sc_hd__decap_3
XFILLER_98_753 VGND VGND VPWR VPWR sky130_fd_sc_hd__decap_3
XFILLER_97_241 VGND VGND VPWR VPWR sky130_fd_sc_hd__fill_2
Xfanout917 net918 VGND VGND VPWR VPWR net917 sky130_fd_sc_hd__clkbuf_2
Xfanout939 picorv32_core.instr_rdinstr VGND VGND VPWR VPWR net939 sky130_fd_sc_hd__buf_2
Xfanout928 picorv32_core.mem_wordsize\[1\] VGND VGND VPWR VPWR net928 sky130_fd_sc_hd__buf_4
X_09871_ net1594 net301 net324 VGND VGND VPWR VPWR _01359_ sky130_fd_sc_hd__mux2_1
Xhold1115 picorv32_core.cpuregs\[6\]\[28\] VGND VGND VPWR VPWR net2224 sky130_fd_sc_hd__dlygate4sd3_1
X_08822_ net1655 net500 net369 VGND VGND VPWR VPWR _00998_ sky130_fd_sc_hd__mux2_1
Xhold1104 picorv32_core.cpuregs\[25\]\[7\] VGND VGND VPWR VPWR net2213 sky130_fd_sc_hd__dlygate4sd3_1
Xhold1126 picorv32_core.count_cycle\[21\] VGND VGND VPWR VPWR net2235 sky130_fd_sc_hd__dlygate4sd3_1
XFILLER_85_447 VGND VGND VPWR VPWR sky130_fd_sc_hd__fill_1
X_05965_ net789 _02431_ VGND VGND VPWR VPWR _02433_ sky130_fd_sc_hd__or2_1
Xhold1137 picorv32_core.instr_srli VGND VGND VPWR VPWR net2246 sky130_fd_sc_hd__dlygate4sd3_1
Xhold1148 axi_adapter.mem_valid VGND VGND VPWR VPWR net2257 sky130_fd_sc_hd__dlygate4sd3_1
X_08753_ _02666_ _02797_ VGND VGND VPWR VPWR _04338_ sky130_fd_sc_hd__or2_1
XFILLER_38_330 VGND VGND VPWR VPWR sky130_fd_sc_hd__fill_1
Xhold1159 picorv32_core.count_cycle\[48\] VGND VGND VPWR VPWR net2268 sky130_fd_sc_hd__dlygate4sd3_1
XFILLER_54_801 VGND VGND VPWR VPWR sky130_fd_sc_hd__decap_3
X_07704_ _03786_ _03787_ net692 VGND VGND VPWR VPWR _03799_ sky130_fd_sc_hd__mux2_1
X_08684_ net214 net2062 net389 VGND VGND VPWR VPWR _00834_ sky130_fd_sc_hd__mux2_1
X_05896_ net799 _02366_ VGND VGND VPWR VPWR _02369_ sky130_fd_sc_hd__or2_1
XFILLER_54_29 VGND VGND VPWR VPWR sky130_fd_sc_hd__fill_2
XTAP_TAPCELL_ROW_49_1012 VGND VPWR sky130_fd_sc_hd__tapvpwrvgnd_1
XFILLER_80_152 VGND VGND VPWR VPWR sky130_fd_sc_hd__fill_1
X_07635_ picorv32_core.cpuregs\[16\]\[7\] picorv32_core.cpuregs\[17\]\[7\] picorv32_core.cpuregs\[18\]\[7\]
+ picorv32_core.cpuregs\[19\]\[7\] net735 net702 VGND VGND VPWR VPWR _03733_ sky130_fd_sc_hd__mux4_1
XTAP_TAPCELL_ROW_62_1201 VGND VPWR sky130_fd_sc_hd__tapvpwrvgnd_1
XFILLER_53_399 VPWR VGND VPWR VGND sky130_ef_sc_hd__decap_12
X_07566_ _02611_ _03670_ VGND VGND VPWR VPWR _03671_ sky130_fd_sc_hd__nor2_1
X_06517_ picorv32_core.count_instr\[18\] _02828_ VGND VGND VPWR VPWR _02829_ sky130_fd_sc_hd__and2_1
X_09305_ net825 _04495_ _04498_ net478 VGND VGND VPWR VPWR _04499_ sky130_fd_sc_hd__o211a_1
XFILLER_22_742 VPWR VGND VPWR VGND sky130_ef_sc_hd__decap_12
X_07497_ picorv32_core.reg_out\[19\] picorv32_core.reg_next_pc\[19\] net558 VGND VGND
+ VPWR VPWR _03619_ sky130_fd_sc_hd__mux2_1
X_09236_ picorv32_core.cpuregs\[24\]\[3\] picorv32_core.cpuregs\[25\]\[3\] picorv32_core.cpuregs\[26\]\[3\]
+ picorv32_core.cpuregs\[27\]\[3\] net885 net852 VGND VGND VPWR VPWR _04432_ sky130_fd_sc_hd__mux4_1
X_06448_ net292 net1987 net418 VGND VGND VPWR VPWR _00114_ sky130_fd_sc_hd__mux2_1
XPHY_EDGE_ROW_17_Right_17 VGND VGND VPWR VPWR sky130_fd_sc_hd__decap_3
XTAP_TAPCELL_ROW_32_770 VGND VPWR sky130_fd_sc_hd__tapvpwrvgnd_1
XFILLER_119_140 VGND VGND VPWR VPWR sky130_fd_sc_hd__fill_2
X_06379_ _02774_ _02777_ net564 VGND VGND VPWR VPWR _02778_ sky130_fd_sc_hd__mux2_1
X_09167_ _04364_ _04365_ net837 VGND VGND VPWR VPWR _04366_ sky130_fd_sc_hd__mux2_1
X_09098_ net287 net1622 net332 VGND VGND VPWR VPWR _01265_ sky130_fd_sc_hd__mux2_1
X_08118_ net277 net2070 net414 VGND VGND VPWR VPWR _00411_ sky130_fd_sc_hd__mux2_1
XFILLER_123_817 VGND VGND VPWR VPWR sky130_fd_sc_hd__decap_3
X_08049_ _04123_ _04124_ net459 _04121_ VGND VGND VPWR VPWR _04125_ sky130_fd_sc_hd__o211a_1
XFILLER_134_176 VGND VGND VPWR VPWR sky130_fd_sc_hd__decap_3
Xhold960 picorv32_core.cpuregs\[16\]\[17\] VGND VGND VPWR VPWR net2069 sky130_fd_sc_hd__dlygate4sd3_1
Xhold971 picorv32_core.cpuregs\[15\]\[11\] VGND VGND VPWR VPWR net2080 sky130_fd_sc_hd__dlygate4sd3_1
XFILLER_1_613 VGND VGND VPWR VPWR sky130_fd_sc_hd__decap_3
Xhold982 picorv32_core.cpuregs\[20\]\[2\] VGND VGND VPWR VPWR net2091 sky130_fd_sc_hd__dlygate4sd3_1
X_11060_ clknet_leaf_2_clk _00911_ VGND VGND VPWR VPWR picorv32_core.cpuregs\[10\]\[10\]
+ sky130_fd_sc_hd__dfxtp_1
XTAP_TAPCELL_ROW_73_1363 VGND VPWR sky130_fd_sc_hd__tapvpwrvgnd_1
Xhold993 picorv32_core.cpuregs\[4\]\[6\] VGND VGND VPWR VPWR net2102 sky130_fd_sc_hd__dlygate4sd3_1
X_10011_ net1381 net450 net308 VGND VGND VPWR VPWR _01487_ sky130_fd_sc_hd__mux2_1
XFILLER_130_360 VGND VGND VPWR VPWR sky130_fd_sc_hd__decap_4
XFILLER_89_797 VGND VGND VPWR VPWR sky130_fd_sc_hd__fill_1
XPHY_EDGE_ROW_26_Right_26 VGND VGND VPWR VPWR sky130_fd_sc_hd__decap_3
XFILLER_57_661 VGND VGND VPWR VPWR sky130_fd_sc_hd__fill_2
XFILLER_72_620 VPWR VGND VPWR VGND sky130_ef_sc_hd__decap_12
X_10913_ clknet_leaf_95_clk _00764_ VGND VGND VPWR VPWR picorv32_core.mem_rdata_q\[23\]
+ sky130_fd_sc_hd__dfxtp_2
X_10844_ clknet_leaf_41_clk _00695_ VGND VGND VPWR VPWR picorv32_core.cpuregs\[17\]\[21\]
+ sky130_fd_sc_hd__dfxtp_1
XFILLER_13_753 VPWR VGND VPWR VGND sky130_ef_sc_hd__decap_12
X_10775_ clknet_leaf_23_clk _00626_ VGND VGND VPWR VPWR picorv32_core.cpuregs\[14\]\[16\]
+ sky130_fd_sc_hd__dfxtp_1
XFILLER_9_713 VPWR VGND VPWR VGND sky130_ef_sc_hd__decap_12
XPHY_EDGE_ROW_35_Right_35 VGND VGND VPWR VPWR sky130_fd_sc_hd__decap_3
XFILLER_13_797 VPWR VGND VPWR VGND sky130_ef_sc_hd__decap_12
XTAP_TAPCELL_ROW_10_453 VGND VPWR sky130_fd_sc_hd__tapvpwrvgnd_1
XFILLER_114_817 VGND VGND VPWR VPWR sky130_fd_sc_hd__fill_1
X_11327_ clknet_leaf_12_clk _01168_ VGND VGND VPWR VPWR picorv32_core.cpuregs\[29\]\[11\]
+ sky130_fd_sc_hd__dfxtp_1
X_11258_ clknet_leaf_16_clk _01106_ VGND VGND VPWR VPWR picorv32_core.cpuregs\[4\]\[13\]
+ sky130_fd_sc_hd__dfxtp_1
XPHY_EDGE_ROW_44_Right_44 VGND VGND VPWR VPWR sky130_fd_sc_hd__decap_3
X_10209_ clknet_leaf_67_clk _00128_ VGND VGND VPWR VPWR picorv32_core.cpuregs\[9\]\[25\]
+ sky130_fd_sc_hd__dfxtp_1
XFILLER_121_371 VGND VGND VPWR VPWR sky130_fd_sc_hd__fill_1
X_11189_ clknet_leaf_4_clk _01040_ VGND VGND VPWR VPWR picorv32_core.cpuregs\[6\]\[11\]
+ sky130_fd_sc_hd__dfxtp_1
XFILLER_67_447 VGND VGND VPWR VPWR sky130_fd_sc_hd__fill_1
X_05750_ net764 _02165_ net196 VGND VGND VPWR VPWR _02234_ sky130_fd_sc_hd__or3b_1
XFILLER_67_469 VGND VGND VPWR VPWR sky130_fd_sc_hd__decap_8
XFILLER_48_661 VPWR VGND VPWR VGND sky130_ef_sc_hd__decap_12
XFILLER_48_683 VGND VGND VPWR VPWR sky130_fd_sc_hd__fill_2
X_05681_ _02163_ _02164_ VGND VGND VPWR VPWR _02165_ sky130_fd_sc_hd__and2_1
XFILLER_62_141 VGND VGND VPWR VPWR sky130_fd_sc_hd__decap_4
X_07420_ picorv32_core.cpuregs\[24\]\[31\] picorv32_core.cpuregs\[25\]\[31\] net903
+ VGND VGND VPWR VPWR _03560_ sky130_fd_sc_hd__mux2_1
XTAP_TAPCELL_ROW_18_564 VGND VPWR sky130_fd_sc_hd__tapvpwrvgnd_1
X_07351_ _03430_ _03428_ VGND VGND VPWR VPWR _03491_ sky130_fd_sc_hd__nand2b_1
XPHY_EDGE_ROW_53_Right_53 VGND VGND VPWR VPWR sky130_fd_sc_hd__decap_3
XFILLER_50_325 VGND VGND VPWR VPWR sky130_fd_sc_hd__decap_3
XTAP_TAPCELL_ROW_118_2009 VGND VPWR sky130_fd_sc_hd__tapvpwrvgnd_1
X_06302_ net1349 net286 net433 VGND VGND VPWR VPWR _00051_ sky130_fd_sc_hd__mux2_1
XFILLER_31_561 VPWR VGND VPWR VGND sky130_ef_sc_hd__decap_12
X_07282_ net787 picorv32_core.decoded_imm\[17\] VGND VGND VPWR VPWR _03422_ sky130_fd_sc_hd__and2_1
X_09021_ net499 net1835 net341 VGND VGND VPWR VPWR _01190_ sky130_fd_sc_hd__mux2_1
X_06233_ _02661_ _02662_ _02643_ VGND VGND VPWR VPWR _00036_ sky130_fd_sc_hd__a21oi_1
XTAP_TAPCELL_ROW_131_2209 VGND VPWR sky130_fd_sc_hd__tapvpwrvgnd_1
Xhold201 picorv32_core.cpuregs\[5\]\[6\] VGND VGND VPWR VPWR net1310 sky130_fd_sc_hd__dlygate4sd3_1
X_06164_ picorv32_core.decoded_imm_j\[2\] _00763_ net437 VGND VGND VPWR VPWR _00022_
+ sky130_fd_sc_hd__mux2_1
X_05115_ picorv32_core.mem_wordsize\[1\] _01645_ _01646_ net2368 VGND VGND VPWR VPWR
+ _01647_ sky130_fd_sc_hd__a22o_1
Xhold234 picorv32_core.cpuregs\[7\]\[5\] VGND VGND VPWR VPWR net1343 sky130_fd_sc_hd__dlygate4sd3_1
Xhold223 picorv32_core.cpuregs\[28\]\[0\] VGND VGND VPWR VPWR net1332 sky130_fd_sc_hd__dlygate4sd3_1
Xhold212 picorv32_core.cpuregs\[31\]\[11\] VGND VGND VPWR VPWR net1321 sky130_fd_sc_hd__dlygate4sd3_1
XTAP_TAPCELL_ROW_113_1942 VGND VPWR sky130_fd_sc_hd__tapvpwrvgnd_1
Xhold278 picorv32_core.cpuregs\[30\]\[20\] VGND VGND VPWR VPWR net1387 sky130_fd_sc_hd__dlygate4sd3_1
X_06095_ _01599_ _02551_ VGND VGND VPWR VPWR _02552_ sky130_fd_sc_hd__or2_1
Xhold256 picorv32_core.cpuregs\[7\]\[17\] VGND VGND VPWR VPWR net1365 sky130_fd_sc_hd__dlygate4sd3_1
Xhold267 picorv32_core.cpuregs\[30\]\[16\] VGND VGND VPWR VPWR net1376 sky130_fd_sc_hd__dlygate4sd3_1
Xhold245 picorv32_core.cpuregs\[2\]\[15\] VGND VGND VPWR VPWR net1354 sky130_fd_sc_hd__dlygate4sd3_1
XPHY_EDGE_ROW_62_Right_62 VGND VGND VPWR VPWR sky130_fd_sc_hd__decap_3
X_09923_ net238 net1998 net322 VGND VGND VPWR VPWR _01407_ sky130_fd_sc_hd__mux2_1
Xfanout714 net716 VGND VGND VPWR VPWR net714 sky130_fd_sc_hd__clkbuf_4
Xhold289 picorv32_core.cpuregs\[11\]\[15\] VGND VGND VPWR VPWR net1398 sky130_fd_sc_hd__dlygate4sd3_1
X_05046_ picorv32_core.instr_bgeu VGND VGND VPWR VPWR _01581_ sky130_fd_sc_hd__inv_2
Xfanout703 net705 VGND VGND VPWR VPWR net703 sky130_fd_sc_hd__clkbuf_4
X_09854_ net839 _05017_ net829 VGND VGND VPWR VPWR _05023_ sky130_fd_sc_hd__o21a_1
Xfanout747 net749 VGND VGND VPWR VPWR net747 sky130_fd_sc_hd__buf_4
Xfanout758 _00000_ VGND VGND VPWR VPWR net758 sky130_fd_sc_hd__clkbuf_4
Xfanout725 _00001_ VGND VGND VPWR VPWR net725 sky130_fd_sc_hd__buf_2
Xfanout736 net738 VGND VGND VPWR VPWR net736 sky130_fd_sc_hd__buf_4
XFILLER_140_691 VGND VGND VPWR VPWR sky130_fd_sc_hd__decap_8
XFILLER_105_57 VGND VGND VPWR VPWR sky130_fd_sc_hd__decap_3
XFILLER_100_533 VGND VGND VPWR VPWR sky130_fd_sc_hd__fill_1
Xfanout769 net770 VGND VGND VPWR VPWR net769 sky130_fd_sc_hd__clkbuf_2
X_08805_ net256 net1995 net372 VGND VGND VPWR VPWR _00983_ sky130_fd_sc_hd__mux2_1
XPHY_EDGE_ROW_0_Left_142 VGND VGND VPWR VPWR sky130_fd_sc_hd__decap_3
X_09785_ picorv32_core.cpuregs\[0\]\[27\] picorv32_core.cpuregs\[1\]\[27\] picorv32_core.cpuregs\[2\]\[27\]
+ picorv32_core.cpuregs\[3\]\[27\] net898 net864 VGND VGND VPWR VPWR _04957_ sky130_fd_sc_hd__mux4_1
X_06997_ _03192_ _03199_ VGND VGND VPWR VPWR _03208_ sky130_fd_sc_hd__nor2_1
XFILLER_58_469 VGND VGND VPWR VPWR sky130_fd_sc_hd__decap_6
XPHY_EDGE_ROW_37_Left_179 VGND VGND VPWR VPWR sky130_fd_sc_hd__decap_3
X_05948_ _02415_ _02416_ VGND VGND VPWR VPWR _02417_ sky130_fd_sc_hd__or2_1
X_08736_ net1398 net268 net379 VGND VGND VPWR VPWR _00884_ sky130_fd_sc_hd__mux2_1
X_08667_ net288 net1435 net387 VGND VGND VPWR VPWR _00817_ sky130_fd_sc_hd__mux2_1
X_05879_ net958 _02352_ VGND VGND VPWR VPWR _02353_ sky130_fd_sc_hd__xnor2_1
XFILLER_54_653 VGND VGND VPWR VPWR sky130_fd_sc_hd__fill_1
XTAP_TAPCELL_ROW_37_840 VGND VPWR sky130_fd_sc_hd__tapvpwrvgnd_1
XPHY_EDGE_ROW_71_Right_71 VGND VGND VPWR VPWR sky130_fd_sc_hd__decap_3
X_07618_ picorv32_core.cpuregs\[28\]\[6\] picorv32_core.cpuregs\[29\]\[6\] picorv32_core.cpuregs\[30\]\[6\]
+ picorv32_core.cpuregs\[31\]\[6\] net732 net699 VGND VGND VPWR VPWR _03717_ sky130_fd_sc_hd__mux4_1
X_08598_ net275 net1861 net394 VGND VGND VPWR VPWR _00721_ sky130_fd_sc_hd__mux2_1
XFILLER_10_701 VGND VGND VPWR VPWR sky130_fd_sc_hd__decap_4
X_07549_ picorv32_core.cpuregs\[4\]\[0\] picorv32_core.cpuregs\[5\]\[0\] picorv32_core.cpuregs\[6\]\[0\]
+ picorv32_core.cpuregs\[7\]\[0\] net743 net710 VGND VGND VPWR VPWR _03654_ sky130_fd_sc_hd__mux4_1
X_10560_ clknet_leaf_20_clk _00414_ VGND VGND VPWR VPWR picorv32_core.cpuregs\[25\]\[16\]
+ sky130_fd_sc_hd__dfxtp_1
XFILLER_14_65 VPWR VGND VPWR VGND sky130_ef_sc_hd__decap_12
XPHY_EDGE_ROW_46_Left_188 VGND VGND VPWR VPWR sky130_fd_sc_hd__decap_3
X_10491_ clknet_leaf_18_clk _00377_ VGND VGND VPWR VPWR net181 sky130_fd_sc_hd__dfxtp_4
X_09219_ picorv32_core.cpuregs\[16\]\[2\] picorv32_core.cpuregs\[17\]\[2\] picorv32_core.cpuregs\[18\]\[2\]
+ picorv32_core.cpuregs\[19\]\[2\] net875 net842 VGND VGND VPWR VPWR _04416_ sky130_fd_sc_hd__mux4_1
XFILLER_6_749 VGND VGND VPWR VPWR sky130_fd_sc_hd__decap_6
XPHY_EDGE_ROW_80_Right_80 VGND VGND VPWR VPWR sky130_fd_sc_hd__decap_3
X_11112_ clknet_leaf_65_clk _00963_ VGND VGND VPWR VPWR picorv32_core.cpuregs\[0\]\[30\]
+ sky130_fd_sc_hd__dfxtp_1
XFILLER_111_809 VGND VGND VPWR VPWR sky130_fd_sc_hd__decap_4
Xhold790 picorv32_core.cpuregs\[20\]\[14\] VGND VGND VPWR VPWR net1899 sky130_fd_sc_hd__dlygate4sd3_1
X_11043_ clknet_leaf_68_clk _00894_ VGND VGND VPWR VPWR picorv32_core.cpuregs\[11\]\[25\]
+ sky130_fd_sc_hd__dfxtp_1
XFILLER_76_222 VGND VGND VPWR VPWR sky130_fd_sc_hd__fill_1
XPHY_EDGE_ROW_55_Left_197 VGND VGND VPWR VPWR sky130_fd_sc_hd__decap_3
XFILLER_49_447 VGND VGND VPWR VPWR sky130_fd_sc_hd__fill_1
XFILLER_39_73 VGND VGND VPWR VPWR sky130_fd_sc_hd__decap_4
Xclkbuf_4_3_0_clk clknet_0_clk VGND VGND VPWR VPWR clknet_4_3_0_clk sky130_fd_sc_hd__clkbuf_8
XFILLER_91_225 VGND VGND VPWR VPWR sky130_fd_sc_hd__decap_3
XTAP_TAPCELL_ROW_86_1554 VGND VPWR sky130_fd_sc_hd__tapvpwrvgnd_1
XFILLER_72_450 VGND VGND VPWR VPWR sky130_fd_sc_hd__fill_1
XFILLER_72_472 VGND VGND VPWR VPWR sky130_fd_sc_hd__decap_4
XTAP_TAPCELL_ROW_15_523 VGND VPWR sky130_fd_sc_hd__tapvpwrvgnd_1
X_10827_ clknet_leaf_113_clk _00678_ VGND VGND VPWR VPWR picorv32_core.cpuregs\[17\]\[4\]
+ sky130_fd_sc_hd__dfxtp_1
X_10758_ clknet_leaf_112_clk _00609_ VGND VGND VPWR VPWR picorv32_core.decoded_imm\[1\]
+ sky130_fd_sc_hd__dfxtp_2
X_10689_ clknet_leaf_127_clk _00540_ VGND VGND VPWR VPWR picorv32_core.is_compare
+ sky130_fd_sc_hd__dfxtp_1
XFILLER_113_113 VGND VGND VPWR VPWR sky130_fd_sc_hd__decap_3
XFILLER_99_303 VGND VGND VPWR VPWR sky130_fd_sc_hd__decap_3
X_06920_ _03133_ _03134_ _03137_ net679 VGND VGND VPWR VPWR _03138_ sky130_fd_sc_hd__o22a_1
XFILLER_68_734 VGND VGND VPWR VPWR sky130_fd_sc_hd__fill_1
XTAP_TAPCELL_ROW_128_2160 VGND VPWR sky130_fd_sc_hd__tapvpwrvgnd_1
XFILLER_68_767 VGND VGND VPWR VPWR sky130_fd_sc_hd__fill_2
X_06851_ _03024_ _03025_ _03073_ VGND VGND VPWR VPWR _03074_ sky130_fd_sc_hd__and3_1
X_09570_ _04743_ _04744_ net657 VGND VGND VPWR VPWR _04752_ sky130_fd_sc_hd__mux2_1
X_05802_ _02281_ _02282_ VGND VGND VPWR VPWR _02283_ sky130_fd_sc_hd__xnor2_1
X_06782_ net665 picorv32_core.reg_next_pc\[7\] _02919_ net491 VGND VGND VPWR VPWR
+ _03011_ sky130_fd_sc_hd__a22o_1
X_08521_ net1308 net443 net402 VGND VGND VPWR VPWR _00648_ sky130_fd_sc_hd__mux2_1
X_05733_ net807 _01607_ _02129_ _02212_ _02216_ VGND VGND VPWR VPWR _02217_ sky130_fd_sc_hd__o221a_1
XTAP_TAPCELL_ROW_141_2371 VGND VPWR sky130_fd_sc_hd__tapvpwrvgnd_1
XTAP_TAPCELL_ROW_141_2360 VGND VPWR sky130_fd_sc_hd__tapvpwrvgnd_1
XFILLER_91_792 VGND VGND VPWR VPWR sky130_fd_sc_hd__fill_1
XFILLER_91_781 VGND VGND VPWR VPWR sky130_fd_sc_hd__decap_3
X_08452_ net931 picorv32_core.mem_rdata_q\[7\] picorv32_core.decoded_imm_j\[11\] net674
+ net524 VGND VGND VPWR VPWR _04307_ sky130_fd_sc_hd__a221o_1
X_07403_ _01637_ _03540_ _03541_ _03542_ VGND VGND VPWR VPWR _03543_ sky130_fd_sc_hd__o31a_1
X_05664_ _02147_ VGND VGND VPWR VPWR _02148_ sky130_fd_sc_hd__inv_2
X_05595_ _02079_ _02082_ VGND VGND VPWR VPWR _02083_ sky130_fd_sc_hd__nand2_1
X_08383_ net1170 net454 _04266_ VGND VGND VPWR VPWR _00570_ sky130_fd_sc_hd__o21a_1
X_07334_ _03471_ _03473_ _03452_ VGND VGND VPWR VPWR _03474_ sky130_fd_sc_hd__o21ai_1
X_07265_ net769 picorv32_core.decoded_imm\[26\] VGND VGND VPWR VPWR _03405_ sky130_fd_sc_hd__nand2_1
X_09004_ net262 net2241 net346 VGND VGND VPWR VPWR _01174_ sky130_fd_sc_hd__mux2_1
X_06216_ _02644_ _02645_ net633 VGND VGND VPWR VPWR _02646_ sky130_fd_sc_hd__mux2_1
XFILLER_117_430 VGND VGND VPWR VPWR sky130_fd_sc_hd__fill_1
X_07196_ net2275 _03353_ net992 VGND VGND VPWR VPWR _03355_ sky130_fd_sc_hd__o21ai_1
XTAP_TAPCELL_ROW_57_1133 VGND VPWR sky130_fd_sc_hd__tapvpwrvgnd_1
X_06147_ _01630_ net982 picorv32_core.mem_do_rinst VGND VGND VPWR VPWR _02599_ sky130_fd_sc_hd__and3b_1
XFILLER_132_455 VGND VGND VPWR VPWR sky130_fd_sc_hd__decap_3
X_06078_ net771 net190 net608 _02536_ VGND VGND VPWR VPWR _02537_ sky130_fd_sc_hd__o22a_1
XFILLER_132_477 VGND VGND VPWR VPWR sky130_fd_sc_hd__decap_4
Xfanout511 net512 VGND VGND VPWR VPWR net511 sky130_fd_sc_hd__buf_2
XTAP_TAPCELL_ROW_70_1322 VGND VPWR sky130_fd_sc_hd__tapvpwrvgnd_1
Xfanout533 net535 VGND VGND VPWR VPWR net533 sky130_fd_sc_hd__clkbuf_4
Xfanout522 net525 VGND VGND VPWR VPWR net522 sky130_fd_sc_hd__buf_2
X_09906_ net443 net1673 net320 VGND VGND VPWR VPWR _01390_ sky130_fd_sc_hd__mux2_1
Xfanout500 _02672_ VGND VGND VPWR VPWR net500 sky130_fd_sc_hd__clkbuf_2
XFILLER_98_380 VGND VGND VPWR VPWR sky130_fd_sc_hd__decap_3
Xfanout544 net545 VGND VGND VPWR VPWR net544 sky130_fd_sc_hd__buf_2
Xfanout566 _02668_ VGND VGND VPWR VPWR net566 sky130_fd_sc_hd__buf_2
Xfanout555 net556 VGND VGND VPWR VPWR net555 sky130_fd_sc_hd__clkbuf_4
X_09837_ picorv32_core.reg_pc\[29\] net538 _05006_ net483 VGND VGND VPWR VPWR _05007_
+ sky130_fd_sc_hd__a211o_1
Xfanout577 _01726_ VGND VGND VPWR VPWR net577 sky130_fd_sc_hd__buf_2
Xfanout599 _01652_ VGND VGND VPWR VPWR net599 sky130_fd_sc_hd__buf_2
Xfanout588 net589 VGND VGND VPWR VPWR net588 sky130_fd_sc_hd__clkbuf_4
X_09768_ _04932_ _04933_ net660 VGND VGND VPWR VPWR _04941_ sky130_fd_sc_hd__mux2_1
XFILLER_46_428 VGND VGND VPWR VPWR sky130_fd_sc_hd__fill_1
XFILLER_46_439 VGND VGND VPWR VPWR sky130_fd_sc_hd__fill_1
XFILLER_132_77 VGND VGND VPWR VPWR sky130_fd_sc_hd__decap_6
X_08719_ net1459 net206 net385 VGND VGND VPWR VPWR _00868_ sky130_fd_sc_hd__mux2_1
XFILLER_61_409 VGND VGND VPWR VPWR sky130_fd_sc_hd__decap_6
X_09699_ picorv32_core.cpuregs\[24\]\[23\] picorv32_core.cpuregs\[25\]\[23\] picorv32_core.cpuregs\[26\]\[23\]
+ picorv32_core.cpuregs\[27\]\[23\] net897 net863 VGND VGND VPWR VPWR _04875_ sky130_fd_sc_hd__mux4_1
XTAP_TAPCELL_ROW_68_1284 VGND VPWR sky130_fd_sc_hd__tapvpwrvgnd_1
XFILLER_26_141 VGND VGND VPWR VPWR sky130_fd_sc_hd__fill_1
XFILLER_42_601 VGND VGND VPWR VPWR sky130_fd_sc_hd__decap_3
XTAP_TAPCELL_ROW_68_1295 VGND VPWR sky130_fd_sc_hd__tapvpwrvgnd_1
XFILLER_41_122 VGND VGND VPWR VPWR sky130_fd_sc_hd__decap_3
X_11661_ clknet_leaf_1_clk _01492_ VGND VGND VPWR VPWR picorv32_core.cpuregs\[26\]\[10\]
+ sky130_fd_sc_hd__dfxtp_1
XTAP_TAPCELL_ROW_81_1484 VGND VPWR sky130_fd_sc_hd__tapvpwrvgnd_1
XTAP_TAPCELL_ROW_81_1473 VGND VPWR sky130_fd_sc_hd__tapvpwrvgnd_1
X_10612_ clknet_leaf_88_clk _00466_ VGND VGND VPWR VPWR picorv32_core.instr_or sky130_fd_sc_hd__dfxtp_1
X_11592_ clknet_leaf_140_clk _01423_ VGND VGND VPWR VPWR picorv32_core.cpuregs\[23\]\[5\]
+ sky130_fd_sc_hd__dfxtp_1
X_10543_ clknet_leaf_61_clk picorv32_core.alu_out\[31\] VGND VGND VPWR VPWR picorv32_core.alu_out_q\[31\]
+ sky130_fd_sc_hd__dfxtp_1
XFILLER_10_542 VGND VGND VPWR VPWR sky130_fd_sc_hd__decap_4
XFILLER_10_531 VGND VGND VPWR VPWR sky130_fd_sc_hd__fill_1
XTAP_TAPCELL_ROW_40_879 VGND VPWR sky130_fd_sc_hd__tapvpwrvgnd_1
XFILLER_127_249 VGND VGND VPWR VPWR sky130_fd_sc_hd__fill_1
XFILLER_41_52 VGND VGND VPWR VPWR sky130_fd_sc_hd__decap_4
XTAP_TAPCELL_ROW_20_592 VGND VPWR sky130_fd_sc_hd__tapvpwrvgnd_1
X_10474_ clknet_leaf_119_clk _00360_ VGND VGND VPWR VPWR picorv32_core.mem_la_wdata\[0\]
+ sky130_fd_sc_hd__dfxtp_1
XPHY_EDGE_ROW_63_Left_205 VGND VGND VPWR VPWR sky130_fd_sc_hd__decap_3
XFILLER_89_391 VGND VGND VPWR VPWR sky130_fd_sc_hd__fill_1
X_11026_ clknet_leaf_13_clk _00877_ VGND VGND VPWR VPWR picorv32_core.cpuregs\[11\]\[8\]
+ sky130_fd_sc_hd__dfxtp_1
XFILLER_92_589 VGND VGND VPWR VPWR sky130_fd_sc_hd__decap_3
XFILLER_64_269 VGND VGND VPWR VPWR sky130_fd_sc_hd__fill_2
XTAP_TAPCELL_ROW_123_2090 VGND VPWR sky130_fd_sc_hd__tapvpwrvgnd_1
XPHY_EDGE_ROW_72_Left_214 VGND VGND VPWR VPWR sky130_fd_sc_hd__decap_3
X_11859_ net968 VGND VGND VPWR VPWR net184 sky130_fd_sc_hd__clkbuf_1
XANTENNA_18 _04125_ VGND VGND VPWR VPWR sky130_fd_sc_hd__diode_2
XFILLER_60_475 VGND VGND VPWR VPWR sky130_fd_sc_hd__fill_1
XANTENNA_29 _04630_ VGND VGND VPWR VPWR sky130_fd_sc_hd__diode_2
X_05380_ _01834_ picorv32_core.decoded_imm\[8\] picorv32_core.reg_pc\[8\] VGND VGND
+ VPWR VPWR _01884_ sky130_fd_sc_hd__nand3b_1
XTAP_TAPCELL_ROW_99_1745 VGND VPWR sky130_fd_sc_hd__tapvpwrvgnd_1
XTAP_TAPCELL_ROW_99_1734 VGND VPWR sky130_fd_sc_hd__tapvpwrvgnd_1
X_07050_ _03255_ _03256_ VGND VGND VPWR VPWR _03257_ sky130_fd_sc_hd__nor2_1
XFILLER_70_3 VGND VGND VPWR VPWR sky130_fd_sc_hd__decap_3
X_06001_ _02463_ _02464_ VGND VGND VPWR VPWR _02466_ sky130_fd_sc_hd__or2_1
Xoutput114 net114 VGND VGND VPWR VPWR mem_axi_wdata[19] sky130_fd_sc_hd__buf_2
XPHY_EDGE_ROW_81_Left_223 VGND VGND VPWR VPWR sky130_fd_sc_hd__decap_3
Xoutput125 net125 VGND VGND VPWR VPWR mem_axi_wdata[29] sky130_fd_sc_hd__buf_2
Xoutput103 net103 VGND VGND VPWR VPWR mem_axi_rready sky130_fd_sc_hd__buf_2
Xoutput158 net158 VGND VGND VPWR VPWR pcpi_rs1[25] sky130_fd_sc_hd__buf_2
Xoutput147 net792 VGND VGND VPWR VPWR pcpi_rs1[15] sky130_fd_sc_hd__buf_2
Xoutput136 net136 VGND VGND VPWR VPWR mem_axi_wstrb[0] sky130_fd_sc_hd__buf_2
XTAP_TAPCELL_ROW_110_1901 VGND VPWR sky130_fd_sc_hd__tapvpwrvgnd_1
XFILLER_88_818 VGND VGND VPWR VPWR sky130_fd_sc_hd__fill_2
Xoutput169 net810 VGND VGND VPWR VPWR pcpi_rs1[6] sky130_fd_sc_hd__buf_2
X_07952_ picorv32_core.cpuregs\[12\]\[24\] picorv32_core.cpuregs\[13\]\[24\] picorv32_core.cpuregs\[14\]\[24\]
+ picorv32_core.cpuregs\[15\]\[24\] net752 net719 VGND VGND VPWR VPWR _04033_ sky130_fd_sc_hd__mux4_1
X_07883_ net695 _03964_ net620 VGND VGND VPWR VPWR _03968_ sky130_fd_sc_hd__o21a_1
X_06903_ _03118_ _03121_ VGND VGND VPWR VPWR _03122_ sky130_fd_sc_hd__nand2_1
XTAP_TAPCELL_ROW_52_1063 VGND VPWR sky130_fd_sc_hd__tapvpwrvgnd_1
XTAP_TAPCELL_ROW_52_1052 VGND VPWR sky130_fd_sc_hd__tapvpwrvgnd_1
XFILLER_95_383 VGND VGND VPWR VPWR sky130_fd_sc_hd__fill_2
X_09622_ _03511_ _03513_ VGND VGND VPWR VPWR _04801_ sky130_fd_sc_hd__or2_1
X_06834_ picorv32_core.decoded_imm_j\[12\] _02924_ VGND VGND VPWR VPWR _03058_ sky130_fd_sc_hd__nand2_1
XFILLER_46_19 VGND VGND VPWR VPWR sky130_fd_sc_hd__fill_1
X_09553_ net790 _04735_ net285 VGND VGND VPWR VPWR _01335_ sky130_fd_sc_hd__mux2_1
X_08504_ net1709 net232 net408 VGND VGND VPWR VPWR _00634_ sky130_fd_sc_hd__mux2_1
XTAP_TAPCELL_ROW_108_1874 VGND VPWR sky130_fd_sc_hd__tapvpwrvgnd_1
XPHY_EDGE_ROW_90_Left_232 VGND VGND VPWR VPWR sky130_fd_sc_hd__decap_3
X_06765_ _02918_ _02983_ net663 VGND VGND VPWR VPWR _02995_ sky130_fd_sc_hd__o21ai_1
X_06696_ picorv32_core.reg_pc\[25\] net553 _02937_ net516 VGND VGND VPWR VPWR _00223_
+ sky130_fd_sc_hd__a22o_1
X_09484_ net831 _04667_ _04669_ net478 VGND VGND VPWR VPWR _04670_ sky130_fd_sc_hd__o211a_1
X_05716_ net803 net959 VGND VGND VPWR VPWR _02200_ sky130_fd_sc_hd__xnor2_1
XTAP_TAPCELL_ROW_47_990 VGND VPWR sky130_fd_sc_hd__tapvpwrvgnd_1
X_08435_ net676 picorv32_core.decoded_imm_j\[19\] net616 picorv32_core.mem_rdata_q\[19\]
+ VGND VGND VPWR VPWR _04298_ sky130_fd_sc_hd__a22o_1
XFILLER_62_29 VGND VGND VPWR VPWR sky130_fd_sc_hd__decap_3
X_05647_ _01596_ net969 VGND VGND VPWR VPWR _02131_ sky130_fd_sc_hd__nand2_1
X_08366_ picorv32_core.mem_la_wdata\[5\] net186 net581 VGND VGND VPWR VPWR _04258_
+ sky130_fd_sc_hd__mux2_1
XFILLER_137_503 VGND VGND VPWR VPWR sky130_fd_sc_hd__fill_1
X_05578_ _02054_ _02057_ VGND VGND VPWR VPWR _02067_ sky130_fd_sc_hd__nand2_1
X_07317_ net817 picorv32_core.decoded_imm\[2\] VGND VGND VPWR VPWR _03457_ sky130_fd_sc_hd__nand2_1
X_08297_ net1186 _00749_ net438 VGND VGND VPWR VPWR _00519_ sky130_fd_sc_hd__mux2_1
X_07248_ picorv32_core.instr_sra picorv32_core.instr_srl picorv32_core.instr_srai
+ picorv32_core.instr_srli VGND VGND VPWR VPWR _03388_ sky130_fd_sc_hd__or4_4
XFILLER_124_219 VGND VGND VPWR VPWR sky130_fd_sc_hd__decap_6
X_07179_ picorv32_core.count_cycle\[37\] picorv32_core.count_cycle\[38\] picorv32_core.count_cycle\[39\]
+ _03339_ VGND VGND VPWR VPWR _03344_ sky130_fd_sc_hd__and4_1
XFILLER_133_753 VPWR VGND VPWR VGND sky130_ef_sc_hd__decap_12
XFILLER_127_55 VGND VGND VPWR VPWR sky130_fd_sc_hd__fill_1
X_10190_ clknet_leaf_138_clk _00109_ VGND VGND VPWR VPWR picorv32_core.cpuregs\[9\]\[6\]
+ sky130_fd_sc_hd__dfxtp_1
XFILLER_2_6 VPWR VGND VPWR VGND sky130_ef_sc_hd__decap_12
XFILLER_133_797 VPWR VGND VPWR VGND sky130_ef_sc_hd__decap_12
XFILLER_79_818 VGND VGND VPWR VPWR sky130_fd_sc_hd__fill_1
XFILLER_120_447 VGND VGND VPWR VPWR sky130_fd_sc_hd__fill_1
Xfanout330 net331 VGND VGND VPWR VPWR net330 sky130_fd_sc_hd__buf_4
Xfanout341 _04348_ VGND VGND VPWR VPWR net341 sky130_fd_sc_hd__clkbuf_4
Xfanout363 net364 VGND VGND VPWR VPWR net363 sky130_fd_sc_hd__clkbuf_8
XFILLER_59_553 VGND VGND VPWR VPWR sky130_fd_sc_hd__fill_1
Xfanout374 net377 VGND VGND VPWR VPWR net374 sky130_fd_sc_hd__clkbuf_8
XPHY_EDGE_ROW_129_Left_271 VGND VGND VPWR VPWR sky130_fd_sc_hd__decap_3
Xfanout385 _04336_ VGND VGND VPWR VPWR net385 sky130_fd_sc_hd__buf_4
Xfanout396 net397 VGND VGND VPWR VPWR net396 sky130_fd_sc_hd__clkbuf_8
XTAP_TAPCELL_ROW_6_398 VGND VPWR sky130_fd_sc_hd__tapvpwrvgnd_1
XTAP_TAPCELL_ROW_6_387 VGND VPWR sky130_fd_sc_hd__tapvpwrvgnd_1
XFILLER_19_428 VGND VGND VPWR VPWR sky130_fd_sc_hd__decap_4
XFILLER_86_394 VGND VGND VPWR VPWR sky130_fd_sc_hd__decap_3
XTAP_TAPCELL_ROW_83_1513 VGND VPWR sky130_fd_sc_hd__tapvpwrvgnd_1
XTAP_TAPCELL_ROW_83_1502 VGND VPWR sky130_fd_sc_hd__tapvpwrvgnd_1
XFILLER_46_269 VGND VGND VPWR VPWR sky130_fd_sc_hd__fill_1
X_11713_ clknet_leaf_62_clk _01544_ VGND VGND VPWR VPWR picorv32_core.cpuregs\[27\]\[30\]
+ sky130_fd_sc_hd__dfxtp_1
X_11644_ clknet_leaf_72_clk _01475_ VGND VGND VPWR VPWR picorv32_core.cpuregs\[28\]\[25\]
+ sky130_fd_sc_hd__dfxtp_1
XTAP_TAPCELL_ROW_25_662 VGND VPWR sky130_fd_sc_hd__tapvpwrvgnd_1
XTAP_TAPCELL_ROW_25_673 VGND VPWR sky130_fd_sc_hd__tapvpwrvgnd_1
XFILLER_30_615 VGND VGND VPWR VPWR sky130_fd_sc_hd__decap_3
XPHY_EDGE_ROW_138_Left_280 VGND VGND VPWR VPWR sky130_fd_sc_hd__decap_3
X_11575_ clknet_leaf_29_clk _01406_ VGND VGND VPWR VPWR picorv32_core.cpuregs\[2\]\[22\]
+ sky130_fd_sc_hd__dfxtp_1
Xinput27 mem_axi_rdata[30] VGND VGND VPWR VPWR net27 sky130_fd_sc_hd__clkbuf_2
XFILLER_7_833 VGND VGND VPWR VPWR sky130_fd_sc_hd__fill_1
Xinput16 mem_axi_rdata[20] VGND VGND VPWR VPWR net16 sky130_fd_sc_hd__clkbuf_2
Xinput38 resetn VGND VGND VPWR VPWR net38 sky130_fd_sc_hd__buf_2
X_10526_ clknet_leaf_55_clk picorv32_core.alu_out\[14\] VGND VGND VPWR VPWR picorv32_core.alu_out_q\[14\]
+ sky130_fd_sc_hd__dfxtp_1
X_10457_ clknet_leaf_79_clk _00344_ VGND VGND VPWR VPWR net49 sky130_fd_sc_hd__dfxtp_1
XFILLER_6_365 VGND VGND VPWR VPWR sky130_fd_sc_hd__decap_4
XTAP_TAPCELL_ROW_94_1675 VGND VPWR sky130_fd_sc_hd__tapvpwrvgnd_1
XTAP_TAPCELL_ROW_94_1664 VGND VPWR sky130_fd_sc_hd__tapvpwrvgnd_1
X_10388_ clknet_leaf_82_clk _00307_ VGND VGND VPWR VPWR picorv32_core.count_cycle\[46\]
+ sky130_fd_sc_hd__dfxtp_1
XFILLER_111_436 VGND VGND VPWR VPWR sky130_fd_sc_hd__fill_1
XFILLER_84_309 VGND VGND VPWR VPWR sky130_fd_sc_hd__decap_4
X_11009_ clknet_leaf_44_clk _00860_ VGND VGND VPWR VPWR picorv32_core.cpuregs\[12\]\[23\]
+ sky130_fd_sc_hd__dfxtp_1
XFILLER_65_512 VPWR VGND VPWR VGND sky130_ef_sc_hd__decap_12
XFILLER_38_715 VGND VGND VPWR VPWR sky130_fd_sc_hd__fill_2
XFILLER_38_726 VGND VGND VPWR VPWR sky130_fd_sc_hd__decap_4
XFILLER_92_331 VGND VGND VPWR VPWR sky130_fd_sc_hd__decap_3
XFILLER_37_225 VGND VGND VPWR VPWR sky130_fd_sc_hd__decap_3
X_06550_ _02849_ _02850_ VGND VGND VPWR VPWR _00164_ sky130_fd_sc_hd__nor2_1
XFILLER_80_559 VGND VGND VPWR VPWR sky130_fd_sc_hd__fill_2
XFILLER_18_472 VGND VGND VPWR VPWR sky130_fd_sc_hd__decap_4
X_05501_ _01979_ _01986_ VGND VGND VPWR VPWR _01996_ sky130_fd_sc_hd__and2_1
X_06481_ _02805_ _02806_ VGND VGND VPWR VPWR _00139_ sky130_fd_sc_hd__nor2_1
X_05432_ _01888_ _01892_ _01928_ _01931_ VGND VGND VPWR VPWR _01932_ sky130_fd_sc_hd__o31a_1
X_08220_ picorv32_core.instr_sra net477 _04207_ _04210_ VGND VGND VPWR VPWR _00465_
+ sky130_fd_sc_hd__a22o_1
XFILLER_33_497 VGND VGND VPWR VPWR sky130_fd_sc_hd__fill_2
XFILLER_119_503 VGND VGND VPWR VPWR sky130_fd_sc_hd__fill_1
XTAP_TAPCELL_ROW_103_1793 VGND VPWR sky130_fd_sc_hd__tapvpwrvgnd_1
X_05363_ picorv32_core.count_instr\[43\] net936 net944 picorv32_core.count_cycle\[43\]
+ VGND VGND VPWR VPWR _01868_ sky130_fd_sc_hd__a22o_1
X_08151_ picorv32_core.decoder_pseudo_trigger net970 VGND VGND VPWR VPWR _04178_ sky130_fd_sc_hd__nand2b_1
XTAP_TAPCELL_ROW_136_2281 VGND VPWR sky130_fd_sc_hd__tapvpwrvgnd_1
XTAP_TAPCELL_ROW_136_2270 VGND VPWR sky130_fd_sc_hd__tapvpwrvgnd_1
X_08082_ _04145_ _04146_ net639 VGND VGND VPWR VPWR _04156_ sky130_fd_sc_hd__mux2_1
X_07102_ picorv32_core.count_cycle\[10\] _03294_ net974 VGND VGND VPWR VPWR _03296_
+ sky130_fd_sc_hd__a21oi_1
X_05294_ net920 _01796_ _01802_ _01803_ VGND VGND VPWR VPWR _01575_ sky130_fd_sc_hd__a211o_1
X_07033_ net587 _03240_ _03241_ VGND VGND VPWR VPWR _03242_ sky130_fd_sc_hd__o21ba_1
X_08984_ net1328 net208 net351 VGND VGND VPWR VPWR _01156_ sky130_fd_sc_hd__mux2_1
XFILLER_115_797 VPWR VGND VPWR VGND sky130_ef_sc_hd__decap_12
XFILLER_88_648 VPWR VGND VPWR VGND sky130_ef_sc_hd__decap_12
XFILLER_87_136 VGND VGND VPWR VPWR sky130_fd_sc_hd__decap_4
X_07935_ picorv32_core.cpuregs\[0\]\[23\] picorv32_core.cpuregs\[1\]\[23\] picorv32_core.cpuregs\[2\]\[23\]
+ picorv32_core.cpuregs\[3\]\[23\] net756 net723 VGND VGND VPWR VPWR _04017_ sky130_fd_sc_hd__mux4_1
X_07866_ _03942_ _03950_ _03951_ net620 net689 VGND VGND VPWR VPWR _03952_ sky130_fd_sc_hd__a221o_1
X_09605_ net786 net781 net544 VGND VGND VPWR VPWR _04785_ sky130_fd_sc_hd__mux2_1
XTAP_TAPCELL_ROW_3_346 VGND VPWR sky130_fd_sc_hd__tapvpwrvgnd_1
XFILLER_83_375 VGND VGND VPWR VPWR sky130_fd_sc_hd__fill_1
X_07797_ picorv32_core.cpuregs\[20\]\[16\] picorv32_core.cpuregs\[21\]\[16\] picorv32_core.cpuregs\[22\]\[16\]
+ picorv32_core.cpuregs\[23\]\[16\] net749 net716 VGND VGND VPWR VPWR _03886_ sky130_fd_sc_hd__mux4_1
XFILLER_71_515 VGND VGND VPWR VPWR sky130_fd_sc_hd__decap_4
X_06817_ net663 _03039_ _03042_ VGND VGND VPWR VPWR _03043_ sky130_fd_sc_hd__o21ai_1
XFILLER_16_409 VGND VGND VPWR VPWR sky130_fd_sc_hd__fill_2
X_09536_ net472 _04717_ _04718_ net470 VGND VGND VPWR VPWR _04719_ sky130_fd_sc_hd__a22o_1
XFILLER_83_386 VGND VGND VPWR VPWR sky130_fd_sc_hd__decap_6
X_06748_ _02964_ _02978_ VGND VGND VPWR VPWR _02979_ sky130_fd_sc_hd__and2_1
X_09467_ _03428_ _03429_ _03487_ VGND VGND VPWR VPWR _04653_ sky130_fd_sc_hd__a21oi_1
XTAP_TAPCELL_ROW_65_1254 VGND VPWR sky130_fd_sc_hd__tapvpwrvgnd_1
XTAP_TAPCELL_ROW_65_1243 VGND VPWR sky130_fd_sc_hd__tapvpwrvgnd_1
XTAP_TAPCELL_ROW_42_908 VGND VPWR sky130_fd_sc_hd__tapvpwrvgnd_1
XTAP_TAPCELL_ROW_42_919 VGND VPWR sky130_fd_sc_hd__tapvpwrvgnd_1
X_08418_ picorv32_core.decoded_imm\[28\] net529 _04285_ _04289_ VGND VGND VPWR VPWR
+ _00582_ sky130_fd_sc_hd__o22a_1
X_06679_ _02732_ picorv32_core.reg_next_pc\[17\] net558 VGND VGND VPWR VPWR _02929_
+ sky130_fd_sc_hd__mux2_2
X_09398_ picorv32_core.reg_pc\[9\] net539 _04587_ _03392_ VGND VGND VPWR VPWR _04588_
+ sky130_fd_sc_hd__a211o_1
XTAP_TAPCELL_ROW_22_621 VGND VPWR sky130_fd_sc_hd__tapvpwrvgnd_1
X_08349_ net1180 net454 _04248_ VGND VGND VPWR VPWR _00554_ sky130_fd_sc_hd__o21a_1
XFILLER_11_169 VGND VGND VPWR VPWR sky130_fd_sc_hd__fill_2
XPHY_EDGE_ROW_129_Right_129 VGND VGND VPWR VPWR sky130_fd_sc_hd__decap_3
X_11360_ clknet_leaf_5_clk _01201_ VGND VGND VPWR VPWR picorv32_core.cpuregs\[18\]\[12\]
+ sky130_fd_sc_hd__dfxtp_1
XFILLER_22_65 VPWR VGND VPWR VGND sky130_ef_sc_hd__decap_12
XFILLER_138_65 VPWR VGND VPWR VGND sky130_ef_sc_hd__decap_12
XFILLER_118_3 VPWR VGND VPWR VGND sky130_ef_sc_hd__decap_12
XFILLER_4_825 VGND VGND VPWR VPWR sky130_fd_sc_hd__decap_8
X_10311_ clknet_leaf_122_clk _00230_ VGND VGND VPWR VPWR picorv32_core.reg_next_pc\[1\]
+ sky130_fd_sc_hd__dfxtp_1
X_11291_ clknet_leaf_6_clk _01139_ VGND VGND VPWR VPWR picorv32_core.cpuregs\[3\]\[14\]
+ sky130_fd_sc_hd__dfxtp_1
XFILLER_106_753 VGND VGND VPWR VPWR sky130_fd_sc_hd__decap_3
X_10242_ clknet_leaf_78_clk _00161_ VGND VGND VPWR VPWR picorv32_core.count_instr\[26\]
+ sky130_fd_sc_hd__dfxtp_1
X_10173_ clknet_leaf_48_clk _00092_ VGND VGND VPWR VPWR picorv32_core.cpuregs\[21\]\[21\]
+ sky130_fd_sc_hd__dfxtp_1
XFILLER_59_383 VGND VGND VPWR VPWR sky130_fd_sc_hd__fill_1
XFILLER_59_372 VGND VGND VPWR VPWR sky130_fd_sc_hd__decap_6
XFILLER_74_320 VGND VGND VPWR VPWR sky130_fd_sc_hd__decap_3
XFILLER_90_813 VGND VGND VPWR VPWR sky130_fd_sc_hd__fill_2
XFILLER_28_781 VPWR VGND VPWR VGND sky130_ef_sc_hd__decap_12
XFILLER_43_773 VGND VGND VPWR VPWR sky130_fd_sc_hd__decap_6
X_11627_ clknet_leaf_129_clk _01458_ VGND VGND VPWR VPWR picorv32_core.cpuregs\[28\]\[8\]
+ sky130_fd_sc_hd__dfxtp_1
XTAP_TAPCELL_ROW_96_1704 VGND VPWR sky130_fd_sc_hd__tapvpwrvgnd_1
Xwire550 _03387_ VGND VGND VPWR VPWR net550 sky130_fd_sc_hd__buf_1
X_11558_ clknet_leaf_137_clk _01389_ VGND VGND VPWR VPWR picorv32_core.cpuregs\[2\]\[5\]
+ sky130_fd_sc_hd__dfxtp_1
Xhold608 picorv32_core.cpuregs\[15\]\[1\] VGND VGND VPWR VPWR net1717 sky130_fd_sc_hd__dlygate4sd3_1
X_10509_ clknet_leaf_122_clk _00395_ VGND VGND VPWR VPWR picorv32_core.decoder_pseudo_trigger
+ sky130_fd_sc_hd__dfxtp_1
Xhold619 net40 VGND VGND VPWR VPWR net1728 sky130_fd_sc_hd__dlygate4sd3_1
XFILLER_6_195 VGND VGND VPWR VPWR sky130_fd_sc_hd__fill_1
X_11489_ clknet_leaf_124_clk _01325_ VGND VGND VPWR VPWR net169 sky130_fd_sc_hd__dfxtp_1
XFILLER_112_734 VPWR VGND VPWR VGND sky130_ef_sc_hd__decap_12
XFILLER_97_423 VPWR VGND VPWR VGND sky130_ef_sc_hd__decap_12
XFILLER_33_3 VPWR VGND VPWR VGND sky130_ef_sc_hd__decap_12
XFILLER_85_607 VGND VGND VPWR VPWR sky130_fd_sc_hd__fill_1
XFILLER_97_489 VGND VGND VPWR VPWR sky130_fd_sc_hd__decap_8
X_05981_ net507 _02444_ _02445_ _02447_ VGND VGND VPWR VPWR picorv32_core.alu_out\[17\]
+ sky130_fd_sc_hd__a211o_1
X_07720_ net629 _03808_ net618 VGND VGND VPWR VPWR _03814_ sky130_fd_sc_hd__o21a_1
XFILLER_38_512 VGND VGND VPWR VPWR sky130_fd_sc_hd__decap_3
XFILLER_65_331 VGND VGND VPWR VPWR sky130_fd_sc_hd__decap_4
XFILLER_93_662 VGND VGND VPWR VPWR sky130_fd_sc_hd__decap_6
XTAP_TAPCELL_ROW_0_305 VGND VPWR sky130_fd_sc_hd__tapvpwrvgnd_1
XFILLER_26_729 VPWR VGND VPWR VGND sky130_ef_sc_hd__decap_12
X_07651_ picorv32_core.decoded_imm\[7\] net590 net594 VGND VGND VPWR VPWR _03749_
+ sky130_fd_sc_hd__a21o_1
XTAP_TAPCELL_ROW_105_1822 VGND VPWR sky130_fd_sc_hd__tapvpwrvgnd_1
X_06602_ picorv32_core.count_instr\[49\] _02881_ VGND VGND VPWR VPWR _02883_ sky130_fd_sc_hd__or2_1
X_07582_ _03684_ _03685_ net633 VGND VGND VPWR VPWR _03686_ sky130_fd_sc_hd__mux2_1
XTAP_TAPCELL_ROW_105_1833 VGND VPWR sky130_fd_sc_hd__tapvpwrvgnd_1
X_06533_ net2250 _02837_ net996 VGND VGND VPWR VPWR _02840_ sky130_fd_sc_hd__o21ai_1
X_09321_ picorv32_core.cpuregs\[0\]\[6\] picorv32_core.cpuregs\[1\]\[6\] picorv32_core.cpuregs\[2\]\[6\]
+ picorv32_core.cpuregs\[3\]\[6\] net874 net841 VGND VGND VPWR VPWR _04514_ sky130_fd_sc_hd__mux4_1
XTAP_TAPCELL_ROW_138_2310 VGND VPWR sky130_fd_sc_hd__tapvpwrvgnd_1
X_06464_ net221 net2099 net419 VGND VGND VPWR VPWR _00130_ sky130_fd_sc_hd__mux2_1
X_09252_ net817 net814 net540 VGND VGND VPWR VPWR _04448_ sky130_fd_sc_hd__mux2_1
X_06395_ net564 _02788_ _02789_ _02790_ VGND VGND VPWR VPWR _02791_ sky130_fd_sc_hd__a31o_2
X_05415_ _01914_ _01915_ VGND VGND VPWR VPWR _01916_ sky130_fd_sc_hd__nand2_1
X_09183_ picorv32_core.cpuregs\[18\]\[1\] picorv32_core.cpuregs\[19\]\[1\] net886
+ VGND VGND VPWR VPWR _04381_ sky130_fd_sc_hd__mux2_1
X_08203_ picorv32_core.latched_rd\[0\] _04205_ _04206_ net1136 VGND VGND VPWR VPWR
+ _00452_ sky130_fd_sc_hd__a22o_1
Xpicorv32_axi_1018 VGND VGND VPWR VPWR picorv32_axi_1018/HI eoi[19] sky130_fd_sc_hd__conb_1
X_08134_ net214 net1836 net417 VGND VGND VPWR VPWR _00427_ sky130_fd_sc_hd__mux2_1
X_05346_ net943 picorv32_core.count_cycle\[42\] picorv32_core.count_cycle\[10\] net605
+ _01851_ VGND VGND VPWR VPWR _01852_ sky130_fd_sc_hd__a221o_1
XTAP_TAPCELL_ROW_60_1173 VGND VPWR sky130_fd_sc_hd__tapvpwrvgnd_1
Xpicorv32_axi_1007 VGND VGND VPWR VPWR picorv32_axi_1007/HI eoi[8] sky130_fd_sc_hd__conb_1
Xpicorv32_axi_1029 VGND VGND VPWR VPWR picorv32_axi_1029/HI eoi[30] sky130_fd_sc_hd__conb_1
X_08065_ _04130_ _04131_ net640 VGND VGND VPWR VPWR _04140_ sky130_fd_sc_hd__mux2_1
XFILLER_119_399 VGND VGND VPWR VPWR sky130_fd_sc_hd__fill_1
X_05277_ picorv32_core.count_cycle\[5\] net599 net576 _01787_ VGND VGND VPWR VPWR
+ _01788_ sky130_fd_sc_hd__o211a_1
XTAP_TAPCELL_ROW_116_1984 VGND VPWR sky130_fd_sc_hd__tapvpwrvgnd_1
X_07016_ _02938_ _03219_ VGND VGND VPWR VPWR _03226_ sky130_fd_sc_hd__xnor2_1
XTAP_TAPCELL_ROW_8_427 VGND VPWR sky130_fd_sc_hd__tapvpwrvgnd_1
XTAP_TAPCELL_ROW_8_416 VGND VPWR sky130_fd_sc_hd__tapvpwrvgnd_1
XFILLER_130_520 VGND VGND VPWR VPWR sky130_fd_sc_hd__fill_2
XFILLER_88_412 VGND VGND VPWR VPWR sky130_fd_sc_hd__decap_8
XFILLER_130_553 VGND VGND VPWR VPWR sky130_fd_sc_hd__decap_4
XFILLER_103_767 VGND VGND VPWR VPWR sky130_fd_sc_hd__fill_1
X_08967_ net1666 net272 net348 VGND VGND VPWR VPWR _01139_ sky130_fd_sc_hd__mux2_1
XFILLER_124_89 VGND VGND VPWR VPWR sky130_fd_sc_hd__fill_1
X_07918_ picorv32_core.cpuregs\[12\]\[22\] picorv32_core.cpuregs\[13\]\[22\] picorv32_core.cpuregs\[14\]\[22\]
+ picorv32_core.cpuregs\[15\]\[22\] net748 net715 VGND VGND VPWR VPWR _04001_ sky130_fd_sc_hd__mux4_1
X_08898_ net291 net1609 net358 VGND VGND VPWR VPWR _01072_ sky130_fd_sc_hd__mux2_1
X_07849_ _03925_ _03926_ net638 VGND VGND VPWR VPWR _03936_ sky130_fd_sc_hd__mux2_1
XFILLER_84_673 VGND VGND VPWR VPWR sky130_fd_sc_hd__fill_1
XFILLER_72_813 VGND VGND VPWR VPWR sky130_fd_sc_hd__fill_1
XFILLER_17_729 VPWR VGND VPWR VGND sky130_ef_sc_hd__decap_12
XTAP_TAPCELL_ROW_27_702 VGND VPWR sky130_fd_sc_hd__tapvpwrvgnd_1
XFILLER_17_54 VGND VGND VPWR VPWR sky130_fd_sc_hd__fill_2
X_10860_ clknet_leaf_113_clk _00711_ VGND VGND VPWR VPWR picorv32_core.cpuregs\[16\]\[4\]
+ sky130_fd_sc_hd__dfxtp_1
X_09519_ picorv32_core.cpuregs\[8\]\[15\] picorv32_core.cpuregs\[9\]\[15\] picorv32_core.cpuregs\[10\]\[15\]
+ picorv32_core.cpuregs\[11\]\[15\] net882 net849 VGND VGND VPWR VPWR _04703_ sky130_fd_sc_hd__mux4_1
XFILLER_44_559 VGND VGND VPWR VPWR sky130_fd_sc_hd__fill_2
XFILLER_140_77 VGND VGND VPWR VPWR sky130_fd_sc_hd__decap_6
X_10791_ clknet_leaf_131_clk _00642_ VGND VGND VPWR VPWR picorv32_core.cpuregs\[15\]\[0\]
+ sky130_fd_sc_hd__dfxtp_1
XFILLER_33_31 VGND VGND VPWR VPWR sky130_fd_sc_hd__fill_1
XFILLER_129_108 VGND VGND VPWR VPWR sky130_fd_sc_hd__decap_4
XFILLER_33_75 VGND VGND VPWR VPWR sky130_fd_sc_hd__decap_4
X_11412_ clknet_leaf_41_clk _01248_ VGND VGND VPWR VPWR picorv32_core.cpuregs\[31\]\[27\]
+ sky130_fd_sc_hd__dfxtp_1
XTAP_TAPCELL_ROW_78_1434 VGND VPWR sky130_fd_sc_hd__tapvpwrvgnd_1
X_11343_ clknet_leaf_41_clk _01184_ VGND VGND VPWR VPWR picorv32_core.cpuregs\[29\]\[27\]
+ sky130_fd_sc_hd__dfxtp_1
XFILLER_141_818 VGND VGND VPWR VPWR sky130_fd_sc_hd__fill_1
X_11274_ clknet_leaf_70_clk _01122_ VGND VGND VPWR VPWR picorv32_core.cpuregs\[4\]\[29\]
+ sky130_fd_sc_hd__dfxtp_1
XTAP_TAPCELL_ROW_91_1623 VGND VPWR sky130_fd_sc_hd__tapvpwrvgnd_1
XFILLER_79_401 VGND VGND VPWR VPWR sky130_fd_sc_hd__fill_2
X_10225_ clknet_leaf_101_clk _00144_ VGND VGND VPWR VPWR picorv32_core.count_instr\[9\]
+ sky130_fd_sc_hd__dfxtp_1
XFILLER_133_391 VGND VGND VPWR VPWR sky130_fd_sc_hd__fill_1
XFILLER_79_445 VGND VGND VPWR VPWR sky130_fd_sc_hd__decap_3
XFILLER_48_821 VGND VGND VPWR VPWR sky130_fd_sc_hd__decap_3
X_10156_ clknet_leaf_121_clk _00075_ VGND VGND VPWR VPWR picorv32_core.cpuregs\[21\]\[4\]
+ sky130_fd_sc_hd__dfxtp_1
XFILLER_94_459 VPWR VGND VPWR VGND sky130_ef_sc_hd__decap_12
X_10087_ net1113 VGND VGND VPWR VPWR _00937_ sky130_fd_sc_hd__clkbuf_1
Xhold5 picorv32_core.cpuregs\[0\]\[8\] VGND VGND VPWR VPWR net1114 sky130_fd_sc_hd__dlygate4sd3_1
XFILLER_47_331 VGND VGND VPWR VPWR sky130_fd_sc_hd__fill_1
XFILLER_74_150 VGND VGND VPWR VPWR sky130_fd_sc_hd__fill_1
XTAP_TAPCELL_ROW_89_1596 VGND VPWR sky130_fd_sc_hd__tapvpwrvgnd_1
XFILLER_35_548 VPWR VGND VPWR VGND sky130_ef_sc_hd__decap_12
XFILLER_47_386 VGND VGND VPWR VPWR sky130_fd_sc_hd__decap_6
XFILLER_90_643 VGND VGND VPWR VPWR sky130_fd_sc_hd__fill_1
XFILLER_90_687 VGND VGND VPWR VPWR sky130_fd_sc_hd__fill_2
X_10989_ clknet_leaf_117_clk _00840_ VGND VGND VPWR VPWR picorv32_core.cpuregs\[12\]\[3\]
+ sky130_fd_sc_hd__dfxtp_1
XTAP_TAPCELL_ROW_100_1752 VGND VPWR sky130_fd_sc_hd__tapvpwrvgnd_1
XFILLER_31_765 VPWR VGND VPWR VGND sky130_ef_sc_hd__decap_12
X_05200_ net928 net925 VGND VGND VPWR VPWR _01716_ sky130_fd_sc_hd__or2_1
XFILLER_7_460 VGND VGND VPWR VPWR sky130_fd_sc_hd__fill_1
XTAP_TAPCELL_ROW_13_495 VGND VPWR sky130_fd_sc_hd__tapvpwrvgnd_1
X_06180_ picorv32_core.cpuregs\[20\]\[2\] picorv32_core.cpuregs\[21\]\[2\] picorv32_core.cpuregs\[22\]\[2\]
+ picorv32_core.cpuregs\[23\]\[2\] net733 net700 VGND VGND VPWR VPWR _02612_ sky130_fd_sc_hd__mux4_1
Xhold416 picorv32_core.cpuregs\[20\]\[28\] VGND VGND VPWR VPWR net1525 sky130_fd_sc_hd__dlygate4sd3_1
XTAP_TAPCELL_ROW_133_2240 VGND VPWR sky130_fd_sc_hd__tapvpwrvgnd_1
Xhold405 picorv32_core.cpuregs\[27\]\[17\] VGND VGND VPWR VPWR net1514 sky130_fd_sc_hd__dlygate4sd3_1
X_05131_ _01642_ _01659_ _01661_ VGND VGND VPWR VPWR _01662_ sky130_fd_sc_hd__or3_1
Xhold427 picorv32_core.cpuregs\[23\]\[2\] VGND VGND VPWR VPWR net1536 sky130_fd_sc_hd__dlygate4sd3_1
Xhold438 picorv32_core.cpuregs\[12\]\[25\] VGND VGND VPWR VPWR net1547 sky130_fd_sc_hd__dlygate4sd3_1
Xhold449 picorv32_core.cpuregs\[14\]\[13\] VGND VGND VPWR VPWR net1558 sky130_fd_sc_hd__dlygate4sd3_1
X_05062_ net1115 VGND VGND VPWR VPWR _01597_ sky130_fd_sc_hd__inv_2
Xfanout907 _00005_ VGND VGND VPWR VPWR net907 sky130_fd_sc_hd__buf_4
X_09870_ net1313 net428 net325 VGND VGND VPWR VPWR _01358_ sky130_fd_sc_hd__mux2_1
Xfanout918 net919 VGND VGND VPWR VPWR net918 sky130_fd_sc_hd__buf_2
Xfanout929 picorv32_core.mem_rdata_q\[14\] VGND VGND VPWR VPWR net929 sky130_fd_sc_hd__buf_2
X_08821_ net1203 net504 net369 VGND VGND VPWR VPWR _00997_ sky130_fd_sc_hd__mux2_1
XFILLER_112_586 VGND VGND VPWR VPWR sky130_fd_sc_hd__fill_2
Xhold1105 picorv32_core.cpuregs\[2\]\[7\] VGND VGND VPWR VPWR net2214 sky130_fd_sc_hd__dlygate4sd3_1
Xhold1116 picorv32_core.cpuregs\[17\]\[21\] VGND VGND VPWR VPWR net2225 sky130_fd_sc_hd__dlygate4sd3_1
X_08752_ net2192 net206 net380 VGND VGND VPWR VPWR _00900_ sky130_fd_sc_hd__mux2_1
Xhold1149 picorv32_core.count_instr\[26\] VGND VGND VPWR VPWR net2258 sky130_fd_sc_hd__dlygate4sd3_1
Xhold1138 picorv32_core.count_instr\[47\] VGND VGND VPWR VPWR net2247 sky130_fd_sc_hd__dlygate4sd3_1
X_05964_ net789 _02431_ VGND VGND VPWR VPWR _02432_ sky130_fd_sc_hd__nand2_1
Xhold1127 picorv32_core.cpuregs\[4\]\[3\] VGND VGND VPWR VPWR net2236 sky130_fd_sc_hd__dlygate4sd3_1
X_08683_ net217 net1676 net389 VGND VGND VPWR VPWR _00833_ sky130_fd_sc_hd__mux2_1
XFILLER_66_662 VGND VGND VPWR VPWR sky130_fd_sc_hd__fill_1
XFILLER_54_813 VGND VGND VPWR VPWR sky130_fd_sc_hd__fill_2
XFILLER_38_353 VGND VGND VPWR VPWR sky130_fd_sc_hd__fill_1
X_07703_ _03789_ _03796_ _03797_ net617 net687 VGND VGND VPWR VPWR _03798_ sky130_fd_sc_hd__a221o_1
XFILLER_93_470 VPWR VGND VPWR VGND sky130_ef_sc_hd__decap_12
X_05895_ net799 _02366_ VGND VGND VPWR VPWR _02368_ sky130_fd_sc_hd__nor2_1
XTAP_TAPCELL_ROW_49_1013 VGND VPWR sky130_fd_sc_hd__tapvpwrvgnd_1
X_07634_ picorv32_core.cpuregs\[20\]\[7\] picorv32_core.cpuregs\[21\]\[7\] picorv32_core.cpuregs\[22\]\[7\]
+ picorv32_core.cpuregs\[23\]\[7\] net735 net702 VGND VGND VPWR VPWR _03732_ sky130_fd_sc_hd__mux4_1
XTAP_TAPCELL_ROW_62_1202 VGND VPWR sky130_fd_sc_hd__tapvpwrvgnd_1
X_07565_ net619 _03657_ _03661_ _03668_ _03669_ VGND VGND VPWR VPWR _03670_ sky130_fd_sc_hd__a32o_1
X_07496_ net2265 _03618_ net462 VGND VGND VPWR VPWR _00342_ sky130_fd_sc_hd__mux2_1
X_06516_ _01587_ _02826_ _02828_ net976 VGND VGND VPWR VPWR _00152_ sky130_fd_sc_hd__a211oi_1
X_09304_ _04493_ _04496_ _04497_ net648 net642 VGND VGND VPWR VPWR _04498_ sky130_fd_sc_hd__a221o_1
XFILLER_22_754 VGND VGND VPWR VPWR sky130_fd_sc_hd__fill_2
XFILLER_70_29 VGND VGND VPWR VPWR sky130_fd_sc_hd__decap_3
X_09235_ _04429_ _04430_ net656 VGND VGND VPWR VPWR _04431_ sky130_fd_sc_hd__mux2_1
X_06447_ net296 net1882 net418 VGND VGND VPWR VPWR _00113_ sky130_fd_sc_hd__mux2_1
XTAP_TAPCELL_ROW_32_771 VGND VPWR sky130_fd_sc_hd__tapvpwrvgnd_1
X_06378_ _02775_ _02776_ VGND VGND VPWR VPWR _02777_ sky130_fd_sc_hd__nor2_1
X_09166_ picorv32_core.cpuregs\[20\]\[0\] picorv32_core.cpuregs\[21\]\[0\] picorv32_core.cpuregs\[22\]\[0\]
+ picorv32_core.cpuregs\[23\]\[0\] net884 net851 VGND VGND VPWR VPWR _04365_ sky130_fd_sc_hd__mux4_1
X_08117_ net288 net1691 net415 VGND VGND VPWR VPWR _00410_ sky130_fd_sc_hd__mux2_1
X_05329_ picorv32_core.reg_pc\[9\] picorv32_core.decoded_imm\[9\] VGND VGND VPWR VPWR
+ _01836_ sky130_fd_sc_hd__nand2_1
X_09097_ net290 net1932 net332 VGND VGND VPWR VPWR _01264_ sky130_fd_sc_hd__mux2_1
X_08048_ net686 _04122_ net626 VGND VGND VPWR VPWR _04124_ sky130_fd_sc_hd__a21o_1
Xhold972 picorv32_core.cpuregs\[10\]\[27\] VGND VGND VPWR VPWR net2081 sky130_fd_sc_hd__dlygate4sd3_1
Xhold961 picorv32_core.cpuregs\[25\]\[13\] VGND VGND VPWR VPWR net2070 sky130_fd_sc_hd__dlygate4sd3_1
Xhold950 picorv32_core.cpuregs\[16\]\[2\] VGND VGND VPWR VPWR net2059 sky130_fd_sc_hd__dlygate4sd3_1
XFILLER_135_55 VGND VGND VPWR VPWR sky130_fd_sc_hd__fill_1
XFILLER_89_743 VGND VGND VPWR VPWR sky130_fd_sc_hd__decap_3
XTAP_TAPCELL_ROW_73_1364 VGND VPWR sky130_fd_sc_hd__tapvpwrvgnd_1
XFILLER_0_113 VPWR VGND VPWR VGND sky130_ef_sc_hd__decap_12
Xhold994 net68 VGND VGND VPWR VPWR net2103 sky130_fd_sc_hd__dlygate4sd3_1
X_10010_ net1719 net466 net309 VGND VGND VPWR VPWR _01486_ sky130_fd_sc_hd__mux2_1
Xhold983 picorv32_core.cpuregs\[28\]\[9\] VGND VGND VPWR VPWR net2092 sky130_fd_sc_hd__dlygate4sd3_1
X_09999_ net1982 _02773_ net315 VGND VGND VPWR VPWR _01476_ sky130_fd_sc_hd__mux2_1
XFILLER_95_15 VGND VGND VPWR VPWR sky130_fd_sc_hd__decap_6
XFILLER_88_253 VGND VGND VPWR VPWR sky130_fd_sc_hd__decap_3
XFILLER_76_404 VPWR VGND VPWR VGND sky130_ef_sc_hd__decap_12
XFILLER_72_632 VGND VGND VPWR VPWR sky130_fd_sc_hd__fill_1
XFILLER_17_537 VGND VGND VPWR VPWR sky130_fd_sc_hd__fill_2
X_10912_ clknet_leaf_112_clk _00763_ VGND VGND VPWR VPWR picorv32_core.mem_rdata_q\[22\]
+ sky130_fd_sc_hd__dfxtp_2
XFILLER_72_643 VGND VGND VPWR VPWR sky130_fd_sc_hd__fill_1
X_10843_ clknet_leaf_41_clk _00694_ VGND VGND VPWR VPWR picorv32_core.cpuregs\[17\]\[20\]
+ sky130_fd_sc_hd__dfxtp_1
XFILLER_72_698 VGND VGND VPWR VPWR sky130_fd_sc_hd__fill_2
XFILLER_25_570 VGND VGND VPWR VPWR sky130_fd_sc_hd__decap_3
X_10774_ clknet_leaf_9_clk _00625_ VGND VGND VPWR VPWR picorv32_core.cpuregs\[14\]\[15\]
+ sky130_fd_sc_hd__dfxtp_1
XFILLER_44_74 VGND VGND VPWR VPWR sky130_fd_sc_hd__fill_1
XFILLER_9_725 VGND VGND VPWR VPWR sky130_fd_sc_hd__decap_3
XFILLER_13_765 VPWR VGND VPWR VGND sky130_ef_sc_hd__decap_12
XFILLER_12_264 VGND VGND VPWR VPWR sky130_fd_sc_hd__fill_2
XTAP_TAPCELL_ROW_10_443 VGND VPWR sky130_fd_sc_hd__tapvpwrvgnd_1
XTAP_TAPCELL_ROW_10_454 VGND VPWR sky130_fd_sc_hd__tapvpwrvgnd_1
X_11326_ clknet_leaf_2_clk _01167_ VGND VGND VPWR VPWR picorv32_core.cpuregs\[29\]\[10\]
+ sky130_fd_sc_hd__dfxtp_1
XFILLER_5_57 VPWR VGND VPWR VGND sky130_ef_sc_hd__decap_12
XFILLER_4_474 VGND VGND VPWR VPWR sky130_fd_sc_hd__fill_2
X_11257_ clknet_leaf_7_clk _01105_ VGND VGND VPWR VPWR picorv32_core.cpuregs\[4\]\[12\]
+ sky130_fd_sc_hd__dfxtp_1
X_10208_ clknet_leaf_39_clk _00127_ VGND VGND VPWR VPWR picorv32_core.cpuregs\[9\]\[24\]
+ sky130_fd_sc_hd__dfxtp_1
X_11188_ clknet_leaf_3_clk _01039_ VGND VGND VPWR VPWR picorv32_core.cpuregs\[6\]\[10\]
+ sky130_fd_sc_hd__dfxtp_1
X_10139_ clknet_leaf_34_clk _00061_ VGND VGND VPWR VPWR picorv32_core.cpuregs\[22\]\[22\]
+ sky130_fd_sc_hd__dfxtp_1
XFILLER_95_779 VGND VGND VPWR VPWR sky130_fd_sc_hd__decap_4
XFILLER_36_813 VPWR VGND VPWR VGND sky130_ef_sc_hd__decap_12
XFILLER_48_673 VGND VGND VPWR VPWR sky130_fd_sc_hd__fill_2
X_05680_ net971 net197 VGND VGND VPWR VPWR _02164_ sky130_fd_sc_hd__or2_1
XFILLER_90_451 VGND VGND VPWR VPWR sky130_fd_sc_hd__fill_1
XFILLER_90_484 VGND VGND VPWR VPWR sky130_fd_sc_hd__decap_3
XFILLER_63_698 VGND VGND VPWR VPWR sky130_fd_sc_hd__decap_3
XTAP_TAPCELL_ROW_18_565 VGND VPWR sky130_fd_sc_hd__tapvpwrvgnd_1
X_07350_ _03423_ _03424_ _03427_ VGND VGND VPWR VPWR _03490_ sky130_fd_sc_hd__nor3_1
XFILLER_62_197 VGND VGND VPWR VPWR sky130_fd_sc_hd__decap_3
X_06301_ _02713_ _02714_ net566 VGND VGND VPWR VPWR _02715_ sky130_fd_sc_hd__mux2_1
X_07281_ net787 picorv32_core.decoded_imm\[17\] VGND VGND VPWR VPWR _03421_ sky130_fd_sc_hd__or2_1
X_09020_ net502 net2193 net341 VGND VGND VPWR VPWR _01189_ sky130_fd_sc_hd__mux2_1
XFILLER_31_573 VGND VGND VPWR VPWR sky130_fd_sc_hd__decap_4
X_06232_ picorv32_core.is_slli_srli_srai picorv32_core.decoded_imm_j\[4\] net913 VGND
+ VGND VPWR VPWR _02662_ sky130_fd_sc_hd__a21oi_1
Xhold202 picorv32_core.cpuregs\[19\]\[5\] VGND VGND VPWR VPWR net1311 sky130_fd_sc_hd__dlygate4sd3_1
X_06163_ picorv32_core.mem_rdata_q\[22\] net18 net518 VGND VGND VPWR VPWR _00763_
+ sky130_fd_sc_hd__mux2_1
Xhold213 picorv32_core.cpuregs\[20\]\[30\] VGND VGND VPWR VPWR net1322 sky130_fd_sc_hd__dlygate4sd3_1
XFILLER_105_818 VGND VGND VPWR VPWR sky130_fd_sc_hd__decap_3
X_05114_ net984 picorv32_core.cpu_state\[5\] _01632_ VGND VGND VPWR VPWR _01646_ sky130_fd_sc_hd__and3_1
Xhold235 picorv32_core.cpuregs\[27\]\[5\] VGND VGND VPWR VPWR net1344 sky130_fd_sc_hd__dlygate4sd3_1
Xhold224 picorv32_core.cpuregs\[24\]\[8\] VGND VGND VPWR VPWR net1333 sky130_fd_sc_hd__dlygate4sd3_1
XTAP_TAPCELL_ROW_113_1943 VGND VPWR sky130_fd_sc_hd__tapvpwrvgnd_1
XFILLER_104_306 VGND VGND VPWR VPWR sky130_fd_sc_hd__fill_2
X_06094_ _01614_ _02550_ VGND VGND VPWR VPWR _02551_ sky130_fd_sc_hd__xnor2_1
Xhold246 picorv32_core.cpuregs\[30\]\[17\] VGND VGND VPWR VPWR net1355 sky130_fd_sc_hd__dlygate4sd3_1
XFILLER_49_19 VGND VGND VPWR VPWR sky130_fd_sc_hd__fill_1
Xhold268 picorv32_core.cpuregs\[15\]\[10\] VGND VGND VPWR VPWR net1377 sky130_fd_sc_hd__dlygate4sd3_1
Xhold257 picorv32_core.cpuregs\[30\]\[10\] VGND VGND VPWR VPWR net1366 sky130_fd_sc_hd__dlygate4sd3_1
X_09922_ net240 net1974 net322 VGND VGND VPWR VPWR _01406_ sky130_fd_sc_hd__mux2_1
Xfanout715 net716 VGND VGND VPWR VPWR net715 sky130_fd_sc_hd__clkbuf_4
X_05045_ net923 VGND VGND VPWR VPWR _01580_ sky130_fd_sc_hd__inv_2
Xfanout704 net705 VGND VGND VPWR VPWR net704 sky130_fd_sc_hd__clkbuf_4
Xhold279 picorv32_core.cpuregs\[7\]\[2\] VGND VGND VPWR VPWR net1388 sky130_fd_sc_hd__dlygate4sd3_1
X_09853_ _05013_ _05014_ _05018_ _05019_ net661 net647 VGND VGND VPWR VPWR _05022_
+ sky130_fd_sc_hd__mux4_1
XFILLER_131_169 VGND VGND VPWR VPWR sky130_fd_sc_hd__decap_3
XFILLER_131_158 VGND VGND VPWR VPWR sky130_fd_sc_hd__fill_2
Xfanout726 net727 VGND VGND VPWR VPWR net726 sky130_fd_sc_hd__clkbuf_4
Xfanout748 net749 VGND VGND VPWR VPWR net748 sky130_fd_sc_hd__buf_4
Xfanout737 net738 VGND VGND VPWR VPWR net737 sky130_fd_sc_hd__buf_4
X_09784_ picorv32_core.cpuregs\[4\]\[27\] picorv32_core.cpuregs\[5\]\[27\] picorv32_core.cpuregs\[6\]\[27\]
+ picorv32_core.cpuregs\[7\]\[27\] net898 net864 VGND VGND VPWR VPWR _04956_ sky130_fd_sc_hd__mux4_1
Xfanout759 net760 VGND VGND VPWR VPWR net759 sky130_fd_sc_hd__buf_4
XFILLER_86_757 VPWR VGND VPWR VGND sky130_ef_sc_hd__decap_12
X_08804_ net261 net2167 net372 VGND VGND VPWR VPWR _00982_ sky130_fd_sc_hd__mux2_1
X_06996_ _03206_ _03207_ net990 VGND VGND VPWR VPWR _00253_ sky130_fd_sc_hd__o21a_1
XFILLER_105_69 VGND VGND VPWR VPWR sky130_fd_sc_hd__fill_2
X_08735_ net1457 net273 net379 VGND VGND VPWR VPWR _00883_ sky130_fd_sc_hd__mux2_1
XFILLER_100_589 VPWR VGND VPWR VGND sky130_ef_sc_hd__decap_12
X_05947_ net791 _02414_ VGND VGND VPWR VPWR _02416_ sky130_fd_sc_hd__xnor2_1
XFILLER_39_695 VGND VGND VPWR VPWR sky130_fd_sc_hd__decap_4
X_05878_ net960 net204 _02331_ net669 VGND VGND VPWR VPWR _02352_ sky130_fd_sc_hd__o31a_1
X_08666_ net292 net1736 net387 VGND VGND VPWR VPWR _00816_ sky130_fd_sc_hd__mux2_1
XTAP_TAPCELL_ROW_37_841 VGND VPWR sky130_fd_sc_hd__tapvpwrvgnd_1
X_08597_ net277 net2201 net395 VGND VGND VPWR VPWR _00720_ sky130_fd_sc_hd__mux2_1
X_07617_ net693 _03715_ VGND VGND VPWR VPWR _03716_ sky130_fd_sc_hd__or2_1
X_07548_ _01632_ net576 _03647_ _01699_ picorv32_core.mem_do_wdata VGND VGND VPWR
+ VPWR _00359_ sky130_fd_sc_hd__a32o_1
XFILLER_139_225 VGND VGND VPWR VPWR sky130_fd_sc_hd__decap_4
X_07479_ picorv32_core.reg_out\[13\] picorv32_core.reg_next_pc\[13\] net557 VGND VGND
+ VPWR VPWR _03607_ sky130_fd_sc_hd__mux2_1
XFILLER_14_77 VGND VGND VPWR VPWR sky130_fd_sc_hd__decap_6
Xclkbuf_leaf_142_clk clknet_4_0_0_clk VGND VGND VPWR VPWR clknet_leaf_142_clk sky130_fd_sc_hd__clkbuf_8
XFILLER_127_409 VGND VGND VPWR VPWR sky130_fd_sc_hd__fill_1
XPHY_EDGE_ROW_101_Left_243 VGND VGND VPWR VPWR sky130_fd_sc_hd__decap_3
X_10490_ clknet_leaf_18_clk _00376_ VGND VGND VPWR VPWR net180 sky130_fd_sc_hd__dfxtp_1
XFILLER_10_757 VPWR VGND VPWR VGND sky130_ef_sc_hd__decap_12
X_09218_ picorv32_core.cpuregs\[20\]\[2\] picorv32_core.cpuregs\[21\]\[2\] picorv32_core.cpuregs\[22\]\[2\]
+ picorv32_core.cpuregs\[23\]\[2\] net876 net842 VGND VGND VPWR VPWR _04415_ sky130_fd_sc_hd__mux4_1
X_09149_ net1913 net212 net331 VGND VGND VPWR VPWR _01315_ sky130_fd_sc_hd__mux2_1
XFILLER_5_205 VPWR VGND VPWR VGND sky130_ef_sc_hd__decap_12
XFILLER_108_678 VGND VGND VPWR VPWR sky130_fd_sc_hd__fill_1
X_11111_ clknet_leaf_72_clk _00962_ VGND VGND VPWR VPWR picorv32_core.cpuregs\[0\]\[29\]
+ sky130_fd_sc_hd__dfxtp_1
XFILLER_100_3 VPWR VGND VPWR VGND sky130_ef_sc_hd__decap_12
Xhold780 picorv32_core.cpuregs\[28\]\[24\] VGND VGND VPWR VPWR net1889 sky130_fd_sc_hd__dlygate4sd3_1
Xhold791 picorv32_core.cpuregs\[13\]\[20\] VGND VGND VPWR VPWR net1900 sky130_fd_sc_hd__dlygate4sd3_1
XFILLER_89_540 VGND VGND VPWR VPWR sky130_fd_sc_hd__decap_8
X_11042_ clknet_leaf_33_clk _00893_ VGND VGND VPWR VPWR picorv32_core.cpuregs\[11\]\[24\]
+ sky130_fd_sc_hd__dfxtp_1
XPHY_EDGE_ROW_110_Left_252 VGND VGND VPWR VPWR sky130_fd_sc_hd__decap_3
XFILLER_64_418 VGND VGND VPWR VPWR sky130_fd_sc_hd__fill_2
XFILLER_57_481 VGND VGND VPWR VPWR sky130_fd_sc_hd__decap_8
XFILLER_18_813 VGND VGND VPWR VPWR sky130_fd_sc_hd__fill_1
XTAP_TAPCELL_ROW_86_1555 VGND VPWR sky130_fd_sc_hd__tapvpwrvgnd_1
XFILLER_45_698 VGND VGND VPWR VPWR sky130_fd_sc_hd__fill_2
X_10826_ clknet_leaf_118_clk _00677_ VGND VGND VPWR VPWR picorv32_core.cpuregs\[17\]\[3\]
+ sky130_fd_sc_hd__dfxtp_1
XTAP_TAPCELL_ROW_15_524 VGND VPWR sky130_fd_sc_hd__tapvpwrvgnd_1
Xclkbuf_leaf_133_clk clknet_4_2_0_clk VGND VGND VPWR VPWR clknet_leaf_133_clk sky130_fd_sc_hd__clkbuf_8
X_10757_ clknet_leaf_112_clk _00608_ VGND VGND VPWR VPWR picorv32_core.decoded_imm\[2\]
+ sky130_fd_sc_hd__dfxtp_1
X_10688_ clknet_leaf_98_clk _00539_ VGND VGND VPWR VPWR picorv32_core.is_alu_reg_imm
+ sky130_fd_sc_hd__dfxtp_1
XFILLER_9_577 VGND VGND VPWR VPWR sky130_fd_sc_hd__fill_2
XFILLER_138_280 VGND VGND VPWR VPWR sky130_fd_sc_hd__fill_1
XFILLER_126_475 VGND VGND VPWR VPWR sky130_fd_sc_hd__fill_1
XFILLER_5_783 VGND VGND VPWR VPWR sky130_fd_sc_hd__fill_1
X_11309_ clknet_leaf_95_clk _00010_ VGND VGND VPWR VPWR picorv32_core.cpu_state\[0\]
+ sky130_fd_sc_hd__dfxtp_1
XFILLER_113_169 VGND VGND VPWR VPWR sky130_fd_sc_hd__decap_3
XFILLER_68_757 VGND VGND VPWR VPWR sky130_fd_sc_hd__decap_6
X_06850_ _03023_ _03037_ _03070_ VGND VGND VPWR VPWR _03073_ sky130_fd_sc_hd__and3b_1
XTAP_TAPCELL_ROW_128_2161 VGND VPWR sky130_fd_sc_hd__tapvpwrvgnd_1
XFILLER_95_554 VGND VGND VPWR VPWR sky130_fd_sc_hd__decap_6
X_05801_ _02268_ _02270_ _02267_ VGND VGND VPWR VPWR _02282_ sky130_fd_sc_hd__a21bo_1
XFILLER_83_749 VGND VGND VPWR VPWR sky130_fd_sc_hd__decap_6
X_06781_ _03006_ _03009_ net587 VGND VGND VPWR VPWR _03010_ sky130_fd_sc_hd__a21oi_1
X_08520_ net1363 net447 net402 VGND VGND VPWR VPWR _00647_ sky130_fd_sc_hd__mux2_1
XFILLER_36_643 VGND VGND VPWR VPWR sky130_fd_sc_hd__fill_1
XFILLER_36_654 VGND VGND VPWR VPWR sky130_fd_sc_hd__decap_3
X_05732_ _02214_ _02215_ _02125_ VGND VGND VPWR VPWR _02216_ sky130_fd_sc_hd__o21ai_1
XFILLER_48_492 VGND VGND VPWR VPWR sky130_fd_sc_hd__fill_2
XTAP_TAPCELL_ROW_141_2361 VGND VPWR sky130_fd_sc_hd__tapvpwrvgnd_1
XTAP_TAPCELL_ROW_141_2350 VGND VPWR sky130_fd_sc_hd__tapvpwrvgnd_1
XFILLER_91_771 VGND VGND VPWR VPWR sky130_fd_sc_hd__fill_1
X_05663_ _02145_ _02146_ _02144_ VGND VGND VPWR VPWR _02147_ sky130_fd_sc_hd__a21oi_1
XFILLER_63_462 VGND VGND VPWR VPWR sky130_fd_sc_hd__fill_2
X_08451_ picorv32_core.is_sb_sh_sw _04227_ picorv32_core.mem_rdata_q\[31\] VGND VGND
+ VPWR VPWR _04306_ sky130_fd_sc_hd__o21a_1
XTAP_TAPCELL_ROW_34_800 VGND VPWR sky130_fd_sc_hd__tapvpwrvgnd_1
XFILLER_36_687 VGND VGND VPWR VPWR sky130_fd_sc_hd__decap_4
X_07402_ _01602_ _01688_ _01706_ _02073_ net545 VGND VGND VPWR VPWR _03542_ sky130_fd_sc_hd__a221o_1
XFILLER_51_646 VGND VGND VPWR VPWR sky130_fd_sc_hd__decap_3
X_05594_ _02080_ _02081_ VGND VGND VPWR VPWR _02082_ sky130_fd_sc_hd__nand2_1
X_08382_ net954 net586 net452 _04247_ VGND VGND VPWR VPWR _04266_ sky130_fd_sc_hd__a211o_2
X_07333_ _03456_ _03467_ _03468_ _03472_ VGND VGND VPWR VPWR _03473_ sky130_fd_sc_hd__a211oi_2
Xclkbuf_leaf_124_clk clknet_4_9_0_clk VGND VGND VPWR VPWR clknet_leaf_124_clk sky130_fd_sc_hd__clkbuf_8
XFILLER_137_729 VPWR VGND VPWR VGND sky130_ef_sc_hd__decap_12
XFILLER_109_409 VGND VGND VPWR VPWR sky130_fd_sc_hd__fill_1
X_07264_ net768 picorv32_core.decoded_imm\[27\] VGND VGND VPWR VPWR _03404_ sky130_fd_sc_hd__nand2_1
X_09003_ net265 net1575 net346 VGND VGND VPWR VPWR _01173_ sky130_fd_sc_hd__mux2_1
X_06215_ picorv32_core.cpuregs\[0\]\[4\] picorv32_core.cpuregs\[1\]\[4\] picorv32_core.cpuregs\[2\]\[4\]
+ picorv32_core.cpuregs\[3\]\[4\] net745 net712 VGND VGND VPWR VPWR _02645_ sky130_fd_sc_hd__mux4_1
X_07195_ picorv32_core.count_cycle\[43\] picorv32_core.count_cycle\[44\] picorv32_core.count_cycle\[45\]
+ _03349_ VGND VGND VPWR VPWR _03354_ sky130_fd_sc_hd__and4_1
X_06146_ net508 _02598_ _02594_ VGND VGND VPWR VPWR picorv32_core.alu_out\[31\] sky130_fd_sc_hd__a21o_1
XTAP_TAPCELL_ROW_57_1134 VGND VPWR sky130_fd_sc_hd__tapvpwrvgnd_1
X_06077_ net771 net190 _02248_ VGND VGND VPWR VPWR _02536_ sky130_fd_sc_hd__a21oi_1
XTAP_TAPCELL_ROW_70_1323 VGND VPWR sky130_fd_sc_hd__tapvpwrvgnd_1
Xfanout512 net513 VGND VGND VPWR VPWR net512 sky130_fd_sc_hd__clkbuf_4
Xfanout523 net525 VGND VGND VPWR VPWR net523 sky130_fd_sc_hd__clkbuf_2
X_09905_ net447 net1726 net320 VGND VGND VPWR VPWR _01389_ sky130_fd_sc_hd__mux2_1
Xfanout501 _02672_ VGND VGND VPWR VPWR net501 sky130_fd_sc_hd__buf_1
Xfanout534 net535 VGND VGND VPWR VPWR net534 sky130_fd_sc_hd__buf_2
Xfanout545 net546 VGND VGND VPWR VPWR net545 sky130_fd_sc_hd__clkbuf_2
Xfanout556 net557 VGND VGND VPWR VPWR net556 sky130_fd_sc_hd__buf_2
X_09836_ net834 _05002_ _05005_ net481 VGND VGND VPWR VPWR _05006_ sky130_fd_sc_hd__o211a_1
Xfanout578 net580 VGND VGND VPWR VPWR net578 sky130_fd_sc_hd__buf_2
XFILLER_86_543 VGND VGND VPWR VPWR sky130_fd_sc_hd__fill_2
XFILLER_74_705 VGND VGND VPWR VPWR sky130_fd_sc_hd__fill_1
Xfanout567 net568 VGND VGND VPWR VPWR net567 sky130_fd_sc_hd__buf_2
Xfanout589 _01700_ VGND VGND VPWR VPWR net589 sky130_fd_sc_hd__clkbuf_4
X_09767_ net839 _04938_ net829 VGND VGND VPWR VPWR _04940_ sky130_fd_sc_hd__o21a_1
X_06979_ _03190_ _03191_ VGND VGND VPWR VPWR _03192_ sky130_fd_sc_hd__nand2_1
XFILLER_86_598 VGND VGND VPWR VPWR sky130_fd_sc_hd__decap_4
XFILLER_27_621 VGND VGND VPWR VPWR sky130_fd_sc_hd__fill_1
X_08718_ net1803 net210 net385 VGND VGND VPWR VPWR _00867_ sky130_fd_sc_hd__mux2_1
X_09698_ picorv32_core.cpuregs\[28\]\[23\] picorv32_core.cpuregs\[29\]\[23\] picorv32_core.cpuregs\[30\]\[23\]
+ picorv32_core.cpuregs\[31\]\[23\] net898 net864 VGND VGND VPWR VPWR _04874_ sky130_fd_sc_hd__mux4_1
X_08649_ net1520 net223 net392 VGND VGND VPWR VPWR _00800_ sky130_fd_sc_hd__mux2_1
XFILLER_92_49 VGND VGND VPWR VPWR sky130_fd_sc_hd__decap_6
XFILLER_92_38 VGND VGND VPWR VPWR sky130_fd_sc_hd__fill_2
XTAP_TAPCELL_ROW_68_1296 VGND VPWR sky130_fd_sc_hd__tapvpwrvgnd_1
XTAP_TAPCELL_ROW_68_1285 VGND VPWR sky130_fd_sc_hd__tapvpwrvgnd_1
X_11660_ clknet_leaf_140_clk _01491_ VGND VGND VPWR VPWR picorv32_core.cpuregs\[26\]\[9\]
+ sky130_fd_sc_hd__dfxtp_1
XTAP_TAPCELL_ROW_81_1485 VGND VPWR sky130_fd_sc_hd__tapvpwrvgnd_1
XTAP_TAPCELL_ROW_81_1474 VGND VPWR sky130_fd_sc_hd__tapvpwrvgnd_1
X_10611_ clknet_leaf_97_clk _00465_ VGND VGND VPWR VPWR picorv32_core.instr_sra sky130_fd_sc_hd__dfxtp_1
Xclkbuf_leaf_115_clk clknet_4_8_0_clk VGND VGND VPWR VPWR clknet_leaf_115_clk sky130_fd_sc_hd__clkbuf_8
X_11591_ clknet_leaf_121_clk _01422_ VGND VGND VPWR VPWR picorv32_core.cpuregs\[23\]\[4\]
+ sky130_fd_sc_hd__dfxtp_1
XFILLER_41_189 VGND VGND VPWR VPWR sky130_fd_sc_hd__fill_1
X_10542_ clknet_leaf_61_clk picorv32_core.alu_out\[30\] VGND VGND VPWR VPWR picorv32_core.alu_out_q\[30\]
+ sky130_fd_sc_hd__dfxtp_1
XTAP_TAPCELL_ROW_20_593 VGND VPWR sky130_fd_sc_hd__tapvpwrvgnd_1
X_10473_ clknet_leaf_122_clk _00030_ VGND VGND VPWR VPWR picorv32_core.decoder_trigger
+ sky130_fd_sc_hd__dfxtp_1
XFILLER_108_475 VGND VGND VPWR VPWR sky130_fd_sc_hd__fill_1
XFILLER_110_117 VGND VGND VPWR VPWR sky130_fd_sc_hd__fill_2
X_11025_ clknet_leaf_130_clk _00876_ VGND VGND VPWR VPWR picorv32_core.cpuregs\[11\]\[7\]
+ sky130_fd_sc_hd__dfxtp_1
XFILLER_49_245 VGND VGND VPWR VPWR sky130_fd_sc_hd__decap_3
XFILLER_92_524 VGND VGND VPWR VPWR sky130_fd_sc_hd__decap_8
XFILLER_66_50 VGND VGND VPWR VPWR sky130_fd_sc_hd__fill_2
XFILLER_66_94 VGND VGND VPWR VPWR sky130_fd_sc_hd__fill_1
XFILLER_18_643 VGND VGND VPWR VPWR sky130_fd_sc_hd__fill_1
XTAP_TAPCELL_ROW_123_2091 VGND VPWR sky130_fd_sc_hd__tapvpwrvgnd_1
XFILLER_60_421 VGND VGND VPWR VPWR sky130_fd_sc_hd__fill_2
XFILLER_45_484 VPWR VGND VPWR VGND sky130_ef_sc_hd__decap_12
X_11858_ net969 VGND VGND VPWR VPWR net173 sky130_fd_sc_hd__clkbuf_1
XANTENNA_19 _04226_ VGND VGND VPWR VPWR sky130_fd_sc_hd__diode_2
X_10809_ clknet_leaf_20_clk _00660_ VGND VGND VPWR VPWR picorv32_core.cpuregs\[15\]\[18\]
+ sky130_fd_sc_hd__dfxtp_1
XFILLER_20_307 VGND VGND VPWR VPWR sky130_fd_sc_hd__fill_1
Xclkbuf_leaf_106_clk clknet_4_10_0_clk VGND VGND VPWR VPWR clknet_leaf_106_clk sky130_fd_sc_hd__clkbuf_8
XFILLER_119_729 VPWR VGND VPWR VGND sky130_ef_sc_hd__decap_12
XTAP_TAPCELL_ROW_99_1735 VGND VPWR sky130_fd_sc_hd__tapvpwrvgnd_1
XTAP_TAPCELL_ROW_99_1746 VGND VPWR sky130_fd_sc_hd__tapvpwrvgnd_1
X_06000_ _02463_ _02464_ VGND VGND VPWR VPWR _02465_ sky130_fd_sc_hd__nand2_1
XFILLER_63_3 VGND VGND VPWR VPWR sky130_fd_sc_hd__decap_3
Xoutput104 net104 VGND VGND VPWR VPWR mem_axi_wdata[0] sky130_fd_sc_hd__buf_2
Xoutput115 net115 VGND VGND VPWR VPWR mem_axi_wdata[1] sky130_fd_sc_hd__buf_2
Xoutput159 net159 VGND VGND VPWR VPWR pcpi_rs1[26] sky130_fd_sc_hd__buf_2
Xoutput148 net148 VGND VGND VPWR VPWR pcpi_rs1[16] sky130_fd_sc_hd__buf_2
Xoutput126 net126 VGND VGND VPWR VPWR mem_axi_wdata[2] sky130_fd_sc_hd__buf_2
Xoutput137 net137 VGND VGND VPWR VPWR mem_axi_wstrb[1] sky130_fd_sc_hd__buf_2
XFILLER_141_253 VGND VGND VPWR VPWR sky130_fd_sc_hd__decap_4
X_07951_ picorv32_core.cpuregs\[0\]\[24\] picorv32_core.cpuregs\[1\]\[24\] picorv32_core.cpuregs\[2\]\[24\]
+ picorv32_core.cpuregs\[3\]\[24\] net752 net719 VGND VGND VPWR VPWR _04032_ sky130_fd_sc_hd__mux4_1
XFILLER_114_467 VGND VGND VPWR VPWR sky130_fd_sc_hd__decap_8
XTAP_TAPCELL_ROW_110_1902 VGND VPWR sky130_fd_sc_hd__tapvpwrvgnd_1
XFILLER_87_318 VGND VGND VPWR VPWR sky130_fd_sc_hd__fill_1
XFILLER_141_275 VGND VGND VPWR VPWR sky130_fd_sc_hd__decap_4
X_06902_ _03119_ _03120_ VGND VGND VPWR VPWR _03121_ sky130_fd_sc_hd__nand2_1
XFILLER_110_640 VGND VGND VPWR VPWR sky130_fd_sc_hd__decap_4
X_07882_ picorv32_core.cpuregs\[8\]\[20\] picorv32_core.cpuregs\[9\]\[20\] picorv32_core.cpuregs\[10\]\[20\]
+ picorv32_core.cpuregs\[11\]\[20\] net750 net717 VGND VGND VPWR VPWR _03967_ sky130_fd_sc_hd__mux4_1
XTAP_TAPCELL_ROW_52_1064 VGND VPWR sky130_fd_sc_hd__tapvpwrvgnd_1
XTAP_TAPCELL_ROW_52_1053 VGND VPWR sky130_fd_sc_hd__tapvpwrvgnd_1
X_09621_ net285 _04787_ _04800_ _04780_ VGND VGND VPWR VPWR _01338_ sky130_fd_sc_hd__a31o_1
XFILLER_68_587 VGND VGND VPWR VPWR sky130_fd_sc_hd__fill_1
X_06833_ picorv32_core.decoded_imm_j\[12\] _02924_ VGND VGND VPWR VPWR _03057_ sky130_fd_sc_hd__or2_1
XFILLER_83_557 VGND VGND VPWR VPWR sky130_fd_sc_hd__decap_3
X_09552_ net488 _04716_ _04719_ _04734_ VGND VGND VPWR VPWR _04735_ sky130_fd_sc_hd__o31a_1
X_06764_ _02918_ _02983_ VGND VGND VPWR VPWR _02994_ sky130_fd_sc_hd__and2_1
X_08503_ net1589 net237 net408 VGND VGND VPWR VPWR _00633_ sky130_fd_sc_hd__mux2_1
XTAP_TAPCELL_ROW_108_1875 VGND VPWR sky130_fd_sc_hd__tapvpwrvgnd_1
XTAP_TAPCELL_ROW_108_1864 VGND VPWR sky130_fd_sc_hd__tapvpwrvgnd_1
XFILLER_102_37 VGND VGND VPWR VPWR sky130_fd_sc_hd__fill_1
XFILLER_102_15 VPWR VGND VPWR VGND sky130_ef_sc_hd__decap_12
X_05715_ _02197_ _02198_ _02196_ VGND VGND VPWR VPWR _02199_ sky130_fd_sc_hd__a21oi_1
X_06695_ _02766_ picorv32_core.reg_next_pc\[25\] net561 VGND VGND VPWR VPWR _02937_
+ sky130_fd_sc_hd__mux2_2
XFILLER_91_590 VGND VGND VPWR VPWR sky130_fd_sc_hd__decap_3
XFILLER_63_281 VGND VGND VPWR VPWR sky130_fd_sc_hd__decap_4
XFILLER_62_19 VGND VGND VPWR VPWR sky130_fd_sc_hd__fill_1
X_09483_ net648 _04668_ VGND VGND VPWR VPWR _04669_ sky130_fd_sc_hd__or2_1
XFILLER_36_484 VPWR VGND VPWR VGND sky130_ef_sc_hd__decap_12
XTAP_TAPCELL_ROW_47_980 VGND VPWR sky130_fd_sc_hd__tapvpwrvgnd_1
XTAP_TAPCELL_ROW_47_991 VGND VPWR sky130_fd_sc_hd__tapvpwrvgnd_1
X_08434_ picorv32_core.mem_rdata_q\[20\] net614 net528 net442 _04297_ VGND VGND VPWR
+ VPWR _00590_ sky130_fd_sc_hd__a32o_1
X_05646_ net819 net968 VGND VGND VPWR VPWR _02130_ sky130_fd_sc_hd__xnor2_1
X_05577_ _02064_ _02065_ VGND VGND VPWR VPWR _02066_ sky130_fd_sc_hd__nand2b_1
X_08365_ net1160 _04257_ net454 VGND VGND VPWR VPWR _00561_ sky130_fd_sc_hd__mux2_1
X_07316_ net815 picorv32_core.decoded_imm\[3\] VGND VGND VPWR VPWR _03456_ sky130_fd_sc_hd__nand2_1
XFILLER_137_526 VGND VGND VPWR VPWR sky130_fd_sc_hd__fill_2
X_08296_ net1196 net34 net519 VGND VGND VPWR VPWR _00749_ sky130_fd_sc_hd__mux2_1
X_07247_ picorv32_core.instr_sra picorv32_core.instr_srl picorv32_core.instr_srai
+ picorv32_core.instr_srli VGND VGND VPWR VPWR _03387_ sky130_fd_sc_hd__nor4_1
Xclkbuf_4_2_0_clk clknet_0_clk VGND VGND VPWR VPWR clknet_4_2_0_clk sky130_fd_sc_hd__clkbuf_8
X_07178_ _03343_ net985 _03342_ VGND VGND VPWR VPWR _00299_ sky130_fd_sc_hd__and3b_1
X_06129_ _02579_ _02582_ VGND VGND VPWR VPWR _02584_ sky130_fd_sc_hd__or2_1
XFILLER_133_765 VPWR VGND VPWR VGND sky130_ef_sc_hd__decap_12
Xfanout331 _04351_ VGND VGND VPWR VPWR net331 sky130_fd_sc_hd__buf_4
Xfanout320 _05033_ VGND VGND VPWR VPWR net320 sky130_fd_sc_hd__clkbuf_8
Xfanout342 net343 VGND VGND VPWR VPWR net342 sky130_fd_sc_hd__clkbuf_8
Xfanout364 net365 VGND VGND VPWR VPWR net364 sky130_fd_sc_hd__clkbuf_8
Xfanout375 net376 VGND VGND VPWR VPWR net375 sky130_fd_sc_hd__buf_4
Xfanout397 _04330_ VGND VGND VPWR VPWR net397 sky130_fd_sc_hd__buf_4
X_09819_ _03399_ _03401_ _03536_ _01637_ VGND VGND VPWR VPWR _04989_ sky130_fd_sc_hd__a31o_1
XTAP_TAPCELL_ROW_6_399 VGND VPWR sky130_fd_sc_hd__tapvpwrvgnd_1
XTAP_TAPCELL_ROW_6_388 VGND VPWR sky130_fd_sc_hd__tapvpwrvgnd_1
Xfanout386 net387 VGND VGND VPWR VPWR net386 sky130_fd_sc_hd__buf_4
XFILLER_47_727 VGND VGND VPWR VPWR sky130_fd_sc_hd__fill_1
XTAP_TAPCELL_ROW_83_1503 VGND VPWR sky130_fd_sc_hd__tapvpwrvgnd_1
XFILLER_55_771 VGND VGND VPWR VPWR sky130_fd_sc_hd__decap_6
XFILLER_55_760 VGND VGND VPWR VPWR sky130_fd_sc_hd__decap_3
XTAP_TAPCELL_ROW_83_1514 VGND VPWR sky130_fd_sc_hd__tapvpwrvgnd_1
XFILLER_42_421 VGND VGND VPWR VPWR sky130_fd_sc_hd__decap_8
X_11712_ clknet_leaf_69_clk _01543_ VGND VGND VPWR VPWR picorv32_core.cpuregs\[27\]\[29\]
+ sky130_fd_sc_hd__dfxtp_1
X_11643_ clknet_leaf_40_clk _01474_ VGND VGND VPWR VPWR picorv32_core.cpuregs\[28\]\[24\]
+ sky130_fd_sc_hd__dfxtp_1
XTAP_TAPCELL_ROW_25_663 VGND VPWR sky130_fd_sc_hd__tapvpwrvgnd_1
XTAP_TAPCELL_ROW_25_674 VGND VPWR sky130_fd_sc_hd__tapvpwrvgnd_1
X_11574_ clknet_leaf_41_clk _01405_ VGND VGND VPWR VPWR picorv32_core.cpuregs\[2\]\[21\]
+ sky130_fd_sc_hd__dfxtp_1
Xinput28 mem_axi_rdata[31] VGND VGND VPWR VPWR net28 sky130_fd_sc_hd__clkbuf_2
Xinput17 mem_axi_rdata[21] VGND VGND VPWR VPWR net17 sky130_fd_sc_hd__buf_2
XFILLER_109_740 VPWR VGND VPWR VGND sky130_ef_sc_hd__decap_12
X_10525_ clknet_leaf_17_clk picorv32_core.alu_out\[13\] VGND VGND VPWR VPWR picorv32_core.alu_out_q\[13\]
+ sky130_fd_sc_hd__dfxtp_1
X_10456_ clknet_leaf_79_clk _00343_ VGND VGND VPWR VPWR net48 sky130_fd_sc_hd__dfxtp_1
XTAP_TAPCELL_ROW_94_1665 VGND VPWR sky130_fd_sc_hd__tapvpwrvgnd_1
XFILLER_97_605 VGND VGND VPWR VPWR sky130_fd_sc_hd__fill_2
X_10387_ clknet_leaf_100_clk _00306_ VGND VGND VPWR VPWR picorv32_core.count_cycle\[45\]
+ sky130_fd_sc_hd__dfxtp_1
X_11008_ clknet_leaf_31_clk _00859_ VGND VGND VPWR VPWR picorv32_core.cpuregs\[12\]\[22\]
+ sky130_fd_sc_hd__dfxtp_1
XFILLER_77_384 VGND VGND VPWR VPWR sky130_fd_sc_hd__fill_1
XFILLER_65_524 VGND VGND VPWR VPWR sky130_fd_sc_hd__fill_1
XTAP_TAPCELL_ROW_125_2120 VGND VPWR sky130_fd_sc_hd__tapvpwrvgnd_1
X_05500_ _01993_ _01994_ VGND VGND VPWR VPWR _01995_ sky130_fd_sc_hd__nand2_1
X_06480_ net2282 _02804_ net982 VGND VGND VPWR VPWR _02806_ sky130_fd_sc_hd__o21ai_1
XTAP_TAPCELL_ROW_44_950 VGND VPWR sky130_fd_sc_hd__tapvpwrvgnd_1
X_05431_ picorv32_core.reg_pc\[15\] picorv32_core.decoded_imm\[15\] _01927_ _01929_
+ _01930_ VGND VGND VPWR VPWR _01931_ sky130_fd_sc_hd__a221oi_1
XTAP_TAPCELL_ROW_103_1794 VGND VPWR sky130_fd_sc_hd__tapvpwrvgnd_1
X_08150_ picorv32_core.decoder_pseudo_trigger picorv32_core.decoder_trigger VGND VGND
+ VPWR VPWR _04177_ sky130_fd_sc_hd__and2b_1
X_05362_ _01822_ _01865_ _01866_ _01817_ VGND VGND VPWR VPWR _01867_ sky130_fd_sc_hd__a31o_1
X_07101_ _03294_ _03295_ VGND VGND VPWR VPWR _00270_ sky130_fd_sc_hd__nor2_1
XTAP_TAPCELL_ROW_136_2271 VGND VPWR sky130_fd_sc_hd__tapvpwrvgnd_1
XFILLER_119_559 VGND VGND VPWR VPWR sky130_fd_sc_hd__fill_1
X_08081_ net641 _04150_ net622 VGND VGND VPWR VPWR _04155_ sky130_fd_sc_hd__o21a_1
X_05293_ net914 net809 _01799_ net909 VGND VGND VPWR VPWR _01803_ sky130_fd_sc_hd__a22o_1
XTAP_TAPCELL_ROW_136_2282 VGND VPWR sky130_fd_sc_hd__tapvpwrvgnd_1
XFILLER_134_529 VGND VGND VPWR VPWR sky130_fd_sc_hd__decap_3
X_07032_ net666 picorv32_core.reg_next_pc\[27\] _02939_ net489 VGND VGND VPWR VPWR
+ _03241_ sky130_fd_sc_hd__a22o_1
XFILLER_114_253 VGND VGND VPWR VPWR sky130_fd_sc_hd__decap_4
X_08983_ net1886 net211 net351 VGND VGND VPWR VPWR _01155_ sky130_fd_sc_hd__mux2_1
X_07934_ picorv32_core.cpuregs\[4\]\[23\] picorv32_core.cpuregs\[5\]\[23\] picorv32_core.cpuregs\[6\]\[23\]
+ picorv32_core.cpuregs\[7\]\[23\] net757 net724 VGND VGND VPWR VPWR _04016_ sky130_fd_sc_hd__mux4_1
XFILLER_130_757 VPWR VGND VPWR VGND sky130_ef_sc_hd__decap_12
X_07865_ _03945_ _03946_ net634 VGND VGND VPWR VPWR _03951_ sky130_fd_sc_hd__mux2_1
XFILLER_84_800 VGND VGND VPWR VPWR sky130_fd_sc_hd__fill_2
XFILLER_68_351 VGND VGND VPWR VPWR sky130_fd_sc_hd__fill_1
XFILLER_56_502 VGND VGND VPWR VPWR sky130_fd_sc_hd__fill_1
X_09604_ net792 net544 _04783_ net472 VGND VGND VPWR VPWR _04784_ sky130_fd_sc_hd__o211a_1
XTAP_TAPCELL_ROW_3_347 VGND VPWR sky130_fd_sc_hd__tapvpwrvgnd_1
X_07796_ net179 net512 _03885_ VGND VGND VPWR VPWR _00375_ sky130_fd_sc_hd__o21a_1
X_06816_ net680 _03040_ _03041_ VGND VGND VPWR VPWR _03042_ sky130_fd_sc_hd__or3_1
X_09535_ net792 net788 net544 VGND VGND VPWR VPWR _04718_ sky130_fd_sc_hd__mux2_1
X_06747_ picorv32_core.decoded_imm_j\[4\] _02916_ _02956_ _02957_ _02954_ VGND VGND
+ VPWR VPWR _02978_ sky130_fd_sc_hd__a221o_1
X_06678_ picorv32_core.reg_pc\[16\] net554 _02928_ net517 VGND VGND VPWR VPWR _00214_
+ sky130_fd_sc_hd__a22o_1
XTAP_TAPCELL_ROW_65_1244 VGND VPWR sky130_fd_sc_hd__tapvpwrvgnd_1
X_09466_ net283 _04637_ _04652_ _04632_ VGND VGND VPWR VPWR _01331_ sky130_fd_sc_hd__a31o_1
XTAP_TAPCELL_ROW_42_909 VGND VPWR sky130_fd_sc_hd__tapvpwrvgnd_1
X_05629_ picorv32_core.reg_pc\[31\] picorv32_core.decoded_imm\[31\] VGND VGND VPWR
+ VPWR _02114_ sky130_fd_sc_hd__xor2_1
X_08417_ picorv32_core.mem_rdata_q\[28\] net614 VGND VGND VPWR VPWR _04289_ sky130_fd_sc_hd__and2_1
XTAP_TAPCELL_ROW_22_622 VGND VPWR sky130_fd_sc_hd__tapvpwrvgnd_1
X_09397_ net830 _04583_ _04586_ net478 VGND VGND VPWR VPWR _04587_ sky130_fd_sc_hd__o211a_1
XFILLER_138_813 VPWR VGND VPWR VGND sky130_ef_sc_hd__decap_12
X_08348_ _01595_ net177 net451 _04247_ VGND VGND VPWR VPWR _04248_ sky130_fd_sc_hd__a211o_1
X_08279_ net1562 net260 net412 VGND VGND VPWR VPWR _00503_ sky130_fd_sc_hd__mux2_1
XFILLER_138_77 VGND VGND VPWR VPWR sky130_fd_sc_hd__decap_6
X_10310_ clknet_leaf_75_clk _00229_ VGND VGND VPWR VPWR picorv32_core.reg_pc\[31\]
+ sky130_fd_sc_hd__dfxtp_1
XFILLER_98_15 VPWR VGND VPWR VGND sky130_ef_sc_hd__decap_12
X_11290_ clknet_leaf_13_clk _01138_ VGND VGND VPWR VPWR picorv32_core.cpuregs\[3\]\[13\]
+ sky130_fd_sc_hd__dfxtp_1
XFILLER_22_77 VGND VGND VPWR VPWR sky130_fd_sc_hd__decap_6
X_10241_ clknet_leaf_78_clk _00160_ VGND VGND VPWR VPWR picorv32_core.count_instr\[25\]
+ sky130_fd_sc_hd__dfxtp_1
X_10172_ clknet_leaf_41_clk _00091_ VGND VGND VPWR VPWR picorv32_core.cpuregs\[21\]\[20\]
+ sky130_fd_sc_hd__dfxtp_1
XFILLER_87_693 VGND VGND VPWR VPWR sky130_fd_sc_hd__decap_6
XFILLER_74_332 VGND VGND VPWR VPWR sky130_fd_sc_hd__decap_6
XFILLER_90_836 VGND VGND VPWR VPWR sky130_fd_sc_hd__fill_1
XFILLER_28_793 VPWR VGND VPWR VGND sky130_ef_sc_hd__decap_12
XFILLER_27_281 VGND VGND VPWR VPWR sky130_fd_sc_hd__decap_4
XTAP_TAPCELL_ROW_120_2050 VGND VPWR sky130_fd_sc_hd__tapvpwrvgnd_1
XFILLER_43_785 VGND VGND VPWR VPWR sky130_fd_sc_hd__decap_8
X_11626_ clknet_leaf_131_clk _01457_ VGND VGND VPWR VPWR picorv32_core.cpuregs\[28\]\[7\]
+ sky130_fd_sc_hd__dfxtp_1
X_11557_ clknet_leaf_111_clk _01388_ VGND VGND VPWR VPWR picorv32_core.cpuregs\[2\]\[4\]
+ sky130_fd_sc_hd__dfxtp_1
XFILLER_6_141 VPWR VGND VPWR VGND sky130_ef_sc_hd__decap_12
X_10508_ clknet_leaf_106_clk _00394_ VGND VGND VPWR VPWR picorv32_core.latched_branch
+ sky130_fd_sc_hd__dfxtp_1
Xhold609 picorv32_core.cpuregs\[10\]\[8\] VGND VGND VPWR VPWR net1718 sky130_fd_sc_hd__dlygate4sd3_1
X_11488_ clknet_leaf_119_clk _01324_ VGND VGND VPWR VPWR net168 sky130_fd_sc_hd__dfxtp_1
X_10439_ clknet_leaf_115_clk _00326_ VGND VGND VPWR VPWR net59 sky130_fd_sc_hd__dfxtp_1
XFILLER_97_435 VGND VGND VPWR VPWR sky130_fd_sc_hd__decap_4
XFILLER_112_757 VPWR VGND VPWR VGND sky130_ef_sc_hd__decap_12
XFILLER_112_746 VGND VGND VPWR VPWR sky130_fd_sc_hd__decap_8
X_05980_ net787 net181 net569 _02446_ VGND VGND VPWR VPWR _02447_ sky130_fd_sc_hd__a31o_1
XFILLER_26_3 VPWR VGND VPWR VGND sky130_ef_sc_hd__decap_12
XFILLER_93_652 VGND VGND VPWR VPWR sky130_fd_sc_hd__decap_4
XFILLER_65_365 VGND VGND VPWR VPWR sky130_fd_sc_hd__decap_4
XFILLER_53_505 VPWR VGND VPWR VGND sky130_ef_sc_hd__decap_12
XTAP_TAPCELL_ROW_0_306 VGND VPWR sky130_fd_sc_hd__tapvpwrvgnd_1
X_07650_ _03745_ _03747_ net457 _03744_ VGND VGND VPWR VPWR _03748_ sky130_fd_sc_hd__o211a_1
XFILLER_38_557 VGND VGND VPWR VPWR sky130_fd_sc_hd__decap_3
XTAP_TAPCELL_ROW_105_1823 VGND VPWR sky130_fd_sc_hd__tapvpwrvgnd_1
X_06601_ _02881_ _02882_ VGND VGND VPWR VPWR _00183_ sky130_fd_sc_hd__nor2_1
X_07581_ picorv32_core.cpuregs\[24\]\[1\] picorv32_core.cpuregs\[25\]\[1\] picorv32_core.cpuregs\[26\]\[1\]
+ picorv32_core.cpuregs\[27\]\[1\] net745 net712 VGND VGND VPWR VPWR _03685_ sky130_fd_sc_hd__mux4_1
XTAP_TAPCELL_ROW_105_1834 VGND VPWR sky130_fd_sc_hd__tapvpwrvgnd_1
X_06532_ picorv32_core.count_instr\[23\] picorv32_core.count_instr\[22\] picorv32_core.count_instr\[21\]
+ _02833_ VGND VGND VPWR VPWR _02839_ sky130_fd_sc_hd__and4_1
X_09320_ picorv32_core.cpuregs\[4\]\[6\] picorv32_core.cpuregs\[5\]\[6\] picorv32_core.cpuregs\[6\]\[6\]
+ picorv32_core.cpuregs\[7\]\[6\] net874 net841 VGND VGND VPWR VPWR _04513_ sky130_fd_sc_hd__mux4_1
X_09251_ _03457_ _03464_ _03466_ VGND VGND VPWR VPWR _04447_ sky130_fd_sc_hd__nand3_1
XFILLER_34_774 VPWR VGND VPWR VGND sky130_ef_sc_hd__decap_12
XTAP_TAPCELL_ROW_138_2311 VGND VPWR sky130_fd_sc_hd__tapvpwrvgnd_1
XTAP_TAPCELL_ROW_138_2300 VGND VPWR sky130_fd_sc_hd__tapvpwrvgnd_1
X_06463_ net225 net2003 net420 VGND VGND VPWR VPWR _00129_ sky130_fd_sc_hd__mux2_1
X_08202_ _01580_ net924 net982 VGND VGND VPWR VPWR _04206_ sky130_fd_sc_hd__and3_1
XFILLER_138_109 VPWR VGND VPWR VGND sky130_ef_sc_hd__decap_12
X_06394_ net564 _02787_ VGND VGND VPWR VPWR _02790_ sky130_fd_sc_hd__and2b_1
X_05414_ picorv32_core.reg_pc\[15\] picorv32_core.decoded_imm\[15\] VGND VGND VPWR
+ VPWR _01915_ sky130_fd_sc_hd__nand2_1
X_09182_ picorv32_core.cpuregs\[20\]\[1\] picorv32_core.cpuregs\[21\]\[1\] net888
+ VGND VGND VPWR VPWR _04380_ sky130_fd_sc_hd__mux2_1
Xpicorv32_axi_1019 VGND VGND VPWR VPWR picorv32_axi_1019/HI eoi[20] sky130_fd_sc_hd__conb_1
X_08133_ net219 net1686 net417 VGND VGND VPWR VPWR _00426_ sky130_fd_sc_hd__mux2_1
X_05345_ picorv32_core.count_instr\[42\] net936 net940 picorv32_core.count_instr\[10\]
+ VGND VGND VPWR VPWR _01851_ sky130_fd_sc_hd__a22o_1
XTAP_TAPCELL_ROW_60_1174 VGND VPWR sky130_fd_sc_hd__tapvpwrvgnd_1
Xpicorv32_axi_1008 VGND VGND VPWR VPWR picorv32_axi_1008/HI eoi[9] sky130_fd_sc_hd__conb_1
X_08064_ _04129_ _04137_ _04138_ net622 net690 VGND VGND VPWR VPWR _04139_ sky130_fd_sc_hd__a221o_1
XFILLER_119_367 VGND VGND VPWR VPWR sky130_fd_sc_hd__fill_1
XFILLER_107_529 VGND VGND VPWR VPWR sky130_fd_sc_hd__decap_8
XFILLER_119_389 VGND VGND VPWR VPWR sky130_fd_sc_hd__decap_3
X_07015_ _03212_ _03215_ _03223_ net664 VGND VGND VPWR VPWR _03225_ sky130_fd_sc_hd__a31o_1
X_05276_ picorv32_core.count_instr\[5\] net939 net602 _01786_ VGND VGND VPWR VPWR
+ _01787_ sky130_fd_sc_hd__a211o_1
XTAP_TAPCELL_ROW_116_1985 VGND VPWR sky130_fd_sc_hd__tapvpwrvgnd_1
XTAP_TAPCELL_ROW_8_428 VGND VPWR sky130_fd_sc_hd__tapvpwrvgnd_1
XTAP_TAPCELL_ROW_8_417 VGND VPWR sky130_fd_sc_hd__tapvpwrvgnd_1
XFILLER_130_510 VGND VGND VPWR VPWR sky130_fd_sc_hd__fill_1
XFILLER_1_829 VGND VGND VPWR VPWR sky130_fd_sc_hd__fill_2
X_08966_ net1712 net276 net348 VGND VGND VPWR VPWR _01138_ sky130_fd_sc_hd__mux2_1
X_07917_ picorv32_core.cpuregs\[0\]\[22\] picorv32_core.cpuregs\[1\]\[22\] picorv32_core.cpuregs\[2\]\[22\]
+ picorv32_core.cpuregs\[3\]\[22\] net748 net715 VGND VGND VPWR VPWR _04000_ sky130_fd_sc_hd__mux4_1
X_08897_ net294 net1438 net358 VGND VGND VPWR VPWR _01071_ sky130_fd_sc_hd__mux2_1
Xclkbuf_leaf_95_clk clknet_4_10_0_clk VGND VGND VPWR VPWR clknet_leaf_95_clk sky130_fd_sc_hd__clkbuf_8
X_07848_ net696 _03931_ _03930_ net620 VGND VGND VPWR VPWR _03935_ sky130_fd_sc_hd__o211a_1
XFILLER_56_365 VGND VGND VPWR VPWR sky130_fd_sc_hd__decap_4
XFILLER_17_708 VPWR VGND VPWR VGND sky130_ef_sc_hd__decap_12
XFILLER_56_398 VPWR VGND VPWR VGND sky130_ef_sc_hd__decap_12
XTAP_TAPCELL_ROW_27_703 VGND VPWR sky130_fd_sc_hd__tapvpwrvgnd_1
XFILLER_71_335 VGND VGND VPWR VPWR sky130_fd_sc_hd__fill_1
X_07779_ _03868_ _03869_ net457 _03866_ VGND VGND VPWR VPWR _03870_ sky130_fd_sc_hd__o211a_1
X_09518_ picorv32_core.cpuregs\[12\]\[15\] picorv32_core.cpuregs\[13\]\[15\] picorv32_core.cpuregs\[14\]\[15\]
+ picorv32_core.cpuregs\[15\]\[15\] net882 net849 VGND VGND VPWR VPWR _04702_ sky130_fd_sc_hd__mux4_1
XFILLER_17_99 VGND VGND VPWR VPWR sky130_fd_sc_hd__decap_3
XFILLER_25_741 VPWR VGND VPWR VGND sky130_ef_sc_hd__decap_12
X_10790_ clknet_leaf_62_clk _00641_ VGND VGND VPWR VPWR picorv32_core.cpuregs\[14\]\[31\]
+ sky130_fd_sc_hd__dfxtp_1
XFILLER_24_251 VGND VGND VPWR VPWR sky130_fd_sc_hd__fill_1
XFILLER_25_785 VPWR VGND VPWR VGND sky130_ef_sc_hd__decap_12
X_09449_ net800 net546 _04571_ net471 VGND VGND VPWR VPWR _04636_ sky130_fd_sc_hd__o211a_1
XFILLER_130_3 VPWR VGND VPWR VGND sky130_ef_sc_hd__decap_12
XFILLER_138_654 VGND VGND VPWR VPWR sky130_fd_sc_hd__decap_4
XFILLER_138_643 VGND VGND VPWR VPWR sky130_fd_sc_hd__fill_1
X_11411_ clknet_leaf_46_clk _01247_ VGND VGND VPWR VPWR picorv32_core.cpuregs\[31\]\[26\]
+ sky130_fd_sc_hd__dfxtp_1
XFILLER_126_805 VGND VGND VPWR VPWR sky130_fd_sc_hd__decap_6
X_11342_ clknet_leaf_46_clk _01183_ VGND VGND VPWR VPWR picorv32_core.cpuregs\[29\]\[26\]
+ sky130_fd_sc_hd__dfxtp_1
XTAP_TAPCELL_ROW_78_1435 VGND VPWR sky130_fd_sc_hd__tapvpwrvgnd_1
XFILLER_3_111 VGND VGND VPWR VPWR sky130_fd_sc_hd__fill_1
X_11273_ clknet_leaf_37_clk _01121_ VGND VGND VPWR VPWR picorv32_core.cpuregs\[4\]\[28\]
+ sky130_fd_sc_hd__dfxtp_1
XFILLER_4_645 VGND VGND VPWR VPWR sky130_fd_sc_hd__decap_3
XTAP_TAPCELL_ROW_91_1624 VGND VPWR sky130_fd_sc_hd__tapvpwrvgnd_1
X_10224_ clknet_leaf_101_clk _00143_ VGND VGND VPWR VPWR picorv32_core.count_instr\[8\]
+ sky130_fd_sc_hd__dfxtp_1
XFILLER_4_689 VGND VGND VPWR VPWR sky130_fd_sc_hd__decap_8
XFILLER_106_595 VGND VGND VPWR VPWR sky130_fd_sc_hd__decap_8
X_10155_ clknet_leaf_118_clk _00074_ VGND VGND VPWR VPWR picorv32_core.cpuregs\[21\]\[3\]
+ sky130_fd_sc_hd__dfxtp_1
XFILLER_94_416 VGND VGND VPWR VPWR sky130_fd_sc_hd__decap_4
Xclkbuf_leaf_86_clk clknet_4_14_0_clk VGND VGND VPWR VPWR clknet_leaf_86_clk sky130_fd_sc_hd__clkbuf_8
XFILLER_75_630 VGND VGND VPWR VPWR sky130_fd_sc_hd__fill_2
X_10086_ net1119 VGND VGND VPWR VPWR _00936_ sky130_fd_sc_hd__clkbuf_1
Xhold6 picorv32_core.cpu_state\[0\] VGND VGND VPWR VPWR net1115 sky130_fd_sc_hd__dlygate4sd3_1
XFILLER_35_505 VPWR VGND VPWR VGND sky130_ef_sc_hd__decap_12
XTAP_TAPCELL_ROW_89_1597 VGND VPWR sky130_fd_sc_hd__tapvpwrvgnd_1
XFILLER_35_538 VGND VGND VPWR VPWR sky130_fd_sc_hd__fill_1
XFILLER_90_655 VGND VGND VPWR VPWR sky130_fd_sc_hd__fill_1
X_10988_ clknet_leaf_134_clk _00839_ VGND VGND VPWR VPWR picorv32_core.cpuregs\[12\]\[2\]
+ sky130_fd_sc_hd__dfxtp_1
XTAP_TAPCELL_ROW_100_1753 VGND VPWR sky130_fd_sc_hd__tapvpwrvgnd_1
XFILLER_31_777 VGND VGND VPWR VPWR sky130_fd_sc_hd__decap_6
X_11609_ clknet_leaf_34_clk _01440_ VGND VGND VPWR VPWR picorv32_core.cpuregs\[23\]\[22\]
+ sky130_fd_sc_hd__dfxtp_1
X_05130_ picorv32_core.instr_bgeu picorv32_core.instr_bge _01649_ _01660_ VGND VGND
+ VPWR VPWR _01661_ sky130_fd_sc_hd__or4_1
Xclkbuf_leaf_10_clk clknet_4_1_0_clk VGND VGND VPWR VPWR clknet_leaf_10_clk sky130_fd_sc_hd__clkbuf_8
XTAP_TAPCELL_ROW_13_496 VGND VPWR sky130_fd_sc_hd__tapvpwrvgnd_1
XTAP_TAPCELL_ROW_133_2230 VGND VPWR sky130_fd_sc_hd__tapvpwrvgnd_1
XFILLER_128_197 VGND VGND VPWR VPWR sky130_fd_sc_hd__decap_6
Xhold406 picorv32_core.cpuregs\[3\]\[4\] VGND VGND VPWR VPWR net1515 sky130_fd_sc_hd__dlygate4sd3_1
Xhold417 picorv32_core.cpuregs\[7\]\[9\] VGND VGND VPWR VPWR net1526 sky130_fd_sc_hd__dlygate4sd3_1
Xhold428 picorv32_core.cpuregs\[25\]\[25\] VGND VGND VPWR VPWR net1537 sky130_fd_sc_hd__dlygate4sd3_1
Xhold439 picorv32_core.cpuregs\[5\]\[16\] VGND VGND VPWR VPWR net1548 sky130_fd_sc_hd__dlygate4sd3_1
X_05061_ net824 VGND VGND VPWR VPWR _01596_ sky130_fd_sc_hd__inv_2
X_08820_ _04325_ _04340_ VGND VGND VPWR VPWR _04341_ sky130_fd_sc_hd__nor2_1
Xfanout919 picorv32_core.cpu_state\[4\] VGND VGND VPWR VPWR net919 sky130_fd_sc_hd__buf_2
Xfanout908 picorv32_core.cpu_state\[6\] VGND VGND VPWR VPWR net908 sky130_fd_sc_hd__buf_4
Xhold1106 picorv32_core.cpuregs\[10\]\[23\] VGND VGND VPWR VPWR net2215 sky130_fd_sc_hd__dlygate4sd3_1
XFILLER_97_276 VGND VGND VPWR VPWR sky130_fd_sc_hd__decap_4
XFILLER_58_619 VGND VGND VPWR VPWR sky130_fd_sc_hd__decap_8
X_08751_ net1503 net211 net380 VGND VGND VPWR VPWR _00899_ sky130_fd_sc_hd__mux2_1
Xhold1128 picorv32_core.cpuregs\[25\]\[24\] VGND VGND VPWR VPWR net2237 sky130_fd_sc_hd__dlygate4sd3_1
Xhold1117 picorv32_core.cpuregs\[29\]\[22\] VGND VGND VPWR VPWR net2226 sky130_fd_sc_hd__dlygate4sd3_1
Xclkbuf_leaf_77_clk clknet_4_14_0_clk VGND VGND VPWR VPWR clknet_leaf_77_clk sky130_fd_sc_hd__clkbuf_8
Xhold1139 picorv32_core.count_cycle\[51\] VGND VGND VPWR VPWR net2248 sky130_fd_sc_hd__dlygate4sd3_1
XFILLER_85_449 VGND VGND VPWR VPWR sky130_fd_sc_hd__decap_4
X_05963_ net956 _02430_ VGND VGND VPWR VPWR _02431_ sky130_fd_sc_hd__xor2_1
X_08682_ net223 net2107 net389 VGND VGND VPWR VPWR _00832_ sky130_fd_sc_hd__mux2_1
X_05894_ net799 _02366_ VGND VGND VPWR VPWR _02367_ sky130_fd_sc_hd__nand2_1
X_07702_ _03791_ _03792_ net627 VGND VGND VPWR VPWR _03797_ sky130_fd_sc_hd__mux2_1
XFILLER_93_482 VGND VGND VPWR VPWR sky130_fd_sc_hd__decap_4
XTAP_TAPCELL_ROW_49_1014 VGND VPWR sky130_fd_sc_hd__tapvpwrvgnd_1
X_07633_ net963 net510 _03730_ _03731_ VGND VGND VPWR VPWR _00366_ sky130_fd_sc_hd__o22a_1
XFILLER_110_15 VPWR VGND VPWR VGND sky130_ef_sc_hd__decap_12
XFILLER_81_699 VGND VGND VPWR VPWR sky130_fd_sc_hd__fill_2
XTAP_TAPCELL_ROW_62_1203 VGND VPWR sky130_fd_sc_hd__tapvpwrvgnd_1
X_07564_ net691 _03664_ net619 VGND VGND VPWR VPWR _03669_ sky130_fd_sc_hd__a21oi_1
X_07495_ net786 _03617_ net533 VGND VGND VPWR VPWR _03618_ sky130_fd_sc_hd__mux2_1
X_06515_ picorv32_core.count_instr\[15\] picorv32_core.count_instr\[14\] _02820_ _02827_
+ VGND VGND VPWR VPWR _02828_ sky130_fd_sc_hd__and4_1
X_09303_ _04488_ _04489_ net653 VGND VGND VPWR VPWR _04497_ sky130_fd_sc_hd__mux2_1
X_09234_ picorv32_core.cpuregs\[8\]\[3\] picorv32_core.cpuregs\[9\]\[3\] picorv32_core.cpuregs\[10\]\[3\]
+ picorv32_core.cpuregs\[11\]\[3\] net884 net851 VGND VGND VPWR VPWR _04430_ sky130_fd_sc_hd__mux4_1
XPHY_EDGE_ROW_3_Right_3 VGND VGND VPWR VPWR sky130_fd_sc_hd__decap_3
X_06446_ net300 net1885 net418 VGND VGND VPWR VPWR _00112_ sky130_fd_sc_hd__mux2_1
X_09165_ picorv32_core.cpuregs\[16\]\[0\] picorv32_core.cpuregs\[17\]\[0\] picorv32_core.cpuregs\[18\]\[0\]
+ picorv32_core.cpuregs\[19\]\[0\] net884 net851 VGND VGND VPWR VPWR _04364_ sky130_fd_sc_hd__mux4_1
XTAP_TAPCELL_ROW_32_772 VGND VPWR sky130_fd_sc_hd__tapvpwrvgnd_1
X_06377_ picorv32_core.reg_pc\[27\] picorv32_core.reg_pc\[26\] _02768_ VGND VGND VPWR
+ VPWR _02776_ sky130_fd_sc_hd__and3_1
X_08116_ net293 net1379 net414 VGND VGND VPWR VPWR _00409_ sky130_fd_sc_hd__mux2_1
XFILLER_119_186 VGND VGND VPWR VPWR sky130_fd_sc_hd__fill_1
XFILLER_119_57 VGND VGND VPWR VPWR sky130_fd_sc_hd__fill_2
X_05328_ picorv32_core.reg_pc\[9\] picorv32_core.decoded_imm\[9\] VGND VGND VPWR VPWR
+ _01835_ sky130_fd_sc_hd__and2_1
X_09096_ net294 net1976 net332 VGND VGND VPWR VPWR _01263_ sky130_fd_sc_hd__mux2_1
Xhold940 picorv32_core.cpuregs\[4\]\[31\] VGND VGND VPWR VPWR net2049 sky130_fd_sc_hd__dlygate4sd3_1
X_08047_ net697 _04118_ _04117_ net622 VGND VGND VPWR VPWR _04123_ sky130_fd_sc_hd__o211a_1
X_05259_ net820 net7 _01718_ _01770_ VGND VGND VPWR VPWR _01771_ sky130_fd_sc_hd__o211a_1
Xhold951 picorv32_core.cpuregs\[8\]\[23\] VGND VGND VPWR VPWR net2060 sky130_fd_sc_hd__dlygate4sd3_1
Xhold973 picorv32_core.cpuregs\[30\]\[28\] VGND VGND VPWR VPWR net2082 sky130_fd_sc_hd__dlygate4sd3_1
Xhold962 picorv32_core.cpuregs\[2\]\[0\] VGND VGND VPWR VPWR net2071 sky130_fd_sc_hd__dlygate4sd3_1
XFILLER_103_543 VGND VGND VPWR VPWR sky130_fd_sc_hd__fill_1
XTAP_TAPCELL_ROW_73_1365 VGND VPWR sky130_fd_sc_hd__tapvpwrvgnd_1
XFILLER_0_125 VPWR VGND VPWR VGND sky130_ef_sc_hd__decap_12
Xhold984 picorv32_core.cpuregs\[25\]\[5\] VGND VGND VPWR VPWR net2093 sky130_fd_sc_hd__dlygate4sd3_1
Xhold995 picorv32_core.cpuregs\[9\]\[7\] VGND VGND VPWR VPWR net2104 sky130_fd_sc_hd__dlygate4sd3_1
X_09998_ net1231 net230 net315 VGND VGND VPWR VPWR _01475_ sky130_fd_sc_hd__mux2_1
XFILLER_88_276 VGND VGND VPWR VPWR sky130_fd_sc_hd__fill_1
XFILLER_76_416 VGND VGND VPWR VPWR sky130_fd_sc_hd__decap_4
XFILLER_0_169 VPWR VGND VPWR VGND sky130_ef_sc_hd__decap_12
X_08949_ net215 net1751 net356 VGND VGND VPWR VPWR _01122_ sky130_fd_sc_hd__mux2_1
XFILLER_103_598 VGND VGND VPWR VPWR sky130_fd_sc_hd__fill_1
Xclkbuf_leaf_68_clk clknet_4_13_0_clk VGND VGND VPWR VPWR clknet_leaf_68_clk sky130_fd_sc_hd__clkbuf_8
X_10911_ clknet_leaf_106_clk _00762_ VGND VGND VPWR VPWR picorv32_core.mem_rdata_q\[21\]
+ sky130_fd_sc_hd__dfxtp_2
XFILLER_45_836 VGND VGND VPWR VPWR sky130_fd_sc_hd__fill_1
XFILLER_56_195 VGND VGND VPWR VPWR sky130_fd_sc_hd__fill_1
XFILLER_44_346 VPWR VGND VPWR VGND sky130_ef_sc_hd__decap_12
X_10842_ clknet_leaf_30_clk _00693_ VGND VGND VPWR VPWR picorv32_core.cpuregs\[17\]\[19\]
+ sky130_fd_sc_hd__dfxtp_1
XFILLER_32_519 VGND VGND VPWR VPWR sky130_fd_sc_hd__fill_1
X_10773_ clknet_leaf_7_clk _00624_ VGND VGND VPWR VPWR picorv32_core.cpuregs\[14\]\[14\]
+ sky130_fd_sc_hd__dfxtp_1
XFILLER_44_64 VGND VGND VPWR VPWR sky130_fd_sc_hd__fill_1
XFILLER_52_390 VGND VGND VPWR VPWR sky130_fd_sc_hd__decap_3
XFILLER_13_777 VGND VGND VPWR VPWR sky130_fd_sc_hd__decap_6
XFILLER_40_552 VGND VGND VPWR VPWR sky130_fd_sc_hd__decap_4
XFILLER_12_287 VGND VGND VPWR VPWR sky130_fd_sc_hd__decap_4
XFILLER_40_574 VGND VGND VPWR VPWR sky130_fd_sc_hd__decap_8
XFILLER_126_602 VGND VGND VPWR VPWR sky130_fd_sc_hd__fill_1
XFILLER_60_85 VGND VGND VPWR VPWR sky130_fd_sc_hd__fill_2
XTAP_TAPCELL_ROW_10_455 VGND VPWR sky130_fd_sc_hd__tapvpwrvgnd_1
XTAP_TAPCELL_ROW_10_444 VGND VPWR sky130_fd_sc_hd__tapvpwrvgnd_1
X_11325_ clknet_leaf_140_clk _01166_ VGND VGND VPWR VPWR picorv32_core.cpuregs\[29\]\[9\]
+ sky130_fd_sc_hd__dfxtp_1
XFILLER_125_167 VGND VGND VPWR VPWR sky130_fd_sc_hd__fill_1
X_11256_ clknet_leaf_8_clk _01104_ VGND VGND VPWR VPWR picorv32_core.cpuregs\[4\]\[11\]
+ sky130_fd_sc_hd__dfxtp_1
XFILLER_5_69 VPWR VGND VPWR VGND sky130_ef_sc_hd__decap_12
XFILLER_106_392 VPWR VGND VPWR VGND sky130_ef_sc_hd__decap_12
XFILLER_69_61 VGND VGND VPWR VPWR sky130_fd_sc_hd__fill_1
X_10207_ clknet_leaf_41_clk _00126_ VGND VGND VPWR VPWR picorv32_core.cpuregs\[9\]\[23\]
+ sky130_fd_sc_hd__dfxtp_1
X_11187_ clknet_leaf_144_clk _01038_ VGND VGND VPWR VPWR picorv32_core.cpuregs\[6\]\[9\]
+ sky130_fd_sc_hd__dfxtp_1
X_10138_ clknet_leaf_49_clk _00060_ VGND VGND VPWR VPWR picorv32_core.cpuregs\[22\]\[21\]
+ sky130_fd_sc_hd__dfxtp_1
XFILLER_0_692 VGND VGND VPWR VPWR sky130_fd_sc_hd__decap_4
X_10069_ net1912 net211 net307 VGND VGND VPWR VPWR _01544_ sky130_fd_sc_hd__mux2_1
Xclkbuf_leaf_59_clk clknet_4_12_0_clk VGND VGND VPWR VPWR clknet_leaf_59_clk sky130_fd_sc_hd__clkbuf_8
XFILLER_94_257 VGND VGND VPWR VPWR sky130_fd_sc_hd__fill_1
XFILLER_10_6 VPWR VGND VPWR VGND sky130_ef_sc_hd__decap_12
XFILLER_82_419 VGND VGND VPWR VPWR sky130_fd_sc_hd__fill_1
XFILLER_75_482 VGND VGND VPWR VPWR sky130_fd_sc_hd__decap_4
XFILLER_36_825 VGND VGND VPWR VPWR sky130_fd_sc_hd__fill_2
XFILLER_50_305 VGND VGND VPWR VPWR sky130_fd_sc_hd__decap_3
XTAP_TAPCELL_ROW_18_566 VGND VPWR sky130_fd_sc_hd__tapvpwrvgnd_1
XFILLER_16_593 VGND VGND VPWR VPWR sky130_fd_sc_hd__fill_1
X_07280_ net787 picorv32_core.decoded_imm\[17\] VGND VGND VPWR VPWR _03420_ sky130_fd_sc_hd__nor2_1
X_06300_ picorv32_core.reg_pc\[12\] _02709_ VGND VGND VPWR VPWR _02714_ sky130_fd_sc_hd__xor2_1
X_06231_ picorv32_core.is_slli_srli_srai _02660_ VGND VGND VPWR VPWR _02661_ sky130_fd_sc_hd__or2_1
XFILLER_8_781 VPWR VGND VPWR VGND sky130_ef_sc_hd__decap_12
X_06162_ picorv32_core.decoded_imm_j\[1\] _00762_ net437 VGND VGND VPWR VPWR _00021_
+ sky130_fd_sc_hd__mux2_1
Xhold225 picorv32_core.cpuregs\[30\]\[31\] VGND VGND VPWR VPWR net1334 sky130_fd_sc_hd__dlygate4sd3_1
X_06093_ net670 net191 _02541_ VGND VGND VPWR VPWR _02550_ sky130_fd_sc_hd__a21o_1
Xhold214 picorv32_core.cpuregs\[15\]\[13\] VGND VGND VPWR VPWR net1323 sky130_fd_sc_hd__dlygate4sd3_1
Xhold203 picorv32_core.cpuregs\[11\]\[8\] VGND VGND VPWR VPWR net1312 sky130_fd_sc_hd__dlygate4sd3_1
X_05113_ _01643_ _01644_ VGND VGND VPWR VPWR _01645_ sky130_fd_sc_hd__nand2_1
Xhold247 picorv32_core.cpuregs\[23\]\[25\] VGND VGND VPWR VPWR net1356 sky130_fd_sc_hd__dlygate4sd3_1
Xhold269 picorv32_core.cpuregs\[19\]\[30\] VGND VGND VPWR VPWR net1378 sky130_fd_sc_hd__dlygate4sd3_1
X_09921_ net245 net2179 net322 VGND VGND VPWR VPWR _01405_ sky130_fd_sc_hd__mux2_1
Xhold258 picorv32_core.cpuregs\[26\]\[22\] VGND VGND VPWR VPWR net1367 sky130_fd_sc_hd__dlygate4sd3_1
Xhold236 picorv32_core.cpuregs\[5\]\[9\] VGND VGND VPWR VPWR net1345 sky130_fd_sc_hd__dlygate4sd3_1
X_05044_ picorv32_core.instr_sub VGND VGND VPWR VPWR _01579_ sky130_fd_sc_hd__inv_2
XTAP_TAPCELL_ROW_113_1944 VGND VPWR sky130_fd_sc_hd__tapvpwrvgnd_1
Xfanout705 net708 VGND VGND VPWR VPWR net705 sky130_fd_sc_hd__clkbuf_4
X_09852_ picorv32_core.cpuregs\[8\]\[30\] picorv32_core.cpuregs\[9\]\[30\] picorv32_core.cpuregs\[10\]\[30\]
+ picorv32_core.cpuregs\[11\]\[30\] net901 net867 VGND VGND VPWR VPWR _05021_ sky130_fd_sc_hd__mux4_1
Xfanout727 net730 VGND VGND VPWR VPWR net727 sky130_fd_sc_hd__clkbuf_4
XFILLER_105_15 VGND VGND VPWR VPWR sky130_fd_sc_hd__decap_8
Xfanout749 net758 VGND VGND VPWR VPWR net749 sky130_fd_sc_hd__buf_2
Xfanout716 net725 VGND VGND VPWR VPWR net716 sky130_fd_sc_hd__clkbuf_2
Xfanout738 net741 VGND VGND VPWR VPWR net738 sky130_fd_sc_hd__buf_4
X_09783_ picorv32_core.cpuregs\[24\]\[27\] picorv32_core.cpuregs\[25\]\[27\] picorv32_core.cpuregs\[26\]\[27\]
+ picorv32_core.cpuregs\[27\]\[27\] net897 net863 VGND VGND VPWR VPWR _04955_ sky130_fd_sc_hd__mux4_1
XFILLER_112_395 VGND VGND VPWR VPWR sky130_fd_sc_hd__fill_1
X_08803_ net265 net1790 net372 VGND VGND VPWR VPWR _00981_ sky130_fd_sc_hd__mux2_1
X_06995_ net666 picorv32_core.reg_next_pc\[24\] _02936_ net489 VGND VGND VPWR VPWR
+ _03207_ sky130_fd_sc_hd__a22o_1
XFILLER_86_769 VGND VGND VPWR VPWR sky130_fd_sc_hd__decap_3
X_08734_ net1233 net278 net378 VGND VGND VPWR VPWR _00882_ sky130_fd_sc_hd__mux2_1
XFILLER_73_419 VGND VGND VPWR VPWR sky130_fd_sc_hd__fill_1
X_05946_ _02404_ _02405_ _02402_ VGND VGND VPWR VPWR _02415_ sky130_fd_sc_hd__o21a_1
XFILLER_93_290 VGND VGND VPWR VPWR sky130_fd_sc_hd__decap_4
X_05877_ net509 _02347_ _02348_ _02351_ VGND VGND VPWR VPWR picorv32_core.alu_out\[9\]
+ sky130_fd_sc_hd__a31o_1
X_08665_ net296 net1873 net386 VGND VGND VPWR VPWR _00815_ sky130_fd_sc_hd__mux2_1
XTAP_TAPCELL_ROW_37_842 VGND VPWR sky130_fd_sc_hd__tapvpwrvgnd_1
X_08596_ net286 net1749 net394 VGND VGND VPWR VPWR _00719_ sky130_fd_sc_hd__mux2_1
X_07616_ picorv32_core.cpuregs\[16\]\[6\] picorv32_core.cpuregs\[17\]\[6\] picorv32_core.cpuregs\[18\]\[6\]
+ picorv32_core.cpuregs\[19\]\[6\] net732 net699 VGND VGND VPWR VPWR _03715_ sky130_fd_sc_hd__mux4_1
X_07547_ net2329 _01699_ _01639_ VGND VGND VPWR VPWR _00358_ sky130_fd_sc_hd__a21o_1
X_07478_ net1866 _03606_ net464 VGND VGND VPWR VPWR _00336_ sky130_fd_sc_hd__mux2_1
XFILLER_10_714 VPWR VGND VPWR VGND sky130_ef_sc_hd__decap_12
X_06429_ net226 net2180 net424 VGND VGND VPWR VPWR _00097_ sky130_fd_sc_hd__mux2_1
XFILLER_10_769 VPWR VGND VPWR VGND sky130_ef_sc_hd__decap_12
X_09217_ net653 _04411_ net648 VGND VGND VPWR VPWR _04414_ sky130_fd_sc_hd__a21oi_1
X_09148_ net1434 net214 net331 VGND VGND VPWR VPWR _01314_ sky130_fd_sc_hd__mux2_1
XFILLER_5_217 VGND VGND VPWR VPWR sky130_fd_sc_hd__decap_6
X_09079_ net1628 net225 net339 VGND VGND VPWR VPWR _01247_ sky130_fd_sc_hd__mux2_1
XFILLER_30_55 VGND VGND VPWR VPWR sky130_fd_sc_hd__decap_4
X_11110_ clknet_leaf_37_clk _00961_ VGND VGND VPWR VPWR picorv32_core.cpuregs\[0\]\[28\]
+ sky130_fd_sc_hd__dfxtp_1
XFILLER_107_167 VGND VGND VPWR VPWR sky130_fd_sc_hd__fill_1
Xhold781 picorv32_core.cpuregs\[4\]\[24\] VGND VGND VPWR VPWR net1890 sky130_fd_sc_hd__dlygate4sd3_1
Xhold770 picorv32_core.cpuregs\[28\]\[22\] VGND VGND VPWR VPWR net1879 sky130_fd_sc_hd__dlygate4sd3_1
X_11041_ clknet_leaf_41_clk _00892_ VGND VGND VPWR VPWR picorv32_core.cpuregs\[11\]\[23\]
+ sky130_fd_sc_hd__dfxtp_1
Xhold792 picorv32_core.cpuregs\[26\]\[9\] VGND VGND VPWR VPWR net1901 sky130_fd_sc_hd__dlygate4sd3_1
XFILLER_131_682 VGND VGND VPWR VPWR sky130_fd_sc_hd__decap_3
XFILLER_89_596 VGND VGND VPWR VPWR sky130_fd_sc_hd__decap_3
XFILLER_130_192 VGND VGND VPWR VPWR sky130_fd_sc_hd__decap_4
XFILLER_76_257 VGND VGND VPWR VPWR sky130_fd_sc_hd__fill_1
XFILLER_18_836 VGND VGND VPWR VPWR sky130_fd_sc_hd__fill_1
XTAP_TAPCELL_ROW_86_1556 VGND VPWR sky130_fd_sc_hd__tapvpwrvgnd_1
XTAP_TAPCELL_ROW_86_1545 VGND VPWR sky130_fd_sc_hd__tapvpwrvgnd_1
XFILLER_33_828 VGND VGND VPWR VPWR sky130_fd_sc_hd__decap_8
XFILLER_72_485 VGND VGND VPWR VPWR sky130_fd_sc_hd__decap_3
X_10825_ clknet_leaf_137_clk _00676_ VGND VGND VPWR VPWR picorv32_core.cpuregs\[17\]\[2\]
+ sky130_fd_sc_hd__dfxtp_1
XTAP_TAPCELL_ROW_15_525 VGND VPWR sky130_fd_sc_hd__tapvpwrvgnd_1
XFILLER_13_552 VGND VGND VPWR VPWR sky130_fd_sc_hd__fill_2
X_10756_ clknet_leaf_112_clk _00607_ VGND VGND VPWR VPWR picorv32_core.decoded_imm\[3\]
+ sky130_fd_sc_hd__dfxtp_1
XTAP_TAPCELL_ROW_117_2000 VGND VPWR sky130_fd_sc_hd__tapvpwrvgnd_1
XFILLER_71_84 VGND VGND VPWR VPWR sky130_fd_sc_hd__decap_6
X_10687_ clknet_leaf_98_clk _00538_ VGND VGND VPWR VPWR picorv32_core.is_beq_bne_blt_bge_bltu_bgeu
+ sky130_fd_sc_hd__dfxtp_1
XFILLER_40_393 VGND VGND VPWR VPWR sky130_fd_sc_hd__fill_1
XFILLER_141_446 VGND VGND VPWR VPWR sky130_fd_sc_hd__fill_2
X_11308_ clknet_leaf_68_clk _01156_ VGND VGND VPWR VPWR picorv32_core.cpuregs\[3\]\[31\]
+ sky130_fd_sc_hd__dfxtp_1
XFILLER_113_137 VGND VGND VPWR VPWR sky130_fd_sc_hd__fill_1
X_11239_ clknet_leaf_71_clk _01090_ VGND VGND VPWR VPWR picorv32_core.cpuregs\[5\]\[29\]
+ sky130_fd_sc_hd__dfxtp_1
XFILLER_110_811 VGND VGND VPWR VPWR sky130_fd_sc_hd__fill_1
XTAP_TAPCELL_ROW_128_2162 VGND VPWR sky130_fd_sc_hd__tapvpwrvgnd_1
X_05800_ _02279_ _02280_ VGND VGND VPWR VPWR _02281_ sky130_fd_sc_hd__nand2_1
X_06780_ net674 _03007_ _03008_ VGND VGND VPWR VPWR _03009_ sky130_fd_sc_hd__or3_1
XFILLER_75_290 VGND VGND VPWR VPWR sky130_fd_sc_hd__decap_4
X_05731_ net813 net965 _02126_ VGND VGND VPWR VPWR _02215_ sky130_fd_sc_hd__and3b_1
XTAP_TAPCELL_ROW_141_2362 VGND VPWR sky130_fd_sc_hd__tapvpwrvgnd_1
XTAP_TAPCELL_ROW_141_2351 VGND VPWR sky130_fd_sc_hd__tapvpwrvgnd_1
X_05662_ net785 net182 VGND VGND VPWR VPWR _02146_ sky130_fd_sc_hd__nand2_1
X_08450_ net2343 net531 _04284_ _04305_ VGND VGND VPWR VPWR _00598_ sky130_fd_sc_hd__o22a_1
XFILLER_51_614 VGND VGND VPWR VPWR sky130_fd_sc_hd__fill_2
XTAP_TAPCELL_ROW_34_801 VGND VPWR sky130_fd_sc_hd__tapvpwrvgnd_1
X_07401_ _03397_ _03538_ _03539_ VGND VGND VPWR VPWR _03541_ sky130_fd_sc_hd__a21oi_1
X_08381_ net1168 net456 _04265_ VGND VGND VPWR VPWR _00569_ sky130_fd_sc_hd__o21a_1
X_05593_ picorv32_core.reg_pc\[28\] picorv32_core.decoded_imm\[28\] VGND VGND VPWR
+ VPWR _02081_ sky130_fd_sc_hd__nand2_1
X_07332_ _03453_ _03455_ VGND VGND VPWR VPWR _03472_ sky130_fd_sc_hd__nand2_1
X_07263_ net768 picorv32_core.decoded_imm\[27\] VGND VGND VPWR VPWR _03403_ sky130_fd_sc_hd__nor2_1
X_09002_ net268 net1375 net344 VGND VGND VPWR VPWR _01172_ sky130_fd_sc_hd__mux2_1
X_07194_ _03353_ net992 _03352_ VGND VGND VPWR VPWR _00305_ sky130_fd_sc_hd__and3b_1
X_06214_ picorv32_core.cpuregs\[4\]\[4\] picorv32_core.cpuregs\[5\]\[4\] picorv32_core.cpuregs\[6\]\[4\]
+ picorv32_core.cpuregs\[7\]\[4\] net745 net712 VGND VGND VPWR VPWR _02644_ sky130_fd_sc_hd__mux4_1
X_06145_ _02595_ _02597_ VGND VGND VPWR VPWR _02598_ sky130_fd_sc_hd__xnor2_1
XFILLER_117_465 VGND VGND VPWR VPWR sky130_fd_sc_hd__decap_3
XTAP_TAPCELL_ROW_57_1135 VGND VPWR sky130_fd_sc_hd__tapvpwrvgnd_1
XFILLER_2_209 VPWR VGND VPWR VGND sky130_ef_sc_hd__decap_12
XFILLER_105_638 VPWR VGND VPWR VGND sky130_ef_sc_hd__decap_12
XFILLER_104_115 VGND VGND VPWR VPWR sky130_fd_sc_hd__decap_3
X_06076_ _02533_ _02534_ VGND VGND VPWR VPWR _02535_ sky130_fd_sc_hd__nor2_1
XTAP_TAPCELL_ROW_70_1313 VGND VPWR sky130_fd_sc_hd__tapvpwrvgnd_1
Xfanout524 net525 VGND VGND VPWR VPWR net524 sky130_fd_sc_hd__buf_2
X_09904_ net467 net1632 net321 VGND VGND VPWR VPWR _01388_ sky130_fd_sc_hd__mux2_1
Xfanout502 net505 VGND VGND VPWR VPWR net502 sky130_fd_sc_hd__clkbuf_2
Xfanout513 _01664_ VGND VGND VPWR VPWR net513 sky130_fd_sc_hd__buf_2
X_09835_ _04996_ _05003_ _05004_ net647 net651 VGND VGND VPWR VPWR _05005_ sky130_fd_sc_hd__a221o_1
XFILLER_86_533 VGND VGND VPWR VPWR sky130_fd_sc_hd__decap_4
XFILLER_76_29 VGND VGND VPWR VPWR sky130_fd_sc_hd__decap_4
XTAP_TAPCELL_ROW_70_1324 VGND VPWR sky130_fd_sc_hd__tapvpwrvgnd_1
Xfanout535 _03580_ VGND VGND VPWR VPWR net535 sky130_fd_sc_hd__buf_4
Xfanout546 _03388_ VGND VGND VPWR VPWR net546 sky130_fd_sc_hd__buf_2
XFILLER_59_725 VGND VGND VPWR VPWR sky130_fd_sc_hd__decap_3
Xfanout557 _02910_ VGND VGND VPWR VPWR net557 sky130_fd_sc_hd__clkbuf_4
Xfanout579 net580 VGND VGND VPWR VPWR net579 sky130_fd_sc_hd__dlymetal6s2s_1
XFILLER_86_555 VGND VGND VPWR VPWR sky130_fd_sc_hd__decap_8
Xfanout568 _02252_ VGND VGND VPWR VPWR net568 sky130_fd_sc_hd__clkbuf_2
X_09766_ _04930_ _04931_ _04934_ _04935_ net660 net829 VGND VGND VPWR VPWR _04939_
+ sky130_fd_sc_hd__mux4_1
X_06978_ net932 _02935_ VGND VGND VPWR VPWR _03191_ sky130_fd_sc_hd__nand2_1
XFILLER_74_739 VGND VGND VPWR VPWR sky130_fd_sc_hd__fill_2
XFILLER_67_780 VGND VGND VPWR VPWR sky130_fd_sc_hd__decap_4
XFILLER_27_611 VGND VGND VPWR VPWR sky130_fd_sc_hd__fill_1
X_09697_ picorv32_core.cpuregs\[16\]\[23\] picorv32_core.cpuregs\[17\]\[23\] picorv32_core.cpuregs\[18\]\[23\]
+ picorv32_core.cpuregs\[19\]\[23\] net899 net865 VGND VGND VPWR VPWR _04873_ sky130_fd_sc_hd__mux4_1
X_08717_ net1856 net214 net385 VGND VGND VPWR VPWR _00866_ sky130_fd_sc_hd__mux2_1
X_05929_ net957 net177 VGND VGND VPWR VPWR _02399_ sky130_fd_sc_hd__or2_1
XFILLER_39_493 VGND VGND VPWR VPWR sky130_fd_sc_hd__decap_3
X_08648_ net2054 net226 net393 VGND VGND VPWR VPWR _00799_ sky130_fd_sc_hd__mux2_1
XTAP_TAPCELL_ROW_68_1297 VGND VPWR sky130_fd_sc_hd__tapvpwrvgnd_1
XTAP_TAPCELL_ROW_68_1286 VGND VPWR sky130_fd_sc_hd__tapvpwrvgnd_1
XFILLER_42_614 VGND VGND VPWR VPWR sky130_fd_sc_hd__fill_1
XFILLER_42_625 VPWR VGND VPWR VGND sky130_ef_sc_hd__decap_12
X_08579_ _02791_ net1607 net401 VGND VGND VPWR VPWR _00704_ sky130_fd_sc_hd__mux2_1
XFILLER_41_146 VGND VGND VPWR VPWR sky130_fd_sc_hd__decap_6
XTAP_TAPCELL_ROW_81_1486 VGND VPWR sky130_fd_sc_hd__tapvpwrvgnd_1
XTAP_TAPCELL_ROW_81_1475 VGND VPWR sky130_fd_sc_hd__tapvpwrvgnd_1
X_10610_ clknet_leaf_93_clk _00464_ VGND VGND VPWR VPWR picorv32_core.instr_srl sky130_fd_sc_hd__dfxtp_1
X_11590_ clknet_leaf_118_clk _01421_ VGND VGND VPWR VPWR picorv32_core.cpuregs\[23\]\[3\]
+ sky130_fd_sc_hd__dfxtp_1
X_10541_ clknet_leaf_61_clk picorv32_core.alu_out\[29\] VGND VGND VPWR VPWR picorv32_core.alu_out_q\[29\]
+ sky130_fd_sc_hd__dfxtp_1
XFILLER_108_421 VGND VGND VPWR VPWR sky130_fd_sc_hd__fill_2
XFILLER_6_537 VGND VGND VPWR VPWR sky130_fd_sc_hd__fill_1
X_10472_ clknet_leaf_105_clk _00359_ VGND VGND VPWR VPWR picorv32_core.mem_do_wdata
+ sky130_fd_sc_hd__dfxtp_2
XFILLER_123_402 VGND VGND VPWR VPWR sky130_fd_sc_hd__decap_3
XFILLER_108_465 VGND VGND VPWR VPWR sky130_fd_sc_hd__fill_1
XTAP_TAPCELL_ROW_20_594 VGND VPWR sky130_fd_sc_hd__tapvpwrvgnd_1
XFILLER_123_446 VGND VGND VPWR VPWR sky130_fd_sc_hd__fill_2
XFILLER_123_413 VGND VGND VPWR VPWR sky130_fd_sc_hd__fill_2
XFILLER_123_457 VGND VGND VPWR VPWR sky130_fd_sc_hd__decap_4
X_11024_ clknet_leaf_141_clk _00875_ VGND VGND VPWR VPWR picorv32_core.cpuregs\[11\]\[6\]
+ sky130_fd_sc_hd__dfxtp_1
XFILLER_2_26 VGND VGND VPWR VPWR sky130_fd_sc_hd__fill_2
XFILLER_33_603 VGND VGND VPWR VPWR sky130_fd_sc_hd__decap_4
XTAP_TAPCELL_ROW_123_2092 VGND VPWR sky130_fd_sc_hd__tapvpwrvgnd_1
X_11857_ net61 VGND VGND VPWR VPWR net93 sky130_fd_sc_hd__clkbuf_1
XFILLER_21_809 VGND VGND VPWR VPWR sky130_fd_sc_hd__fill_1
X_10808_ clknet_leaf_25_clk _00659_ VGND VGND VPWR VPWR picorv32_core.cpuregs\[15\]\[17\]
+ sky130_fd_sc_hd__dfxtp_1
XFILLER_60_477 VGND VGND VPWR VPWR sky130_fd_sc_hd__decap_8
XFILLER_32_179 VGND VGND VPWR VPWR sky130_fd_sc_hd__fill_1
XTAP_TAPCELL_ROW_99_1736 VGND VPWR sky130_fd_sc_hd__tapvpwrvgnd_1
X_10739_ clknet_leaf_89_clk _00590_ VGND VGND VPWR VPWR picorv32_core.decoded_imm\[20\]
+ sky130_fd_sc_hd__dfxtp_1
XFILLER_13_393 VGND VGND VPWR VPWR sky130_fd_sc_hd__fill_2
XFILLER_118_218 VGND VGND VPWR VPWR sky130_fd_sc_hd__decap_6
XTAP_TAPCELL_ROW_99_1747 VGND VPWR sky130_fd_sc_hd__tapvpwrvgnd_1
XFILLER_127_785 VPWR VGND VPWR VGND sky130_ef_sc_hd__decap_12
Xoutput105 net105 VGND VGND VPWR VPWR mem_axi_wdata[10] sky130_fd_sc_hd__buf_2
Xoutput116 net116 VGND VGND VPWR VPWR mem_axi_wdata[20] sky130_fd_sc_hd__buf_2
XFILLER_141_221 VGND VGND VPWR VPWR sky130_fd_sc_hd__decap_3
XFILLER_99_113 VGND VGND VPWR VPWR sky130_fd_sc_hd__fill_1
Xoutput127 net127 VGND VGND VPWR VPWR mem_axi_wdata[30] sky130_fd_sc_hd__buf_2
Xoutput149 net788 VGND VGND VPWR VPWR pcpi_rs1[17] sky130_fd_sc_hd__buf_2
Xoutput138 net138 VGND VGND VPWR VPWR mem_axi_wstrb[2] sky130_fd_sc_hd__buf_2
X_07950_ picorv32_core.cpuregs\[4\]\[24\] picorv32_core.cpuregs\[5\]\[24\] picorv32_core.cpuregs\[6\]\[24\]
+ picorv32_core.cpuregs\[7\]\[24\] net752 net719 VGND VGND VPWR VPWR _04031_ sky130_fd_sc_hd__mux4_1
XTAP_TAPCELL_ROW_110_1903 VGND VPWR sky130_fd_sc_hd__tapvpwrvgnd_1
X_06901_ picorv32_core.decoded_imm_j\[17\] _02929_ VGND VGND VPWR VPWR _03120_ sky130_fd_sc_hd__nand2_1
X_07881_ net635 _03965_ VGND VGND VPWR VPWR _03966_ sky130_fd_sc_hd__or2_1
XFILLER_68_566 VGND VGND VPWR VPWR sky130_fd_sc_hd__decap_6
XFILLER_68_533 VPWR VGND VPWR VGND sky130_ef_sc_hd__decap_12
XTAP_TAPCELL_ROW_52_1065 VGND VPWR sky130_fd_sc_hd__tapvpwrvgnd_1
XTAP_TAPCELL_ROW_52_1054 VGND VPWR sky130_fd_sc_hd__tapvpwrvgnd_1
XFILLER_95_352 VGND VGND VPWR VPWR sky130_fd_sc_hd__fill_1
X_09620_ picorv32_core.reg_pc\[19\] net537 _04799_ net484 VGND VGND VPWR VPWR _04800_
+ sky130_fd_sc_hd__a211o_1
XFILLER_83_525 VGND VGND VPWR VPWR sky130_fd_sc_hd__decap_4
X_06832_ net975 _03056_ VGND VGND VPWR VPWR _00240_ sky130_fd_sc_hd__nor2_1
XFILLER_110_696 VGND VGND VPWR VPWR sky130_fd_sc_hd__decap_4
XFILLER_83_547 VGND VGND VPWR VPWR sky130_fd_sc_hd__decap_3
X_09551_ picorv32_core.reg_pc\[16\] net537 _04733_ net484 VGND VGND VPWR VPWR _04734_
+ sky130_fd_sc_hd__a211o_1
X_06763_ _02988_ _02990_ _02991_ net663 VGND VGND VPWR VPWR _02993_ sky130_fd_sc_hd__a31o_1
XTAP_TAPCELL_ROW_108_1876 VGND VPWR sky130_fd_sc_hd__tapvpwrvgnd_1
XTAP_TAPCELL_ROW_108_1865 VGND VPWR sky130_fd_sc_hd__tapvpwrvgnd_1
XFILLER_102_27 VGND VGND VPWR VPWR sky130_fd_sc_hd__fill_1
X_08502_ net1425 net241 net408 VGND VGND VPWR VPWR _00632_ sky130_fd_sc_hd__mux2_1
X_05714_ net801 net958 VGND VGND VPWR VPWR _02198_ sky130_fd_sc_hd__nand2_1
X_06694_ picorv32_core.reg_pc\[24\] net553 _02936_ net516 VGND VGND VPWR VPWR _00222_
+ sky130_fd_sc_hd__a22o_1
X_09482_ _04659_ _04660_ _04666_ _04665_ net836 net826 VGND VGND VPWR VPWR _04668_
+ sky130_fd_sc_hd__mux4_1
XFILLER_23_113 VGND VGND VPWR VPWR sky130_fd_sc_hd__fill_1
XFILLER_24_614 VGND VGND VPWR VPWR sky130_fd_sc_hd__fill_1
XFILLER_36_474 VGND VGND VPWR VPWR sky130_fd_sc_hd__fill_2
XFILLER_36_496 VGND VGND VPWR VPWR sky130_fd_sc_hd__fill_2
XTAP_TAPCELL_ROW_47_981 VGND VPWR sky130_fd_sc_hd__tapvpwrvgnd_1
XTAP_TAPCELL_ROW_47_992 VGND VPWR sky130_fd_sc_hd__tapvpwrvgnd_1
X_08433_ picorv32_core.decoded_imm\[20\] net528 VGND VGND VPWR VPWR _04297_ sky130_fd_sc_hd__or2_1
X_05645_ _02128_ VGND VGND VPWR VPWR _02129_ sky130_fd_sc_hd__inv_2
X_05576_ picorv32_core.reg_pc\[27\] picorv32_core.decoded_imm\[27\] VGND VGND VPWR
+ VPWR _02065_ sky130_fd_sc_hd__nand2_1
X_08364_ picorv32_core.mem_la_wdata\[4\] net955 net582 VGND VGND VPWR VPWR _04257_
+ sky130_fd_sc_hd__mux2_1
X_07315_ net812 picorv32_core.decoded_imm\[5\] VGND VGND VPWR VPWR _03455_ sky130_fd_sc_hd__nand2_1
X_08295_ net1136 _00748_ net438 VGND VGND VPWR VPWR _00518_ sky130_fd_sc_hd__mux2_1
X_07246_ picorv32_core.mem_do_wdata _01631_ picorv32_core.cpu_state\[5\] VGND VGND
+ VPWR VPWR _03386_ sky130_fd_sc_hd__o21ai_2
XFILLER_117_262 VGND VGND VPWR VPWR sky130_fd_sc_hd__decap_4
XFILLER_105_402 VPWR VGND VPWR VGND sky130_ef_sc_hd__decap_12
X_07177_ picorv32_core.count_cycle\[37\] picorv32_core.count_cycle\[38\] _03339_ VGND
+ VGND VPWR VPWR _03343_ sky130_fd_sc_hd__and3_1
XFILLER_11_57 VPWR VGND VPWR VGND sky130_ef_sc_hd__decap_12
XFILLER_127_57 VPWR VGND VPWR VGND sky130_ef_sc_hd__decap_12
X_06128_ _02579_ _02582_ VGND VGND VPWR VPWR _02583_ sky130_fd_sc_hd__nand2_1
XFILLER_133_777 VGND VGND VPWR VPWR sky130_fd_sc_hd__decap_6
X_06059_ _02518_ net773 VGND VGND VPWR VPWR _02519_ sky130_fd_sc_hd__nand2b_1
XFILLER_87_831 VGND VGND VPWR VPWR sky130_fd_sc_hd__fill_2
Xfanout310 net311 VGND VGND VPWR VPWR net310 sky130_fd_sc_hd__buf_4
Xfanout321 _05033_ VGND VGND VPWR VPWR net321 sky130_fd_sc_hd__clkbuf_4
Xfanout332 _04350_ VGND VGND VPWR VPWR net332 sky130_fd_sc_hd__clkbuf_8
XFILLER_101_641 VGND VGND VPWR VPWR sky130_fd_sc_hd__fill_1
Xfanout343 _04348_ VGND VGND VPWR VPWR net343 sky130_fd_sc_hd__buf_4
Xfanout354 net357 VGND VGND VPWR VPWR net354 sky130_fd_sc_hd__clkbuf_8
Xfanout365 _04342_ VGND VGND VPWR VPWR net365 sky130_fd_sc_hd__buf_4
Xfanout376 net377 VGND VGND VPWR VPWR net376 sky130_fd_sc_hd__buf_4
X_09818_ _03399_ _03401_ _03536_ VGND VGND VPWR VPWR _04988_ sky130_fd_sc_hd__a21oi_1
XTAP_TAPCELL_ROW_6_389 VGND VPWR sky130_fd_sc_hd__tapvpwrvgnd_1
Xfanout387 _04335_ VGND VGND VPWR VPWR net387 sky130_fd_sc_hd__buf_4
Xfanout398 net399 VGND VGND VPWR VPWR net398 sky130_fd_sc_hd__clkbuf_8
XFILLER_47_706 VGND VGND VPWR VPWR sky130_fd_sc_hd__decap_4
X_09749_ picorv32_core.reg_pc\[25\] net538 _04922_ net483 VGND VGND VPWR VPWR _04923_
+ sky130_fd_sc_hd__a211o_1
XTAP_TAPCELL_ROW_83_1504 VGND VPWR sky130_fd_sc_hd__tapvpwrvgnd_1
XFILLER_39_290 VGND VGND VPWR VPWR sky130_fd_sc_hd__fill_1
XTAP_TAPCELL_ROW_83_1515 VGND VPWR sky130_fd_sc_hd__tapvpwrvgnd_1
X_11711_ clknet_leaf_39_clk _01542_ VGND VGND VPWR VPWR picorv32_core.cpuregs\[27\]\[28\]
+ sky130_fd_sc_hd__dfxtp_1
X_11642_ clknet_leaf_46_clk _01473_ VGND VGND VPWR VPWR picorv32_core.cpuregs\[28\]\[23\]
+ sky130_fd_sc_hd__dfxtp_1
XTAP_TAPCELL_ROW_25_664 VGND VPWR sky130_fd_sc_hd__tapvpwrvgnd_1
X_11573_ clknet_leaf_40_clk _01404_ VGND VGND VPWR VPWR picorv32_core.cpuregs\[2\]\[20\]
+ sky130_fd_sc_hd__dfxtp_1
Xinput18 mem_axi_rdata[22] VGND VGND VPWR VPWR net18 sky130_fd_sc_hd__buf_2
XFILLER_109_752 VGND VGND VPWR VPWR sky130_fd_sc_hd__decap_8
X_10524_ clknet_leaf_126_clk picorv32_core.alu_out\[12\] VGND VGND VPWR VPWR picorv32_core.alu_out_q\[12\]
+ sky130_fd_sc_hd__dfxtp_1
Xinput29 mem_axi_rdata[3] VGND VGND VPWR VPWR net29 sky130_fd_sc_hd__buf_1
XFILLER_136_571 VGND VGND VPWR VPWR sky130_fd_sc_hd__fill_1
XFILLER_109_785 VPWR VGND VPWR VGND sky130_ef_sc_hd__decap_12
X_10455_ clknet_leaf_79_clk _00342_ VGND VGND VPWR VPWR net47 sky130_fd_sc_hd__dfxtp_1
XTAP_TAPCELL_ROW_94_1666 VGND VPWR sky130_fd_sc_hd__tapvpwrvgnd_1
X_10386_ clknet_leaf_100_clk _00305_ VGND VGND VPWR VPWR picorv32_core.count_cycle\[44\]
+ sky130_fd_sc_hd__dfxtp_1
XFILLER_2_595 VGND VGND VPWR VPWR sky130_fd_sc_hd__fill_1
X_11007_ clknet_leaf_48_clk _00858_ VGND VGND VPWR VPWR picorv32_core.cpuregs\[12\]\[21\]
+ sky130_fd_sc_hd__dfxtp_1
XFILLER_65_503 VGND VGND VPWR VPWR sky130_fd_sc_hd__fill_1
XFILLER_38_706 VGND VGND VPWR VPWR sky130_fd_sc_hd__fill_2
XTAP_TAPCELL_ROW_125_2121 VGND VPWR sky130_fd_sc_hd__tapvpwrvgnd_1
XFILLER_92_388 VGND VGND VPWR VPWR sky130_fd_sc_hd__decap_4
XFILLER_46_783 VGND VGND VPWR VPWR sky130_fd_sc_hd__decap_4
XTAP_TAPCELL_ROW_44_940 VGND VPWR sky130_fd_sc_hd__tapvpwrvgnd_1
X_05430_ picorv32_core.reg_pc\[14\] picorv32_core.decoded_imm\[14\] _01914_ VGND VGND
+ VPWR VPWR _01930_ sky130_fd_sc_hd__and3_1
XFILLER_21_617 VGND VGND VPWR VPWR sky130_fd_sc_hd__fill_1
XTAP_TAPCELL_ROW_103_1795 VGND VPWR sky130_fd_sc_hd__tapvpwrvgnd_1
X_05361_ net926 _01757_ net585 VGND VGND VPWR VPWR _01866_ sky130_fd_sc_hd__a21o_1
X_07100_ net2253 _03293_ net986 VGND VGND VPWR VPWR _03295_ sky130_fd_sc_hd__o21ai_1
XTAP_TAPCELL_ROW_136_2272 VGND VPWR sky130_fd_sc_hd__tapvpwrvgnd_1
X_08080_ picorv32_core.cpuregs\[8\]\[31\] picorv32_core.cpuregs\[9\]\[31\] picorv32_core.cpuregs\[10\]\[31\]
+ picorv32_core.cpuregs\[11\]\[31\] net760 net727 VGND VGND VPWR VPWR _04154_ sky130_fd_sc_hd__mux4_1
XFILLER_9_183 VGND VGND VPWR VPWR sky130_fd_sc_hd__decap_4
X_05292_ picorv32_core.count_cycle\[6\] net599 net576 _01801_ VGND VGND VPWR VPWR
+ _01802_ sky130_fd_sc_hd__o211a_1
XTAP_TAPCELL_ROW_136_2283 VGND VPWR sky130_fd_sc_hd__tapvpwrvgnd_1
X_07031_ net678 _03237_ _03238_ _03239_ VGND VGND VPWR VPWR _03240_ sky130_fd_sc_hd__o31a_1
X_08982_ net1461 net215 net351 VGND VGND VPWR VPWR _01154_ sky130_fd_sc_hd__mux2_1
XFILLER_130_725 VPWR VGND VPWR VGND sky130_ef_sc_hd__decap_12
XFILLER_130_769 VPWR VGND VPWR VGND sky130_ef_sc_hd__decap_12
X_07933_ picorv32_core.cpuregs\[24\]\[23\] picorv32_core.cpuregs\[25\]\[23\] picorv32_core.cpuregs\[26\]\[23\]
+ picorv32_core.cpuregs\[27\]\[23\] net755 net722 VGND VGND VPWR VPWR _04015_ sky130_fd_sc_hd__mux4_1
XFILLER_102_449 VGND VGND VPWR VPWR sky130_fd_sc_hd__decap_4
XFILLER_87_149 VGND VGND VPWR VPWR sky130_fd_sc_hd__decap_3
X_07864_ net634 _03940_ net685 VGND VGND VPWR VPWR _03950_ sky130_fd_sc_hd__o21a_1
XFILLER_68_363 VGND VGND VPWR VPWR sky130_fd_sc_hd__fill_1
X_09603_ net775 net547 VGND VGND VPWR VPWR _04783_ sky130_fd_sc_hd__or2_1
XFILLER_68_385 VGND VGND VPWR VPWR sky130_fd_sc_hd__decap_6
X_06815_ _02921_ _03012_ _02922_ VGND VGND VPWR VPWR _03041_ sky130_fd_sc_hd__a21oi_1
XFILLER_56_525 VGND VGND VPWR VPWR sky130_fd_sc_hd__decap_6
XTAP_TAPCELL_ROW_3_348 VGND VPWR sky130_fd_sc_hd__tapvpwrvgnd_1
X_07795_ picorv32_core.decoded_imm\[15\] net591 _03702_ _03884_ net596 VGND VGND VPWR
+ VPWR _03885_ sky130_fd_sc_hd__a221o_1
X_09534_ net798 net781 net544 VGND VGND VPWR VPWR _04717_ sky130_fd_sc_hd__mux2_1
X_06746_ _02975_ _02976_ VGND VGND VPWR VPWR _02977_ sky130_fd_sc_hd__nor2_1
X_06677_ _02729_ picorv32_core.reg_next_pc\[16\] net558 VGND VGND VPWR VPWR _02928_
+ sky130_fd_sc_hd__mux2_2
X_09465_ picorv32_core.reg_pc\[12\] net536 _04651_ net482 VGND VGND VPWR VPWR _04652_
+ sky130_fd_sc_hd__a211o_1
XTAP_TAPCELL_ROW_65_1245 VGND VPWR sky130_fd_sc_hd__tapvpwrvgnd_1
XFILLER_52_753 VGND VGND VPWR VPWR sky130_fd_sc_hd__decap_3
XFILLER_52_731 VGND VGND VPWR VPWR sky130_fd_sc_hd__fill_1
X_05628_ picorv32_core.reg_pc\[30\] picorv32_core.decoded_imm\[30\] _02105_ VGND VGND
+ VPWR VPWR _02113_ sky130_fd_sc_hd__a21oi_1
X_08416_ picorv32_core.decoded_imm\[29\] net529 _04285_ _04288_ VGND VGND VPWR VPWR
+ _00581_ sky130_fd_sc_hd__o22a_1
XFILLER_51_241 VGND VGND VPWR VPWR sky130_fd_sc_hd__fill_2
XFILLER_24_477 VGND VGND VPWR VPWR sky130_fd_sc_hd__fill_2
XTAP_TAPCELL_ROW_22_623 VGND VPWR sky130_fd_sc_hd__tapvpwrvgnd_1
X_09396_ _04577_ _04584_ _04585_ net642 net648 VGND VGND VPWR VPWR _04586_ sky130_fd_sc_hd__a221o_1
XFILLER_138_825 VPWR VGND VPWR VGND sky130_ef_sc_hd__decap_12
XFILLER_137_302 VGND VGND VPWR VPWR sky130_fd_sc_hd__fill_1
X_05559_ picorv32_core.count_cycle\[25\] net600 VGND VGND VPWR VPWR _02050_ sky130_fd_sc_hd__or2_1
X_08347_ net928 net964 net177 net927 VGND VGND VPWR VPWR _04247_ sky130_fd_sc_hd__a22o_1
X_08278_ net1220 net264 net412 VGND VGND VPWR VPWR _00502_ sky130_fd_sc_hd__mux2_1
X_07229_ net977 _03375_ VGND VGND VPWR VPWR _03376_ sky130_fd_sc_hd__nor2_1
XFILLER_4_805 VGND VGND VPWR VPWR sky130_fd_sc_hd__decap_6
XFILLER_106_722 VGND VGND VPWR VPWR sky130_fd_sc_hd__decap_8
XFILLER_98_27 VGND VGND VPWR VPWR sky130_fd_sc_hd__fill_1
X_10240_ clknet_leaf_79_clk _00159_ VGND VGND VPWR VPWR picorv32_core.count_instr\[24\]
+ sky130_fd_sc_hd__dfxtp_1
XFILLER_106_766 VGND VGND VPWR VPWR sky130_fd_sc_hd__decap_6
XFILLER_79_606 VGND VGND VPWR VPWR sky130_fd_sc_hd__decap_4
XFILLER_3_337 VGND VGND VPWR VPWR sky130_fd_sc_hd__fill_2
XFILLER_121_725 VGND VGND VPWR VPWR sky130_fd_sc_hd__decap_3
X_10171_ clknet_leaf_28_clk _00090_ VGND VGND VPWR VPWR picorv32_core.cpuregs\[21\]\[19\]
+ sky130_fd_sc_hd__dfxtp_1
XFILLER_79_628 VGND VGND VPWR VPWR sky130_fd_sc_hd__decap_6
XFILLER_79_617 VGND VGND VPWR VPWR sky130_fd_sc_hd__decap_4
XPHY_EDGE_ROW_110_Right_110 VGND VGND VPWR VPWR sky130_fd_sc_hd__decap_3
XFILLER_94_609 VGND VGND VPWR VPWR sky130_fd_sc_hd__decap_4
XFILLER_59_363 VGND VGND VPWR VPWR sky130_fd_sc_hd__fill_2
XFILLER_47_569 VGND VGND VPWR VPWR sky130_fd_sc_hd__decap_8
XFILLER_74_399 VGND VGND VPWR VPWR sky130_fd_sc_hd__fill_2
XFILLER_62_517 VGND VGND VPWR VPWR sky130_fd_sc_hd__fill_2
XTAP_TAPCELL_ROW_120_2040 VGND VPWR sky130_fd_sc_hd__tapvpwrvgnd_1
XTAP_TAPCELL_ROW_120_2051 VGND VPWR sky130_fd_sc_hd__tapvpwrvgnd_1
XFILLER_30_436 VGND VGND VPWR VPWR sky130_fd_sc_hd__fill_1
X_11625_ clknet_leaf_138_clk _01456_ VGND VGND VPWR VPWR picorv32_core.cpuregs\[28\]\[6\]
+ sky130_fd_sc_hd__dfxtp_1
X_11556_ clknet_leaf_117_clk _01387_ VGND VGND VPWR VPWR picorv32_core.cpuregs\[2\]\[3\]
+ sky130_fd_sc_hd__dfxtp_1
XFILLER_6_153 VPWR VGND VPWR VGND sky130_ef_sc_hd__decap_12
X_10507_ clknet_leaf_105_clk _00393_ VGND VGND VPWR VPWR picorv32_core.latched_stalu
+ sky130_fd_sc_hd__dfxtp_2
X_11487_ clknet_leaf_120_clk _01323_ VGND VGND VPWR VPWR net167 sky130_fd_sc_hd__dfxtp_1
XFILLER_136_390 VGND VGND VPWR VPWR sky130_fd_sc_hd__fill_1
X_10438_ clknet_leaf_76_clk _01571_ VGND VGND VPWR VPWR picorv32_core.reg_out\[31\]
+ sky130_fd_sc_hd__dfxtp_1
XFILLER_6_197 VPWR VGND VPWR VGND sky130_ef_sc_hd__decap_12
X_10369_ clknet_leaf_77_clk _00288_ VGND VGND VPWR VPWR picorv32_core.count_cycle\[27\]
+ sky130_fd_sc_hd__dfxtp_1
XFILLER_69_105 VGND VGND VPWR VPWR sky130_fd_sc_hd__fill_1
XFILLER_112_769 VPWR VGND VPWR VGND sky130_ef_sc_hd__decap_12
XFILLER_38_503 VGND VGND VPWR VPWR sky130_fd_sc_hd__fill_2
XFILLER_93_631 VGND VGND VPWR VPWR sky130_fd_sc_hd__fill_1
XPHY_EDGE_ROW_69_Left_211 VGND VGND VPWR VPWR sky130_fd_sc_hd__decap_3
Xclkbuf_4_1_0_clk clknet_0_clk VGND VGND VPWR VPWR clknet_4_1_0_clk sky130_fd_sc_hd__clkbuf_8
XTAP_TAPCELL_ROW_0_307 VGND VPWR sky130_fd_sc_hd__tapvpwrvgnd_1
X_06600_ picorv32_core.count_instr\[48\] _02879_ net993 VGND VGND VPWR VPWR _02882_
+ sky130_fd_sc_hd__o21ai_1
XFILLER_53_517 VPWR VGND VPWR VGND sky130_ef_sc_hd__decap_12
X_07580_ picorv32_core.cpuregs\[28\]\[1\] picorv32_core.cpuregs\[29\]\[1\] picorv32_core.cpuregs\[30\]\[1\]
+ picorv32_core.cpuregs\[31\]\[1\] net744 net711 VGND VGND VPWR VPWR _03684_ sky130_fd_sc_hd__mux4_1
XFILLER_19_783 VGND VGND VPWR VPWR sky130_fd_sc_hd__fill_1
XTAP_TAPCELL_ROW_105_1824 VGND VPWR sky130_fd_sc_hd__tapvpwrvgnd_1
X_06531_ _02837_ _02838_ VGND VGND VPWR VPWR _00157_ sky130_fd_sc_hd__nor2_1
XFILLER_34_753 VGND VGND VPWR VPWR sky130_fd_sc_hd__decap_3
XFILLER_61_572 VGND VGND VPWR VPWR sky130_fd_sc_hd__decap_3
XFILLER_61_561 VGND VGND VPWR VPWR sky130_fd_sc_hd__decap_4
X_09250_ _04436_ _04445_ net485 net479 VGND VGND VPWR VPWR _04446_ sky130_fd_sc_hd__o211a_1
XFILLER_34_764 VGND VGND VPWR VPWR sky130_fd_sc_hd__fill_2
XFILLER_34_786 VPWR VGND VPWR VGND sky130_ef_sc_hd__decap_12
XTAP_TAPCELL_ROW_138_2312 VGND VPWR sky130_fd_sc_hd__tapvpwrvgnd_1
XTAP_TAPCELL_ROW_138_2301 VGND VPWR sky130_fd_sc_hd__tapvpwrvgnd_1
X_06462_ net228 net1518 net420 VGND VGND VPWR VPWR _00128_ sky130_fd_sc_hd__mux2_1
X_08201_ net972 _01708_ _04165_ VGND VGND VPWR VPWR _04205_ sky130_fd_sc_hd__or3_2
X_06393_ picorv32_core.reg_pc\[30\] _02784_ VGND VGND VPWR VPWR _02789_ sky130_fd_sc_hd__nand2_1
XPHY_EDGE_ROW_78_Left_220 VGND VGND VPWR VPWR sky130_fd_sc_hd__decap_3
X_05413_ picorv32_core.reg_pc\[15\] picorv32_core.decoded_imm\[15\] VGND VGND VPWR
+ VPWR _01914_ sky130_fd_sc_hd__or2_1
X_09181_ picorv32_core.cpuregs\[22\]\[1\] picorv32_core.cpuregs\[23\]\[1\] net886
+ VGND VGND VPWR VPWR _04379_ sky130_fd_sc_hd__mux2_1
Xpicorv32_axi_1009 VGND VGND VPWR VPWR picorv32_axi_1009/HI eoi[10] sky130_fd_sc_hd__conb_1
X_08132_ net221 net2195 net417 VGND VGND VPWR VPWR _00425_ sky130_fd_sc_hd__mux2_1
XTAP_TAPCELL_ROW_60_1175 VGND VPWR sky130_fd_sc_hd__tapvpwrvgnd_1
X_05344_ net914 net801 _01849_ net909 net577 VGND VGND VPWR VPWR _01850_ sky130_fd_sc_hd__a221o_1
X_08063_ _04132_ _04133_ net640 VGND VGND VPWR VPWR _04138_ sky130_fd_sc_hd__mux2_1
X_05275_ picorv32_core.count_instr\[37\] net935 net943 picorv32_core.count_cycle\[37\]
+ VGND VGND VPWR VPWR _01786_ sky130_fd_sc_hd__a22o_1
XFILLER_108_15 VPWR VGND VPWR VGND sky130_ef_sc_hd__decap_12
X_07014_ _03212_ _03215_ _03223_ VGND VGND VPWR VPWR _03224_ sky130_fd_sc_hd__a21oi_1
XTAP_TAPCELL_ROW_116_1986 VGND VPWR sky130_fd_sc_hd__tapvpwrvgnd_1
XTAP_TAPCELL_ROW_8_418 VGND VPWR sky130_fd_sc_hd__tapvpwrvgnd_1
XFILLER_68_19 VGND VGND VPWR VPWR sky130_fd_sc_hd__fill_1
XFILLER_130_533 VGND VGND VPWR VPWR sky130_fd_sc_hd__decap_4
X_08965_ net1452 net287 net348 VGND VGND VPWR VPWR _01137_ sky130_fd_sc_hd__mux2_1
X_07916_ net635 _03998_ VGND VGND VPWR VPWR _03999_ sky130_fd_sc_hd__or2_1
XFILLER_84_29 VGND VGND VPWR VPWR sky130_fd_sc_hd__fill_1
X_08896_ net298 net1345 net358 VGND VGND VPWR VPWR _01070_ sky130_fd_sc_hd__mux2_1
X_07847_ _03924_ _03932_ _03933_ net620 net689 VGND VGND VPWR VPWR _03934_ sky130_fd_sc_hd__a221o_1
XFILLER_56_355 VGND VGND VPWR VPWR sky130_fd_sc_hd__decap_8
X_07778_ net682 _03867_ net625 VGND VGND VPWR VPWR _03869_ sky130_fd_sc_hd__a21o_1
XFILLER_56_377 VGND VGND VPWR VPWR sky130_fd_sc_hd__decap_8
X_09517_ picorv32_core.cpuregs\[0\]\[15\] picorv32_core.cpuregs\[1\]\[15\] picorv32_core.cpuregs\[2\]\[15\]
+ picorv32_core.cpuregs\[3\]\[15\] net893 net859 VGND VGND VPWR VPWR _04701_ sky130_fd_sc_hd__mux4_1
XFILLER_25_753 VPWR VGND VPWR VGND sky130_ef_sc_hd__decap_12
X_06729_ net673 _02960_ _02961_ _02958_ net970 VGND VGND VPWR VPWR _02962_ sky130_fd_sc_hd__o221ai_1
X_09448_ net473 _04569_ _04634_ VGND VGND VPWR VPWR _04635_ sky130_fd_sc_hd__and3_1
XFILLER_24_274 VGND VGND VPWR VPWR sky130_fd_sc_hd__fill_2
XFILLER_25_797 VPWR VGND VPWR VGND sky130_ef_sc_hd__decap_12
XFILLER_40_745 VGND VGND VPWR VPWR sky130_fd_sc_hd__decap_8
XFILLER_138_611 VGND VGND VPWR VPWR sky130_fd_sc_hd__fill_2
X_09379_ net806 net541 VGND VGND VPWR VPWR _04569_ sky130_fd_sc_hd__or2_1
X_11410_ clknet_leaf_70_clk _01246_ VGND VGND VPWR VPWR picorv32_core.cpuregs\[31\]\[25\]
+ sky130_fd_sc_hd__dfxtp_1
X_11341_ clknet_leaf_70_clk _01182_ VGND VGND VPWR VPWR picorv32_core.cpuregs\[29\]\[25\]
+ sky130_fd_sc_hd__dfxtp_1
XFILLER_123_3 VPWR VGND VPWR VGND sky130_ef_sc_hd__decap_12
XTAP_TAPCELL_ROW_78_1436 VGND VPWR sky130_fd_sc_hd__tapvpwrvgnd_1
X_11272_ clknet_leaf_42_clk _01120_ VGND VGND VPWR VPWR picorv32_core.cpuregs\[4\]\[27\]
+ sky130_fd_sc_hd__dfxtp_1
XFILLER_106_541 VGND VGND VPWR VPWR sky130_fd_sc_hd__fill_1
XFILLER_106_530 VGND VGND VPWR VPWR sky130_fd_sc_hd__fill_2
XFILLER_121_500 VGND VGND VPWR VPWR sky130_fd_sc_hd__decap_4
XTAP_TAPCELL_ROW_91_1625 VGND VPWR sky130_fd_sc_hd__tapvpwrvgnd_1
X_10223_ clknet_leaf_102_clk _00142_ VGND VGND VPWR VPWR picorv32_core.count_instr\[7\]
+ sky130_fd_sc_hd__dfxtp_1
XFILLER_3_167 VGND VGND VPWR VPWR sky130_fd_sc_hd__fill_1
XFILLER_121_533 VGND VGND VPWR VPWR sky130_fd_sc_hd__fill_1
X_10154_ clknet_leaf_133_clk _00073_ VGND VGND VPWR VPWR picorv32_core.cpuregs\[21\]\[2\]
+ sky130_fd_sc_hd__dfxtp_1
Xhold7 picorv32_core.cpuregs\[0\]\[20\] VGND VGND VPWR VPWR net1116 sky130_fd_sc_hd__dlygate4sd3_1
X_10085_ net1126 VGND VGND VPWR VPWR _00935_ sky130_fd_sc_hd__clkbuf_1
XFILLER_75_664 VGND VGND VPWR VPWR sky130_fd_sc_hd__decap_3
XTAP_TAPCELL_ROW_89_1598 VGND VPWR sky130_fd_sc_hd__tapvpwrvgnd_1
XFILLER_35_517 VGND VGND VPWR VPWR sky130_fd_sc_hd__decap_8
XFILLER_28_580 VGND VGND VPWR VPWR sky130_fd_sc_hd__fill_1
X_10987_ clknet_leaf_110_clk _00838_ VGND VGND VPWR VPWR picorv32_core.cpuregs\[12\]\[1\]
+ sky130_fd_sc_hd__dfxtp_1
XFILLER_16_753 VGND VGND VPWR VPWR sky130_fd_sc_hd__decap_3
XFILLER_43_561 VPWR VGND VPWR VGND sky130_ef_sc_hd__decap_12
XTAP_TAPCELL_ROW_100_1754 VGND VPWR sky130_fd_sc_hd__tapvpwrvgnd_1
X_11608_ clknet_leaf_49_clk _01439_ VGND VGND VPWR VPWR picorv32_core.cpuregs\[23\]\[21\]
+ sky130_fd_sc_hd__dfxtp_1
XFILLER_90_83 VGND VGND VPWR VPWR sky130_fd_sc_hd__fill_1
XTAP_TAPCELL_ROW_13_497 VGND VPWR sky130_fd_sc_hd__tapvpwrvgnd_1
XTAP_TAPCELL_ROW_133_2231 VGND VPWR sky130_fd_sc_hd__tapvpwrvgnd_1
XFILLER_128_165 VGND VGND VPWR VPWR sky130_fd_sc_hd__decap_4
X_11539_ clknet_leaf_32_clk _01370_ VGND VGND VPWR VPWR picorv32_core.cpuregs\[30\]\[20\]
+ sky130_fd_sc_hd__dfxtp_1
Xhold418 net64 VGND VGND VPWR VPWR net1527 sky130_fd_sc_hd__dlygate4sd3_1
Xhold407 picorv32_core.cpuregs\[14\]\[0\] VGND VGND VPWR VPWR net1516 sky130_fd_sc_hd__dlygate4sd3_1
Xhold429 picorv32_core.cpuregs\[7\]\[25\] VGND VGND VPWR VPWR net1538 sky130_fd_sc_hd__dlygate4sd3_1
X_05060_ picorv32_core.mem_wordsize\[1\] VGND VGND VPWR VPWR _01595_ sky130_fd_sc_hd__clkinv_4
XFILLER_3_690 VPWR VGND VPWR VGND sky130_ef_sc_hd__decap_12
Xfanout909 picorv32_core.cpu_state\[6\] VGND VGND VPWR VPWR net909 sky130_fd_sc_hd__clkbuf_4
XFILLER_98_778 VGND VGND VPWR VPWR sky130_fd_sc_hd__fill_2
XFILLER_39_812 VGND VGND VPWR VPWR sky130_fd_sc_hd__fill_2
X_08750_ net1480 net213 net380 VGND VGND VPWR VPWR _00898_ sky130_fd_sc_hd__mux2_1
Xhold1129 picorv32_core.cpuregs\[4\]\[17\] VGND VGND VPWR VPWR net2238 sky130_fd_sc_hd__dlygate4sd3_1
X_05962_ net671 _02429_ VGND VGND VPWR VPWR _02430_ sky130_fd_sc_hd__nand2_1
Xhold1118 picorv32_core.cpuregs\[1\]\[13\] VGND VGND VPWR VPWR net2227 sky130_fd_sc_hd__dlygate4sd3_1
Xhold1107 picorv32_core.cpuregs\[2\]\[11\] VGND VGND VPWR VPWR net2216 sky130_fd_sc_hd__dlygate4sd3_1
X_08681_ net226 net1799 net389 VGND VGND VPWR VPWR _00831_ sky130_fd_sc_hd__mux2_1
X_05893_ net175 _02365_ VGND VGND VPWR VPWR _02366_ sky130_fd_sc_hd__xnor2_1
X_07701_ net692 _03790_ net681 VGND VGND VPWR VPWR _03796_ sky130_fd_sc_hd__o21a_1
XTAP_TAPCELL_ROW_49_1015 VGND VPWR sky130_fd_sc_hd__tapvpwrvgnd_1
X_07632_ picorv32_core.decoded_imm\[6\] net590 net594 VGND VGND VPWR VPWR _03731_
+ sky130_fd_sc_hd__a21o_1
XFILLER_80_111 VGND VGND VPWR VPWR sky130_fd_sc_hd__fill_1
XTAP_TAPCELL_ROW_62_1204 VGND VPWR sky130_fd_sc_hd__tapvpwrvgnd_1
XFILLER_0_81 VGND VGND VPWR VPWR sky130_fd_sc_hd__decap_3
X_07563_ net624 _03667_ VGND VGND VPWR VPWR _03668_ sky130_fd_sc_hd__nand2_1
X_09302_ net835 _04494_ net830 VGND VGND VPWR VPWR _04496_ sky130_fd_sc_hd__o21a_1
XFILLER_110_27 VGND VGND VPWR VPWR sky130_fd_sc_hd__fill_1
X_07494_ picorv32_core.reg_out\[18\] picorv32_core.reg_next_pc\[18\] net562 VGND VGND
+ VPWR VPWR _03617_ sky130_fd_sc_hd__mux2_1
X_06514_ picorv32_core.count_instr\[17\] picorv32_core.count_instr\[16\] VGND VGND
+ VPWR VPWR _02827_ sky130_fd_sc_hd__and2_1
X_06445_ net428 net1805 net418 VGND VGND VPWR VPWR _00111_ sky130_fd_sc_hd__mux2_1
X_09233_ picorv32_core.cpuregs\[12\]\[3\] picorv32_core.cpuregs\[13\]\[3\] picorv32_core.cpuregs\[14\]\[3\]
+ picorv32_core.cpuregs\[15\]\[3\] net884 net851 VGND VGND VPWR VPWR _04429_ sky130_fd_sc_hd__mux4_1
X_09164_ net656 _04362_ VGND VGND VPWR VPWR _04363_ sky130_fd_sc_hd__nor2_1
XTAP_TAPCELL_ROW_32_762 VGND VPWR sky130_fd_sc_hd__tapvpwrvgnd_1
XTAP_TAPCELL_ROW_32_773 VGND VPWR sky130_fd_sc_hd__tapvpwrvgnd_1
X_06376_ picorv32_core.reg_pc\[26\] _02768_ picorv32_core.reg_pc\[27\] VGND VGND VPWR
+ VPWR _02775_ sky130_fd_sc_hd__a21oi_1
X_08115_ net297 net2165 net414 VGND VGND VPWR VPWR _00408_ sky130_fd_sc_hd__mux2_1
X_05327_ picorv32_core.reg_pc\[9\] picorv32_core.decoded_imm\[9\] VGND VGND VPWR VPWR
+ _01834_ sky130_fd_sc_hd__nor2_1
X_09095_ net298 net1412 net332 VGND VGND VPWR VPWR _01262_ sky130_fd_sc_hd__mux2_1
XFILLER_123_809 VGND VGND VPWR VPWR sky130_fd_sc_hd__decap_8
X_08046_ _04112_ _04113_ net639 VGND VGND VPWR VPWR _04122_ sky130_fd_sc_hd__mux2_1
X_05258_ net24 net820 VGND VGND VPWR VPWR _01770_ sky130_fd_sc_hd__nand2b_1
Xhold930 picorv32_core.cpuregs\[8\]\[11\] VGND VGND VPWR VPWR net2039 sky130_fd_sc_hd__dlygate4sd3_1
Xhold941 picorv32_core.cpuregs\[1\]\[28\] VGND VGND VPWR VPWR net2050 sky130_fd_sc_hd__dlygate4sd3_1
Xhold952 picorv32_core.cpuregs\[9\]\[23\] VGND VGND VPWR VPWR net2061 sky130_fd_sc_hd__dlygate4sd3_1
Xhold963 picorv32_core.cpuregs\[10\]\[29\] VGND VGND VPWR VPWR net2072 sky130_fd_sc_hd__dlygate4sd3_1
X_05189_ _01707_ _01709_ _01710_ _01672_ VGND VGND VPWR VPWR _01711_ sky130_fd_sc_hd__a31o_1
Xhold996 picorv32_core.cpuregs\[16\]\[24\] VGND VGND VPWR VPWR net2105 sky130_fd_sc_hd__dlygate4sd3_1
XFILLER_103_511 VPWR VGND VPWR VGND sky130_ef_sc_hd__decap_12
Xhold974 picorv32_core.cpuregs\[18\]\[18\] VGND VGND VPWR VPWR net2083 sky130_fd_sc_hd__dlygate4sd3_1
XTAP_TAPCELL_ROW_73_1366 VGND VPWR sky130_fd_sc_hd__tapvpwrvgnd_1
Xhold985 picorv32_core.cpuregs\[16\]\[11\] VGND VGND VPWR VPWR net2094 sky130_fd_sc_hd__dlygate4sd3_1
XFILLER_135_57 VPWR VGND VPWR VGND sky130_ef_sc_hd__decap_12
X_09997_ net1889 net235 net314 VGND VGND VPWR VPWR _01474_ sky130_fd_sc_hd__mux2_1
XFILLER_0_137 VGND VGND VPWR VPWR sky130_fd_sc_hd__decap_3
X_08948_ net220 net1950 net356 VGND VGND VPWR VPWR _01121_ sky130_fd_sc_hd__mux2_1
X_08879_ net230 net1702 net364 VGND VGND VPWR VPWR _01054_ sky130_fd_sc_hd__mux2_1
XFILLER_28_66 VGND VGND VPWR VPWR sky130_fd_sc_hd__fill_2
X_10910_ clknet_leaf_94_clk _00761_ VGND VGND VPWR VPWR picorv32_core.mem_rdata_q\[20\]
+ sky130_fd_sc_hd__dfxtp_1
XFILLER_72_645 VGND VGND VPWR VPWR sky130_fd_sc_hd__decap_3
X_10841_ clknet_leaf_51_clk _00692_ VGND VGND VPWR VPWR picorv32_core.cpuregs\[17\]\[18\]
+ sky130_fd_sc_hd__dfxtp_1
XFILLER_72_667 VGND VGND VPWR VPWR sky130_fd_sc_hd__fill_2
XFILLER_44_369 VPWR VGND VPWR VGND sky130_ef_sc_hd__decap_12
XFILLER_71_199 VGND VGND VPWR VPWR sky130_fd_sc_hd__fill_1
X_10772_ clknet_leaf_13_clk _00623_ VGND VGND VPWR VPWR picorv32_core.cpuregs\[14\]\[13\]
+ sky130_fd_sc_hd__dfxtp_1
XFILLER_125_113 VGND VGND VPWR VPWR sky130_fd_sc_hd__fill_1
XTAP_TAPCELL_ROW_10_456 VGND VPWR sky130_fd_sc_hd__tapvpwrvgnd_1
XTAP_TAPCELL_ROW_10_445 VGND VPWR sky130_fd_sc_hd__tapvpwrvgnd_1
XFILLER_125_135 VGND VGND VPWR VPWR sky130_fd_sc_hd__fill_2
XFILLER_4_432 VGND VGND VPWR VPWR sky130_fd_sc_hd__decap_4
XFILLER_4_421 VGND VGND VPWR VPWR sky130_fd_sc_hd__fill_2
X_11324_ clknet_leaf_129_clk _01165_ VGND VGND VPWR VPWR picorv32_core.cpuregs\[29\]\[8\]
+ sky130_fd_sc_hd__dfxtp_1
X_11255_ clknet_leaf_144_clk _01103_ VGND VGND VPWR VPWR picorv32_core.cpuregs\[4\]\[10\]
+ sky130_fd_sc_hd__dfxtp_1
X_10206_ clknet_leaf_32_clk _00125_ VGND VGND VPWR VPWR picorv32_core.cpuregs\[9\]\[22\]
+ sky130_fd_sc_hd__dfxtp_1
X_11186_ clknet_leaf_12_clk _01037_ VGND VGND VPWR VPWR picorv32_core.cpuregs\[6\]\[8\]
+ sky130_fd_sc_hd__dfxtp_1
X_10137_ clknet_leaf_40_clk _00059_ VGND VGND VPWR VPWR picorv32_core.cpuregs\[22\]\[20\]
+ sky130_fd_sc_hd__dfxtp_1
XFILLER_0_671 VGND VGND VPWR VPWR sky130_fd_sc_hd__fill_1
X_10068_ net1732 net214 net307 VGND VGND VPWR VPWR _01543_ sky130_fd_sc_hd__mux2_1
XPHY_EDGE_ROW_13_Right_13 VGND VGND VPWR VPWR sky130_fd_sc_hd__decap_3
XFILLER_63_612 VGND VGND VPWR VPWR sky130_fd_sc_hd__decap_4
XFILLER_90_464 VGND VGND VPWR VPWR sky130_fd_sc_hd__decap_3
XTAP_TAPCELL_ROW_18_567 VGND VPWR sky130_fd_sc_hd__tapvpwrvgnd_1
X_06230_ _02611_ _02651_ _02659_ VGND VGND VPWR VPWR _02660_ sky130_fd_sc_hd__or3_1
XPHY_EDGE_ROW_22_Right_22 VGND VGND VPWR VPWR sky130_fd_sc_hd__decap_3
X_06161_ picorv32_core.mem_rdata_q\[21\] net17 net518 VGND VGND VPWR VPWR _00762_
+ sky130_fd_sc_hd__mux2_1
X_06092_ _02539_ _02540_ _02549_ VGND VGND VPWR VPWR picorv32_core.alu_out\[26\] sky130_fd_sc_hd__or3_1
Xhold215 picorv32_core.cpuregs\[19\]\[16\] VGND VGND VPWR VPWR net1324 sky130_fd_sc_hd__dlygate4sd3_1
Xhold226 picorv32_core.cpuregs\[27\]\[14\] VGND VGND VPWR VPWR net1335 sky130_fd_sc_hd__dlygate4sd3_1
XFILLER_8_793 VPWR VGND VPWR VGND sky130_ef_sc_hd__decap_12
Xhold204 picorv32_core.cpuregs\[30\]\[8\] VGND VGND VPWR VPWR net1313 sky130_fd_sc_hd__dlygate4sd3_1
X_05112_ net984 _01634_ _01635_ VGND VGND VPWR VPWR _01644_ sky130_fd_sc_hd__and3_1
XFILLER_132_628 VGND VGND VPWR VPWR sky130_fd_sc_hd__fill_2
X_09920_ net248 net2021 net322 VGND VGND VPWR VPWR _01404_ sky130_fd_sc_hd__mux2_1
Xhold259 picorv32_core.cpuregs\[28\]\[18\] VGND VGND VPWR VPWR net1368 sky130_fd_sc_hd__dlygate4sd3_1
Xhold248 picorv32_core.cpuregs\[31\]\[15\] VGND VGND VPWR VPWR net1357 sky130_fd_sc_hd__dlygate4sd3_1
Xhold237 picorv32_core.cpuregs\[11\]\[6\] VGND VGND VPWR VPWR net1346 sky130_fd_sc_hd__dlygate4sd3_1
XTAP_TAPCELL_ROW_113_1945 VGND VPWR sky130_fd_sc_hd__tapvpwrvgnd_1
Xfanout706 net708 VGND VGND VPWR VPWR net706 sky130_fd_sc_hd__clkbuf_4
Xfanout728 net729 VGND VGND VPWR VPWR net728 sky130_fd_sc_hd__clkbuf_4
X_09851_ picorv32_core.cpuregs\[12\]\[30\] picorv32_core.cpuregs\[13\]\[30\] picorv32_core.cpuregs\[14\]\[30\]
+ picorv32_core.cpuregs\[15\]\[30\] net901 net872 VGND VGND VPWR VPWR _05020_ sky130_fd_sc_hd__mux4_1
XFILLER_112_341 VGND VGND VPWR VPWR sky130_fd_sc_hd__fill_1
Xfanout717 net718 VGND VGND VPWR VPWR net717 sky130_fd_sc_hd__clkbuf_4
Xfanout739 net741 VGND VGND VPWR VPWR net739 sky130_fd_sc_hd__buf_4
X_09782_ net658 _04953_ VGND VGND VPWR VPWR _04954_ sky130_fd_sc_hd__or2_1
X_06994_ _03202_ _03205_ net587 VGND VGND VPWR VPWR _03206_ sky130_fd_sc_hd__a21oi_1
XFILLER_85_225 VGND VGND VPWR VPWR sky130_fd_sc_hd__fill_2
X_08802_ net269 net2029 net372 VGND VGND VPWR VPWR _00980_ sky130_fd_sc_hd__mux2_1
XTAP_TAPCELL_ROW_55_1096 VGND VPWR sky130_fd_sc_hd__tapvpwrvgnd_1
XPHY_EDGE_ROW_31_Right_31 VGND VGND VPWR VPWR sky130_fd_sc_hd__decap_3
X_05945_ _01608_ _02413_ VGND VGND VPWR VPWR _02414_ sky130_fd_sc_hd__xnor2_1
X_08733_ net1318 net288 net378 VGND VGND VPWR VPWR _00881_ sky130_fd_sc_hd__mux2_1
XFILLER_121_15 VPWR VGND VPWR VGND sky130_ef_sc_hd__decap_12
XFILLER_54_645 VGND VGND VPWR VPWR sky130_fd_sc_hd__decap_3
X_05876_ net803 net959 net567 _02350_ VGND VGND VPWR VPWR _02351_ sky130_fd_sc_hd__a31o_1
XFILLER_53_111 VGND VGND VPWR VPWR sky130_fd_sc_hd__fill_1
X_08664_ net300 net1475 net386 VGND VGND VPWR VPWR _00814_ sky130_fd_sc_hd__mux2_1
XTAP_TAPCELL_ROW_37_843 VGND VPWR sky130_fd_sc_hd__tapvpwrvgnd_1
X_07615_ picorv32_core.cpuregs\[20\]\[6\] picorv32_core.cpuregs\[21\]\[6\] picorv32_core.cpuregs\[22\]\[6\]
+ picorv32_core.cpuregs\[23\]\[6\] net732 net699 VGND VGND VPWR VPWR _03714_ sky130_fd_sc_hd__mux4_1
X_08595_ net290 net2094 net394 VGND VGND VPWR VPWR _00718_ sky130_fd_sc_hd__mux2_1
X_07546_ net931 _02247_ net486 _03647_ _03653_ VGND VGND VPWR VPWR _00357_ sky130_fd_sc_hd__a41o_1
X_07477_ net798 _03605_ net533 VGND VGND VPWR VPWR _03606_ sky130_fd_sc_hd__mux2_1
XFILLER_10_726 VPWR VGND VPWR VGND sky130_ef_sc_hd__decap_12
X_09216_ net836 _04412_ VGND VGND VPWR VPWR _04413_ sky130_fd_sc_hd__nand2_1
XPHY_EDGE_ROW_40_Right_40 VGND VGND VPWR VPWR sky130_fd_sc_hd__decap_3
X_06428_ net228 net1903 net425 VGND VGND VPWR VPWR _00096_ sky130_fd_sc_hd__mux2_1
X_09147_ net2157 net219 net331 VGND VGND VPWR VPWR _01313_ sky130_fd_sc_hd__mux2_1
X_06359_ picorv32_core.reg_out\[24\] picorv32_core.alu_out_q\[24\] net953 VGND VGND
+ VPWR VPWR _02761_ sky130_fd_sc_hd__mux2_1
X_09078_ net1583 net230 net339 VGND VGND VPWR VPWR _01246_ sky130_fd_sc_hd__mux2_1
XFILLER_107_146 VGND VGND VPWR VPWR sky130_fd_sc_hd__fill_1
XPHY_EDGE_ROW_15_Left_157 VGND VGND VPWR VPWR sky130_fd_sc_hd__decap_3
X_08029_ net684 _04105_ net626 VGND VGND VPWR VPWR _04106_ sky130_fd_sc_hd__a21o_1
Xhold771 picorv32_core.cpuregs\[4\]\[18\] VGND VGND VPWR VPWR net1880 sky130_fd_sc_hd__dlygate4sd3_1
Xhold760 picorv32_core.cpuregs\[9\]\[16\] VGND VGND VPWR VPWR net1869 sky130_fd_sc_hd__dlygate4sd3_1
Xhold782 picorv32_core.cpuregs\[10\]\[13\] VGND VGND VPWR VPWR net1891 sky130_fd_sc_hd__dlygate4sd3_1
Xhold793 picorv32_core.cpuregs\[26\]\[27\] VGND VGND VPWR VPWR net1902 sky130_fd_sc_hd__dlygate4sd3_1
X_11040_ clknet_leaf_32_clk _00891_ VGND VGND VPWR VPWR picorv32_core.cpuregs\[11\]\[22\]
+ sky130_fd_sc_hd__dfxtp_1
XFILLER_49_406 VGND VGND VPWR VPWR sky130_fd_sc_hd__decap_4
XFILLER_39_98 VGND VGND VPWR VPWR sky130_fd_sc_hd__fill_2
XTAP_TAPCELL_ROW_86_1546 VGND VPWR sky130_fd_sc_hd__tapvpwrvgnd_1
XPHY_EDGE_ROW_24_Left_166 VGND VGND VPWR VPWR sky130_fd_sc_hd__decap_3
XTAP_TAPCELL_ROW_86_1557 VGND VPWR sky130_fd_sc_hd__tapvpwrvgnd_1
XFILLER_60_637 VGND VGND VPWR VPWR sky130_fd_sc_hd__decap_6
X_10824_ clknet_leaf_113_clk _00675_ VGND VGND VPWR VPWR picorv32_core.cpuregs\[17\]\[1\]
+ sky130_fd_sc_hd__dfxtp_1
XTAP_TAPCELL_ROW_15_526 VGND VPWR sky130_fd_sc_hd__tapvpwrvgnd_1
XFILLER_111_70 VGND VGND VPWR VPWR sky130_fd_sc_hd__fill_2
XFILLER_71_30 VGND VGND VPWR VPWR sky130_fd_sc_hd__decap_8
XFILLER_60_659 VGND VGND VPWR VPWR sky130_fd_sc_hd__decap_3
X_10755_ clknet_leaf_122_clk _00606_ VGND VGND VPWR VPWR picorv32_core.decoded_imm\[4\]
+ sky130_fd_sc_hd__dfxtp_2
XTAP_TAPCELL_ROW_117_2001 VGND VPWR sky130_fd_sc_hd__tapvpwrvgnd_1
X_10686_ clknet_leaf_92_clk net1167 VGND VGND VPWR VPWR picorv32_core.is_sltiu_bltu_sltu
+ sky130_fd_sc_hd__dfxtp_1
XFILLER_139_783 VGND VGND VPWR VPWR sky130_fd_sc_hd__fill_1
XPHY_EDGE_ROW_33_Left_175 VGND VGND VPWR VPWR sky130_fd_sc_hd__decap_3
XFILLER_5_741 VPWR VGND VPWR VGND sky130_ef_sc_hd__decap_12
X_11307_ clknet_leaf_64_clk _01155_ VGND VGND VPWR VPWR picorv32_core.cpuregs\[3\]\[30\]
+ sky130_fd_sc_hd__dfxtp_1
XFILLER_5_785 VPWR VGND VPWR VGND sky130_ef_sc_hd__decap_12
X_11238_ clknet_leaf_37_clk _01089_ VGND VGND VPWR VPWR picorv32_core.cpuregs\[5\]\[28\]
+ sky130_fd_sc_hd__dfxtp_1
XFILLER_106_190 VGND VGND VPWR VPWR sky130_fd_sc_hd__fill_2
X_11169_ clknet_leaf_43_clk _01020_ VGND VGND VPWR VPWR picorv32_core.cpuregs\[7\]\[23\]
+ sky130_fd_sc_hd__dfxtp_1
XFILLER_67_225 VGND VGND VPWR VPWR sky130_fd_sc_hd__fill_2
XTAP_TAPCELL_ROW_128_2163 VGND VPWR sky130_fd_sc_hd__tapvpwrvgnd_1
XFILLER_82_206 VGND VGND VPWR VPWR sky130_fd_sc_hd__fill_2
XPHY_EDGE_ROW_42_Left_184 VGND VGND VPWR VPWR sky130_fd_sc_hd__decap_3
X_05730_ net811 net964 VGND VGND VPWR VPWR _02214_ sky130_fd_sc_hd__and2b_1
XTAP_TAPCELL_ROW_141_2363 VGND VPWR sky130_fd_sc_hd__tapvpwrvgnd_1
XTAP_TAPCELL_ROW_141_2352 VGND VPWR sky130_fd_sc_hd__tapvpwrvgnd_1
X_05661_ net785 net182 VGND VGND VPWR VPWR _02145_ sky130_fd_sc_hd__or2_1
X_07400_ _03397_ _03538_ _03539_ VGND VGND VPWR VPWR _03540_ sky130_fd_sc_hd__and3_1
X_08380_ net193 net581 net451 _04245_ VGND VGND VPWR VPWR _04265_ sky130_fd_sc_hd__a211o_1
XTAP_TAPCELL_ROW_34_802 VGND VPWR sky130_fd_sc_hd__tapvpwrvgnd_1
X_05592_ picorv32_core.reg_pc\[28\] picorv32_core.decoded_imm\[28\] VGND VGND VPWR
+ VPWR _02080_ sky130_fd_sc_hd__or2_1
X_07331_ net814 picorv32_core.decoded_imm\[4\] _03453_ _03454_ VGND VGND VPWR VPWR
+ _03471_ sky130_fd_sc_hd__a31o_1
XFILLER_137_709 VPWR VGND VPWR VGND sky130_ef_sc_hd__decap_12
X_07262_ net766 picorv32_core.decoded_imm\[28\] VGND VGND VPWR VPWR _03402_ sky130_fd_sc_hd__xnor2_1
XPHY_EDGE_ROW_51_Left_193 VGND VGND VPWR VPWR sky130_fd_sc_hd__decap_3
X_07193_ picorv32_core.count_cycle\[43\] picorv32_core.count_cycle\[44\] _03349_ VGND
+ VGND VPWR VPWR _03353_ sky130_fd_sc_hd__and3_1
X_09001_ net274 net1546 net345 VGND VGND VPWR VPWR _01171_ sky130_fd_sc_hd__mux2_1
X_06213_ net2284 _01687_ _01693_ VGND VGND VPWR VPWR _02643_ sky130_fd_sc_hd__a21oi_1
X_06144_ _02165_ _02596_ VGND VGND VPWR VPWR _02597_ sky130_fd_sc_hd__xor2_1
XFILLER_105_617 VGND VGND VPWR VPWR sky130_fd_sc_hd__fill_2
XTAP_TAPCELL_ROW_57_1136 VGND VPWR sky130_fd_sc_hd__tapvpwrvgnd_1
XTAP_TAPCELL_ROW_57_1125 VGND VPWR sky130_fd_sc_hd__tapvpwrvgnd_1
XFILLER_116_15 VPWR VGND VPWR VGND sky130_ef_sc_hd__decap_12
X_06075_ _02519_ _02522_ _02532_ _02254_ VGND VGND VPWR VPWR _02534_ sky130_fd_sc_hd__a31o_1
XFILLER_104_149 VGND VGND VPWR VPWR sky130_fd_sc_hd__decap_4
XFILLER_98_350 VGND VGND VPWR VPWR sky130_fd_sc_hd__fill_1
XTAP_TAPCELL_ROW_70_1314 VGND VPWR sky130_fd_sc_hd__tapvpwrvgnd_1
X_09903_ _02677_ net1590 net321 VGND VGND VPWR VPWR _01387_ sky130_fd_sc_hd__mux2_1
Xfanout503 net505 VGND VGND VPWR VPWR net503 sky130_fd_sc_hd__clkbuf_2
Xfanout514 net515 VGND VGND VPWR VPWR net514 sky130_fd_sc_hd__buf_2
X_09834_ _05000_ _05001_ net661 VGND VGND VPWR VPWR _05004_ sky130_fd_sc_hd__mux2_1
XFILLER_116_59 VGND VGND VPWR VPWR sky130_fd_sc_hd__fill_1
XFILLER_86_523 VGND VGND VPWR VPWR sky130_fd_sc_hd__fill_2
XTAP_TAPCELL_ROW_70_1325 VGND VPWR sky130_fd_sc_hd__tapvpwrvgnd_1
Xfanout547 net548 VGND VGND VPWR VPWR net547 sky130_fd_sc_hd__clkbuf_2
Xfanout536 net539 VGND VGND VPWR VPWR net536 sky130_fd_sc_hd__clkbuf_4
XFILLER_59_737 VGND VGND VPWR VPWR sky130_fd_sc_hd__fill_2
Xfanout525 _04178_ VGND VGND VPWR VPWR net525 sky130_fd_sc_hd__buf_2
Xfanout558 net562 VGND VGND VPWR VPWR net558 sky130_fd_sc_hd__buf_4
Xfanout569 _02252_ VGND VGND VPWR VPWR net569 sky130_fd_sc_hd__buf_2
X_09765_ picorv32_core.cpuregs\[24\]\[26\] picorv32_core.cpuregs\[25\]\[26\] picorv32_core.cpuregs\[26\]\[26\]
+ picorv32_core.cpuregs\[27\]\[26\] net902 net868 VGND VGND VPWR VPWR _04938_ sky130_fd_sc_hd__mux4_1
X_06977_ net932 _02935_ VGND VGND VPWR VPWR _03190_ sky130_fd_sc_hd__or2_1
XFILLER_86_589 VGND VGND VPWR VPWR sky130_fd_sc_hd__fill_2
X_09696_ picorv32_core.cpuregs\[20\]\[23\] picorv32_core.cpuregs\[21\]\[23\] picorv32_core.cpuregs\[22\]\[23\]
+ picorv32_core.cpuregs\[23\]\[23\] net899 net865 VGND VGND VPWR VPWR _04872_ sky130_fd_sc_hd__mux4_1
X_08716_ net1314 net217 net385 VGND VGND VPWR VPWR _00865_ sky130_fd_sc_hd__mux2_1
X_05928_ net506 _02395_ _02396_ _02398_ VGND VGND VPWR VPWR picorv32_core.alu_out\[13\]
+ sky130_fd_sc_hd__a31o_1
X_08647_ net1458 net229 net393 VGND VGND VPWR VPWR _00798_ sky130_fd_sc_hd__mux2_1
XFILLER_92_29 VGND VGND VPWR VPWR sky130_fd_sc_hd__fill_1
XFILLER_54_431 VGND VGND VPWR VPWR sky130_fd_sc_hd__decap_6
X_05859_ net805 _02333_ VGND VGND VPWR VPWR _02335_ sky130_fd_sc_hd__or2_1
XTAP_TAPCELL_ROW_68_1298 VGND VPWR sky130_fd_sc_hd__tapvpwrvgnd_1
XTAP_TAPCELL_ROW_68_1287 VGND VPWR sky130_fd_sc_hd__tapvpwrvgnd_1
XFILLER_54_486 VGND VGND VPWR VPWR sky130_fd_sc_hd__fill_2
XFILLER_42_637 VGND VGND VPWR VPWR sky130_fd_sc_hd__decap_4
X_08578_ net213 net1815 net401 VGND VGND VPWR VPWR _00703_ sky130_fd_sc_hd__mux2_1
X_07529_ net1723 _03640_ net463 VGND VGND VPWR VPWR _00353_ sky130_fd_sc_hd__mux2_1
XTAP_TAPCELL_ROW_81_1476 VGND VPWR sky130_fd_sc_hd__tapvpwrvgnd_1
XFILLER_41_169 VGND VGND VPWR VPWR sky130_fd_sc_hd__decap_4
X_10540_ clknet_leaf_61_clk picorv32_core.alu_out\[28\] VGND VGND VPWR VPWR picorv32_core.alu_out_q\[28\]
+ sky130_fd_sc_hd__dfxtp_1
X_10471_ clknet_leaf_105_clk _00358_ VGND VGND VPWR VPWR picorv32_core.mem_do_rdata
+ sky130_fd_sc_hd__dfxtp_2
XFILLER_108_433 VGND VGND VPWR VPWR sky130_fd_sc_hd__fill_1
XFILLER_10_589 VGND VGND VPWR VPWR sky130_fd_sc_hd__fill_1
XFILLER_6_549 VGND VGND VPWR VPWR sky130_fd_sc_hd__decap_3
XTAP_TAPCELL_ROW_20_595 VGND VPWR sky130_fd_sc_hd__tapvpwrvgnd_1
Xhold590 picorv32_core.cpuregs\[5\]\[21\] VGND VGND VPWR VPWR net1699 sky130_fd_sc_hd__dlygate4sd3_1
XFILLER_2_755 VGND VGND VPWR VPWR sky130_fd_sc_hd__fill_1
XFILLER_77_501 VGND VGND VPWR VPWR sky130_fd_sc_hd__decap_3
X_11023_ clknet_leaf_138_clk _00874_ VGND VGND VPWR VPWR picorv32_core.cpuregs\[11\]\[5\]
+ sky130_fd_sc_hd__dfxtp_1
XFILLER_49_225 VGND VGND VPWR VPWR sky130_fd_sc_hd__decap_4
XFILLER_92_504 VGND VGND VPWR VPWR sky130_fd_sc_hd__decap_4
XFILLER_65_729 VGND VGND VPWR VPWR sky130_fd_sc_hd__fill_1
XFILLER_37_409 VPWR VGND VPWR VGND sky130_ef_sc_hd__decap_12
XFILLER_66_74 VGND VGND VPWR VPWR sky130_fd_sc_hd__fill_1
XFILLER_17_111 VGND VGND VPWR VPWR sky130_fd_sc_hd__fill_1
XFILLER_18_667 VGND VGND VPWR VPWR sky130_fd_sc_hd__decap_3
XTAP_TAPCELL_ROW_123_2082 VGND VPWR sky130_fd_sc_hd__tapvpwrvgnd_1
XFILLER_72_250 VGND VGND VPWR VPWR sky130_fd_sc_hd__fill_2
XFILLER_33_615 VGND VGND VPWR VPWR sky130_fd_sc_hd__fill_1
XFILLER_33_626 VGND VGND VPWR VPWR sky130_fd_sc_hd__fill_2
XTAP_TAPCELL_ROW_123_2093 VGND VPWR sky130_fd_sc_hd__tapvpwrvgnd_1
X_11856_ net60 VGND VGND VPWR VPWR net92 sky130_fd_sc_hd__clkbuf_1
XFILLER_33_659 VGND VGND VPWR VPWR sky130_fd_sc_hd__fill_1
X_10807_ clknet_leaf_23_clk _00658_ VGND VGND VPWR VPWR picorv32_core.cpuregs\[15\]\[16\]
+ sky130_fd_sc_hd__dfxtp_1
XFILLER_60_467 VGND VGND VPWR VPWR sky130_fd_sc_hd__fill_1
XFILLER_20_309 VGND VGND VPWR VPWR sky130_fd_sc_hd__fill_1
X_10738_ clknet_leaf_89_clk _00589_ VGND VGND VPWR VPWR picorv32_core.decoded_imm\[21\]
+ sky130_fd_sc_hd__dfxtp_2
XTAP_TAPCELL_ROW_99_1737 VGND VPWR sky130_fd_sc_hd__tapvpwrvgnd_1
XPHY_EDGE_ROW_124_Right_124 VGND VGND VPWR VPWR sky130_fd_sc_hd__decap_3
X_10669_ clknet_leaf_83_clk _00523_ VGND VGND VPWR VPWR picorv32_core.decoded_imm_j\[15\]
+ sky130_fd_sc_hd__dfxtp_1
Xoutput106 net106 VGND VGND VPWR VPWR mem_axi_wdata[11] sky130_fd_sc_hd__buf_2
Xoutput128 net128 VGND VGND VPWR VPWR mem_axi_wdata[31] sky130_fd_sc_hd__buf_2
XFILLER_127_797 VPWR VGND VPWR VGND sky130_ef_sc_hd__decap_12
Xoutput117 net117 VGND VGND VPWR VPWR mem_axi_wdata[21] sky130_fd_sc_hd__buf_2
Xoutput139 net139 VGND VGND VPWR VPWR mem_axi_wstrb[3] sky130_fd_sc_hd__buf_2
XFILLER_141_233 VGND VGND VPWR VPWR sky130_fd_sc_hd__decap_3
XTAP_TAPCELL_ROW_110_1904 VGND VPWR sky130_fd_sc_hd__tapvpwrvgnd_1
XFILLER_99_169 VGND VGND VPWR VPWR sky130_fd_sc_hd__decap_4
XFILLER_99_147 VGND VGND VPWR VPWR sky130_fd_sc_hd__decap_4
X_06900_ picorv32_core.decoded_imm_j\[17\] _02929_ VGND VGND VPWR VPWR _03119_ sky130_fd_sc_hd__or2_1
X_07880_ picorv32_core.cpuregs\[12\]\[20\] picorv32_core.cpuregs\[13\]\[20\] picorv32_core.cpuregs\[14\]\[20\]
+ picorv32_core.cpuregs\[15\]\[20\] net750 net717 VGND VGND VPWR VPWR _03965_ sky130_fd_sc_hd__mux4_1
XFILLER_68_545 VGND VGND VPWR VPWR sky130_fd_sc_hd__decap_6
XTAP_TAPCELL_ROW_52_1066 VGND VPWR sky130_fd_sc_hd__tapvpwrvgnd_1
XTAP_TAPCELL_ROW_52_1055 VGND VPWR sky130_fd_sc_hd__tapvpwrvgnd_1
XFILLER_68_589 VGND VGND VPWR VPWR sky130_fd_sc_hd__decap_6
X_06831_ net588 _03054_ _03055_ VGND VGND VPWR VPWR _03056_ sky130_fd_sc_hd__a21oi_1
XFILLER_56_718 VGND VGND VPWR VPWR sky130_fd_sc_hd__decap_4
X_09550_ net832 _04729_ _04732_ net480 VGND VGND VPWR VPWR _04733_ sky130_fd_sc_hd__o211a_1
X_06762_ _02988_ _02990_ _02991_ VGND VGND VPWR VPWR _02992_ sky130_fd_sc_hd__a21oi_1
XTAP_TAPCELL_ROW_108_1866 VGND VPWR sky130_fd_sc_hd__tapvpwrvgnd_1
X_08501_ net2166 net244 net408 VGND VGND VPWR VPWR _00631_ sky130_fd_sc_hd__mux2_1
X_09481_ _04661_ _04662_ _04663_ _04664_ net654 net826 VGND VGND VPWR VPWR _04667_
+ sky130_fd_sc_hd__mux4_1
X_05713_ net801 net958 VGND VGND VPWR VPWR _02197_ sky130_fd_sc_hd__or2_1
XTAP_TAPCELL_ROW_108_1877 VGND VPWR sky130_fd_sc_hd__tapvpwrvgnd_1
X_06693_ _02761_ picorv32_core.reg_next_pc\[24\] net561 VGND VGND VPWR VPWR _02936_
+ sky130_fd_sc_hd__mux2_2
XFILLER_91_570 VPWR VGND VPWR VGND sky130_ef_sc_hd__decap_12
X_08432_ picorv32_core.decoded_imm\[21\] net528 net442 _04296_ VGND VGND VPWR VPWR
+ _00589_ sky130_fd_sc_hd__o22a_1
XFILLER_64_773 VGND VGND VPWR VPWR sky130_fd_sc_hd__fill_2
XTAP_TAPCELL_ROW_47_982 VGND VPWR sky130_fd_sc_hd__tapvpwrvgnd_1
XTAP_TAPCELL_ROW_47_993 VGND VPWR sky130_fd_sc_hd__tapvpwrvgnd_1
XFILLER_23_147 VGND VGND VPWR VPWR sky130_fd_sc_hd__decap_4
X_05644_ _02125_ _02126_ _02127_ VGND VGND VPWR VPWR _02128_ sky130_fd_sc_hd__and3_1
X_05575_ picorv32_core.reg_pc\[27\] picorv32_core.decoded_imm\[27\] VGND VGND VPWR
+ VPWR _02064_ sky130_fd_sc_hd__nor2_1
X_08363_ net1152 _04256_ net455 VGND VGND VPWR VPWR _00560_ sky130_fd_sc_hd__mux2_1
XFILLER_23_169 VGND VGND VPWR VPWR sky130_fd_sc_hd__fill_1
X_08294_ picorv32_core.mem_rdata_q\[7\] net33 net519 VGND VGND VPWR VPWR _00748_ sky130_fd_sc_hd__mux2_1
X_07314_ net812 picorv32_core.decoded_imm\[5\] VGND VGND VPWR VPWR _03454_ sky130_fd_sc_hd__and2_1
X_07245_ _03385_ _03384_ VGND VGND VPWR VPWR _00324_ sky130_fd_sc_hd__and2b_1
X_07176_ picorv32_core.count_cycle\[37\] _03339_ picorv32_core.count_cycle\[38\] VGND
+ VGND VPWR VPWR _03342_ sky130_fd_sc_hd__a21o_1
X_06127_ _02578_ _02580_ VGND VGND VPWR VPWR _02582_ sky130_fd_sc_hd__nor2_1
XFILLER_11_69 VPWR VGND VPWR VGND sky130_ef_sc_hd__decap_12
XFILLER_127_69 VPWR VGND VPWR VGND sky130_ef_sc_hd__decap_12
X_06058_ net189 _02517_ VGND VGND VPWR VPWR _02518_ sky130_fd_sc_hd__xor2_1
Xfanout311 _05041_ VGND VGND VPWR VPWR net311 sky130_fd_sc_hd__buf_4
Xfanout322 net323 VGND VGND VPWR VPWR net322 sky130_fd_sc_hd__clkbuf_8
Xfanout300 _02703_ VGND VGND VPWR VPWR net300 sky130_fd_sc_hd__clkbuf_2
XFILLER_132_299 VGND VGND VPWR VPWR sky130_fd_sc_hd__fill_1
XFILLER_101_631 VGND VGND VPWR VPWR sky130_fd_sc_hd__decap_6
Xfanout355 net356 VGND VGND VPWR VPWR net355 sky130_fd_sc_hd__clkbuf_8
XFILLER_59_534 VGND VGND VPWR VPWR sky130_fd_sc_hd__fill_2
Xfanout366 net369 VGND VGND VPWR VPWR net366 sky130_fd_sc_hd__clkbuf_8
Xfanout333 _04350_ VGND VGND VPWR VPWR net333 sky130_fd_sc_hd__buf_2
Xfanout344 net345 VGND VGND VPWR VPWR net344 sky130_fd_sc_hd__buf_4
X_09817_ net284 _04974_ _04987_ _04966_ VGND VGND VPWR VPWR _01347_ sky130_fd_sc_hd__a31o_1
XFILLER_100_141 VGND VGND VPWR VPWR sky130_fd_sc_hd__fill_2
Xfanout388 net389 VGND VGND VPWR VPWR net388 sky130_fd_sc_hd__buf_4
XFILLER_59_589 VGND VGND VPWR VPWR sky130_fd_sc_hd__decap_3
Xfanout399 _04328_ VGND VGND VPWR VPWR net399 sky130_fd_sc_hd__clkbuf_4
Xfanout377 _04338_ VGND VGND VPWR VPWR net377 sky130_fd_sc_hd__buf_4
XFILLER_47_729 VGND VGND VPWR VPWR sky130_fd_sc_hd__decap_3
X_09748_ net833 _04919_ _04921_ net481 VGND VGND VPWR VPWR _04922_ sky130_fd_sc_hd__o211a_1
XFILLER_86_386 VGND VGND VPWR VPWR sky130_fd_sc_hd__decap_8
X_11710_ clknet_leaf_41_clk _01541_ VGND VGND VPWR VPWR picorv32_core.cpuregs\[27\]\[27\]
+ sky130_fd_sc_hd__dfxtp_1
X_09679_ picorv32_core.cpuregs\[12\]\[22\] picorv32_core.cpuregs\[13\]\[22\] picorv32_core.cpuregs\[14\]\[22\]
+ picorv32_core.cpuregs\[15\]\[22\] net890 net856 VGND VGND VPWR VPWR _04856_ sky130_fd_sc_hd__mux4_1
XTAP_TAPCELL_ROW_83_1505 VGND VPWR sky130_fd_sc_hd__tapvpwrvgnd_1
XFILLER_42_445 VGND VGND VPWR VPWR sky130_fd_sc_hd__fill_1
X_11641_ clknet_leaf_21_clk _01472_ VGND VGND VPWR VPWR picorv32_core.cpuregs\[28\]\[22\]
+ sky130_fd_sc_hd__dfxtp_1
XFILLER_70_765 VGND VGND VPWR VPWR sky130_fd_sc_hd__fill_2
XTAP_TAPCELL_ROW_25_665 VGND VPWR sky130_fd_sc_hd__tapvpwrvgnd_1
X_11572_ clknet_leaf_29_clk _01403_ VGND VGND VPWR VPWR picorv32_core.cpuregs\[2\]\[19\]
+ sky130_fd_sc_hd__dfxtp_1
XFILLER_11_821 VPWR VGND VPWR VGND sky130_ef_sc_hd__decap_12
X_10523_ clknet_leaf_126_clk picorv32_core.alu_out\[11\] VGND VGND VPWR VPWR picorv32_core.alu_out_q\[11\]
+ sky130_fd_sc_hd__dfxtp_1
Xinput19 mem_axi_rdata[23] VGND VGND VPWR VPWR net19 sky130_fd_sc_hd__buf_2
XFILLER_124_701 VGND VGND VPWR VPWR sky130_fd_sc_hd__fill_1
X_10454_ clknet_leaf_78_clk _00341_ VGND VGND VPWR VPWR net46 sky130_fd_sc_hd__dfxtp_1
XFILLER_109_797 VPWR VGND VPWR VGND sky130_ef_sc_hd__decap_12
X_10385_ clknet_leaf_100_clk _00304_ VGND VGND VPWR VPWR picorv32_core.count_cycle\[43\]
+ sky130_fd_sc_hd__dfxtp_1
XTAP_TAPCELL_ROW_94_1667 VGND VPWR sky130_fd_sc_hd__tapvpwrvgnd_1
XFILLER_2_530 VGND VGND VPWR VPWR sky130_fd_sc_hd__fill_2
XFILLER_111_428 VGND VGND VPWR VPWR sky130_fd_sc_hd__decap_8
XFILLER_96_106 VGND VGND VPWR VPWR sky130_fd_sc_hd__fill_1
XFILLER_2_574 VGND VGND VPWR VPWR sky130_fd_sc_hd__decap_4
X_11006_ clknet_leaf_21_clk _00857_ VGND VGND VPWR VPWR picorv32_core.cpuregs\[12\]\[20\]
+ sky130_fd_sc_hd__dfxtp_1
XTAP_TAPCELL_ROW_125_2122 VGND VPWR sky130_fd_sc_hd__tapvpwrvgnd_1
XTAP_TAPCELL_ROW_125_2111 VGND VPWR sky130_fd_sc_hd__tapvpwrvgnd_1
XFILLER_65_537 VGND VGND VPWR VPWR sky130_fd_sc_hd__decap_4
XFILLER_37_239 VGND VGND VPWR VPWR sky130_fd_sc_hd__decap_4
XFILLER_18_453 VGND VGND VPWR VPWR sky130_fd_sc_hd__decap_3
XFILLER_92_378 VGND VGND VPWR VPWR sky130_fd_sc_hd__decap_4
XTAP_TAPCELL_ROW_44_941 VGND VPWR sky130_fd_sc_hd__tapvpwrvgnd_1
X_11839_ net42 VGND VGND VPWR VPWR net74 sky130_fd_sc_hd__clkbuf_1
XFILLER_60_253 VGND VGND VPWR VPWR sky130_fd_sc_hd__decap_3
XFILLER_33_456 VGND VGND VPWR VPWR sky130_fd_sc_hd__fill_1
XTAP_TAPCELL_ROW_103_1796 VGND VPWR sky130_fd_sc_hd__tapvpwrvgnd_1
XFILLER_60_297 VGND VGND VPWR VPWR sky130_fd_sc_hd__decap_3
X_05360_ net6 _01818_ VGND VGND VPWR VPWR _01865_ sky130_fd_sc_hd__or2_1
XFILLER_14_670 VGND VGND VPWR VPWR sky130_fd_sc_hd__decap_3
X_05291_ picorv32_core.count_instr\[6\] net939 net602 _01800_ VGND VGND VPWR VPWR
+ _01801_ sky130_fd_sc_hd__a211o_1
XTAP_TAPCELL_ROW_136_2284 VGND VPWR sky130_fd_sc_hd__tapvpwrvgnd_1
XTAP_TAPCELL_ROW_136_2273 VGND VPWR sky130_fd_sc_hd__tapvpwrvgnd_1
XFILLER_127_561 VGND VGND VPWR VPWR sky130_fd_sc_hd__decap_4
X_07030_ net678 _03235_ _03236_ VGND VGND VPWR VPWR _03239_ sky130_fd_sc_hd__nand3_1
XFILLER_9_195 VGND VGND VPWR VPWR sky130_fd_sc_hd__decap_6
X_08981_ net1245 net217 net351 VGND VGND VPWR VPWR _01153_ sky130_fd_sc_hd__mux2_1
XFILLER_130_737 VPWR VGND VPWR VGND sky130_ef_sc_hd__decap_12
XFILLER_88_629 VPWR VGND VPWR VGND sky130_ef_sc_hd__decap_12
X_07932_ picorv32_core.cpuregs\[28\]\[23\] picorv32_core.cpuregs\[29\]\[23\] picorv32_core.cpuregs\[30\]\[23\]
+ picorv32_core.cpuregs\[31\]\[23\] net756 net723 VGND VGND VPWR VPWR _04014_ sky130_fd_sc_hd__mux4_1
X_07863_ picorv32_core.cpuregs\[8\]\[19\] picorv32_core.cpuregs\[9\]\[19\] picorv32_core.cpuregs\[10\]\[19\]
+ picorv32_core.cpuregs\[11\]\[19\] net749 net716 VGND VGND VPWR VPWR _03949_ sky130_fd_sc_hd__mux4_1
XFILLER_3_81 VPWR VGND VPWR VGND sky130_ef_sc_hd__decap_12
XFILLER_29_729 VGND VGND VPWR VPWR sky130_fd_sc_hd__fill_2
XFILLER_96_695 VGND VGND VPWR VPWR sky130_fd_sc_hd__fill_1
X_09602_ _03504_ _03506_ _03507_ _04758_ VGND VGND VPWR VPWR _04782_ sky130_fd_sc_hd__o211ai_1
X_06814_ _02921_ _02922_ _03012_ VGND VGND VPWR VPWR _03040_ sky130_fd_sc_hd__and3_1
XTAP_TAPCELL_ROW_3_349 VGND VPWR sky130_fd_sc_hd__tapvpwrvgnd_1
XFILLER_83_367 VGND VGND VPWR VPWR sky130_fd_sc_hd__fill_1
XFILLER_83_334 VGND VGND VPWR VPWR sky130_fd_sc_hd__fill_2
X_09533_ _03498_ _04715_ VGND VGND VPWR VPWR _04716_ sky130_fd_sc_hd__nor2_1
X_07794_ _03880_ _03881_ _03883_ _03882_ net625 net618 VGND VGND VPWR VPWR _03884_
+ sky130_fd_sc_hd__mux4_1
X_06745_ picorv32_core.decoded_imm_j\[5\] _02917_ VGND VGND VPWR VPWR _02976_ sky130_fd_sc_hd__and2_1
X_06676_ picorv32_core.reg_pc\[15\] net554 _02927_ net517 VGND VGND VPWR VPWR _00213_
+ sky130_fd_sc_hd__a22o_1
XTAP_TAPCELL_ROW_65_1246 VGND VPWR sky130_fd_sc_hd__tapvpwrvgnd_1
X_09464_ net830 _04647_ _04650_ net478 VGND VGND VPWR VPWR _04651_ sky130_fd_sc_hd__o211a_1
X_05627_ _02107_ _02111_ _02112_ VGND VGND VPWR VPWR _01570_ sky130_fd_sc_hd__or3_1
X_08415_ picorv32_core.mem_rdata_q\[29\] net614 VGND VGND VPWR VPWR _04288_ sky130_fd_sc_hd__and2_1
XFILLER_12_618 VGND VGND VPWR VPWR sky130_fd_sc_hd__decap_3
X_09395_ _04581_ _04582_ net652 VGND VGND VPWR VPWR _04585_ sky130_fd_sc_hd__mux2_1
X_08346_ net1162 net454 _04246_ VGND VGND VPWR VPWR _00553_ sky130_fd_sc_hd__o21a_1
XFILLER_52_798 VGND VGND VPWR VPWR sky130_fd_sc_hd__fill_1
XTAP_TAPCELL_ROW_22_624 VGND VPWR sky130_fd_sc_hd__tapvpwrvgnd_1
X_05558_ net945 picorv32_core.count_cycle\[57\] net603 _02048_ VGND VGND VPWR VPWR
+ _02049_ sky130_fd_sc_hd__a211o_1
X_05489_ _01980_ _01984_ VGND VGND VPWR VPWR _01985_ sky130_fd_sc_hd__nand2_1
X_08277_ net1611 net271 net411 VGND VGND VPWR VPWR _00501_ sky130_fd_sc_hd__mux2_1
XFILLER_106_701 VGND VGND VPWR VPWR sky130_fd_sc_hd__decap_3
X_07228_ picorv32_core.count_cycle\[55\] picorv32_core.count_cycle\[56\] picorv32_core.count_cycle\[57\]
+ _03370_ VGND VGND VPWR VPWR _03375_ sky130_fd_sc_hd__and4_1
X_07159_ picorv32_core.count_cycle\[31\] _03329_ _03331_ VGND VGND VPWR VPWR _00292_
+ sky130_fd_sc_hd__o21a_1
X_10170_ clknet_leaf_51_clk _00089_ VGND VGND VPWR VPWR picorv32_core.cpuregs\[21\]\[18\]
+ sky130_fd_sc_hd__dfxtp_1
XFILLER_87_673 VGND VGND VPWR VPWR sky130_fd_sc_hd__decap_4
XFILLER_86_150 VGND VGND VPWR VPWR sky130_fd_sc_hd__decap_3
XFILLER_75_835 VGND VGND VPWR VPWR sky130_fd_sc_hd__fill_2
XFILLER_47_559 VGND VGND VPWR VPWR sky130_fd_sc_hd__fill_1
XFILLER_27_261 VGND VGND VPWR VPWR sky130_fd_sc_hd__decap_3
XFILLER_15_445 VGND VGND VPWR VPWR sky130_fd_sc_hd__decap_3
XTAP_TAPCELL_ROW_120_2052 VGND VPWR sky130_fd_sc_hd__tapvpwrvgnd_1
XTAP_TAPCELL_ROW_120_2041 VGND VPWR sky130_fd_sc_hd__tapvpwrvgnd_1
XPHY_EDGE_ROW_69_Right_69 VGND VGND VPWR VPWR sky130_fd_sc_hd__decap_3
XTAP_TAPCELL_ROW_41_900 VGND VPWR sky130_fd_sc_hd__tapvpwrvgnd_1
XFILLER_42_242 VGND VGND VPWR VPWR sky130_fd_sc_hd__fill_2
XFILLER_8_15 VPWR VGND VPWR VGND sky130_ef_sc_hd__decap_12
X_11624_ clknet_leaf_139_clk _01455_ VGND VGND VPWR VPWR picorv32_core.cpuregs\[28\]\[5\]
+ sky130_fd_sc_hd__dfxtp_1
XPHY_EDGE_ROW_7_Left_149 VGND VGND VPWR VPWR sky130_fd_sc_hd__decap_3
X_11555_ clknet_leaf_135_clk _01386_ VGND VGND VPWR VPWR picorv32_core.cpuregs\[2\]\[2\]
+ sky130_fd_sc_hd__dfxtp_1
XFILLER_7_644 VGND VGND VPWR VPWR sky130_fd_sc_hd__decap_4
XFILLER_6_121 VPWR VGND VPWR VGND sky130_ef_sc_hd__decap_12
X_11486_ clknet_leaf_118_clk _01322_ VGND VGND VPWR VPWR net166 sky130_fd_sc_hd__dfxtp_1
X_10506_ clknet_leaf_106_clk _00392_ VGND VGND VPWR VPWR picorv32_core.latched_store
+ sky130_fd_sc_hd__dfxtp_1
XFILLER_109_561 VGND VGND VPWR VPWR sky130_fd_sc_hd__decap_6
X_10437_ clknet_leaf_76_clk _01570_ VGND VGND VPWR VPWR picorv32_core.reg_out\[30\]
+ sky130_fd_sc_hd__dfxtp_1
XFILLER_6_165 VPWR VGND VPWR VGND sky130_ef_sc_hd__decap_12
XPHY_EDGE_ROW_78_Right_78 VGND VGND VPWR VPWR sky130_fd_sc_hd__decap_3
X_10368_ clknet_leaf_86_clk _00287_ VGND VGND VPWR VPWR picorv32_core.count_cycle\[26\]
+ sky130_fd_sc_hd__dfxtp_1
XFILLER_88_61 VGND VGND VPWR VPWR sky130_fd_sc_hd__decap_6
XFILLER_111_225 VGND VGND VPWR VPWR sky130_fd_sc_hd__fill_1
X_10299_ clknet_leaf_86_clk _00218_ VGND VGND VPWR VPWR picorv32_core.reg_pc\[20\]
+ sky130_fd_sc_hd__dfxtp_2
XFILLER_88_94 VGND VGND VPWR VPWR sky130_fd_sc_hd__fill_1
XFILLER_120_781 VPWR VGND VPWR VGND sky130_ef_sc_hd__decap_12
XTAP_TAPCELL_ROW_0_308 VGND VPWR sky130_fd_sc_hd__tapvpwrvgnd_1
XFILLER_92_175 VGND VGND VPWR VPWR sky130_fd_sc_hd__fill_1
XFILLER_53_529 VGND VGND VPWR VPWR sky130_fd_sc_hd__decap_6
XTAP_TAPCELL_ROW_105_1825 VGND VPWR sky130_fd_sc_hd__tapvpwrvgnd_1
X_06530_ net2299 _02835_ net996 VGND VGND VPWR VPWR _02838_ sky130_fd_sc_hd__o21ai_1
XPHY_EDGE_ROW_87_Right_87 VGND VGND VPWR VPWR sky130_fd_sc_hd__decap_3
X_06461_ net234 net1714 net419 VGND VGND VPWR VPWR _00127_ sky130_fd_sc_hd__mux2_1
XTAP_TAPCELL_ROW_138_2313 VGND VPWR sky130_fd_sc_hd__tapvpwrvgnd_1
XTAP_TAPCELL_ROW_138_2302 VGND VPWR sky130_fd_sc_hd__tapvpwrvgnd_1
X_05412_ net923 _01912_ _01913_ _01905_ _01908_ VGND VGND VPWR VPWR _01552_ sky130_fd_sc_hd__a32o_1
X_08200_ _04184_ _04198_ _04204_ net522 net1426 VGND VGND VPWR VPWR _00451_ sky130_fd_sc_hd__a32o_1
XFILLER_21_426 VGND VGND VPWR VPWR sky130_fd_sc_hd__fill_2
XFILLER_34_798 VPWR VGND VPWR VGND sky130_ef_sc_hd__decap_12
X_06392_ picorv32_core.reg_pc\[30\] _02784_ VGND VGND VPWR VPWR _02788_ sky130_fd_sc_hd__or2_1
X_09180_ _04375_ _04377_ _04374_ _04376_ net656 net853 VGND VGND VPWR VPWR _04378_
+ sky130_fd_sc_hd__mux4_1
X_08131_ net225 net2055 net416 VGND VGND VPWR VPWR _00424_ sky130_fd_sc_hd__mux2_1
XTAP_TAPCELL_ROW_60_1176 VGND VPWR sky130_fd_sc_hd__tapvpwrvgnd_1
X_05343_ _01822_ _01847_ _01848_ _01817_ VGND VGND VPWR VPWR _01849_ sky130_fd_sc_hd__a31o_1
X_08062_ net639 _04127_ net686 VGND VGND VPWR VPWR _04137_ sky130_fd_sc_hd__o21a_1
X_05274_ net17 _01717_ _01722_ net31 _01784_ VGND VGND VPWR VPWR _01785_ sky130_fd_sc_hd__a221o_1
X_07013_ net932 _02938_ VGND VGND VPWR VPWR _03223_ sky130_fd_sc_hd__xnor2_1
XPHY_EDGE_ROW_96_Right_96 VGND VGND VPWR VPWR sky130_fd_sc_hd__decap_3
XFILLER_108_49 VGND VGND VPWR VPWR sky130_fd_sc_hd__decap_3
XFILLER_108_27 VGND VGND VPWR VPWR sky130_fd_sc_hd__fill_1
XTAP_TAPCELL_ROW_8_419 VGND VPWR sky130_fd_sc_hd__tapvpwrvgnd_1
XFILLER_1_809 VPWR VGND VPWR VGND sky130_ef_sc_hd__decap_12
XTAP_TAPCELL_ROW_116_1987 VGND VPWR sky130_fd_sc_hd__tapvpwrvgnd_1
X_08964_ net1777 net290 net348 VGND VGND VPWR VPWR _01136_ sky130_fd_sc_hd__mux2_1
XFILLER_124_15 VPWR VGND VPWR VGND sky130_ef_sc_hd__decap_12
X_07915_ picorv32_core.cpuregs\[4\]\[22\] picorv32_core.cpuregs\[5\]\[22\] picorv32_core.cpuregs\[6\]\[22\]
+ picorv32_core.cpuregs\[7\]\[22\] net748 net715 VGND VGND VPWR VPWR _03998_ sky130_fd_sc_hd__mux4_1
XFILLER_69_651 VPWR VGND VPWR VGND sky130_ef_sc_hd__decap_12
X_08895_ net427 net1758 net358 VGND VGND VPWR VPWR _01069_ sky130_fd_sc_hd__mux2_1
X_07846_ _03927_ _03928_ net635 VGND VGND VPWR VPWR _03933_ sky130_fd_sc_hd__mux2_1
XFILLER_84_643 VGND VGND VPWR VPWR sky130_fd_sc_hd__fill_1
X_07777_ net696 _03863_ _03862_ net618 VGND VGND VPWR VPWR _03868_ sky130_fd_sc_hd__o211a_1
X_09516_ picorv32_core.cpuregs\[4\]\[15\] picorv32_core.cpuregs\[5\]\[15\] picorv32_core.cpuregs\[6\]\[15\]
+ picorv32_core.cpuregs\[7\]\[15\] net893 net859 VGND VGND VPWR VPWR _04700_ sky130_fd_sc_hd__mux4_1
XFILLER_17_57 VPWR VGND VPWR VGND sky130_ef_sc_hd__decap_12
X_06728_ _02956_ _02957_ net673 VGND VGND VPWR VPWR _02961_ sky130_fd_sc_hd__o21ai_1
X_09447_ net790 net547 VGND VGND VPWR VPWR _04634_ sky130_fd_sc_hd__or2_1
XFILLER_24_231 VGND VGND VPWR VPWR sky130_fd_sc_hd__decap_4
XFILLER_24_253 VGND VGND VPWR VPWR sky130_fd_sc_hd__decap_4
XFILLER_25_765 VPWR VGND VPWR VGND sky130_ef_sc_hd__decap_12
X_06659_ _02691_ picorv32_core.reg_next_pc\[7\] net556 VGND VGND VPWR VPWR _02919_
+ sky130_fd_sc_hd__mux2_2
X_09378_ _03446_ _03483_ VGND VGND VPWR VPWR _04568_ sky130_fd_sc_hd__xnor2_1
XFILLER_40_757 VGND VGND VPWR VPWR sky130_fd_sc_hd__fill_2
XFILLER_137_111 VGND VGND VPWR VPWR sky130_fd_sc_hd__fill_1
X_08329_ net964 net1190 net453 VGND VGND VPWR VPWR _00546_ sky130_fd_sc_hd__mux2_1
XFILLER_137_133 VGND VGND VPWR VPWR sky130_fd_sc_hd__fill_2
X_11340_ clknet_leaf_40_clk _01181_ VGND VGND VPWR VPWR picorv32_core.cpuregs\[29\]\[24\]
+ sky130_fd_sc_hd__dfxtp_1
XTAP_TAPCELL_ROW_78_1437 VGND VPWR sky130_fd_sc_hd__tapvpwrvgnd_1
XFILLER_116_3 VPWR VGND VPWR VGND sky130_ef_sc_hd__decap_12
X_11271_ clknet_leaf_64_clk _01119_ VGND VGND VPWR VPWR picorv32_core.cpuregs\[4\]\[26\]
+ sky130_fd_sc_hd__dfxtp_1
XFILLER_3_113 VPWR VGND VPWR VGND sky130_ef_sc_hd__decap_12
XFILLER_140_309 VGND VGND VPWR VPWR sky130_fd_sc_hd__decap_3
XTAP_TAPCELL_ROW_91_1626 VGND VPWR sky130_fd_sc_hd__tapvpwrvgnd_1
X_10222_ clknet_leaf_102_clk _00141_ VGND VGND VPWR VPWR picorv32_core.count_instr\[6\]
+ sky130_fd_sc_hd__dfxtp_1
X_10153_ clknet_leaf_113_clk _00072_ VGND VGND VPWR VPWR picorv32_core.cpuregs\[21\]\[1\]
+ sky130_fd_sc_hd__dfxtp_1
Xhold8 picorv32_core.cpuregs\[0\]\[26\] VGND VGND VPWR VPWR net1117 sky130_fd_sc_hd__dlygate4sd3_1
XFILLER_102_781 VGND VGND VPWR VPWR sky130_fd_sc_hd__fill_1
XFILLER_87_481 VGND VGND VPWR VPWR sky130_fd_sc_hd__decap_8
XFILLER_48_813 VGND VGND VPWR VPWR sky130_fd_sc_hd__fill_2
X_10084_ net1112 VGND VGND VPWR VPWR _00934_ sky130_fd_sc_hd__clkbuf_1
XTAP_TAPCELL_ROW_89_1599 VGND VPWR sky130_fd_sc_hd__tapvpwrvgnd_1
XFILLER_74_41 VGND VGND VPWR VPWR sky130_fd_sc_hd__decap_6
XFILLER_74_197 VGND VGND VPWR VPWR sky130_fd_sc_hd__fill_1
XFILLER_74_85 VGND VGND VPWR VPWR sky130_fd_sc_hd__fill_2
XFILLER_16_721 VPWR VGND VPWR VGND sky130_ef_sc_hd__decap_12
XFILLER_15_253 VGND VGND VPWR VPWR sky130_fd_sc_hd__fill_1
X_10986_ clknet_leaf_133_clk _00837_ VGND VGND VPWR VPWR picorv32_core.cpuregs\[12\]\[0\]
+ sky130_fd_sc_hd__dfxtp_1
XFILLER_31_702 VGND VGND VPWR VPWR sky130_fd_sc_hd__fill_1
XFILLER_43_540 VGND VGND VPWR VPWR sky130_fd_sc_hd__fill_1
XFILLER_70_370 VGND VGND VPWR VPWR sky130_fd_sc_hd__fill_1
XFILLER_43_573 VGND VGND VPWR VPWR sky130_fd_sc_hd__decap_6
XFILLER_70_392 VGND VGND VPWR VPWR sky130_fd_sc_hd__fill_1
X_11607_ clknet_leaf_39_clk _01438_ VGND VGND VPWR VPWR picorv32_core.cpuregs\[23\]\[20\]
+ sky130_fd_sc_hd__dfxtp_1
XTAP_TAPCELL_ROW_100_1755 VGND VPWR sky130_fd_sc_hd__tapvpwrvgnd_1
XTAP_TAPCELL_ROW_13_487 VGND VPWR sky130_fd_sc_hd__tapvpwrvgnd_1
XTAP_TAPCELL_ROW_13_498 VGND VPWR sky130_fd_sc_hd__tapvpwrvgnd_1
XTAP_TAPCELL_ROW_133_2232 VGND VPWR sky130_fd_sc_hd__tapvpwrvgnd_1
Xhold408 picorv32_core.cpuregs\[14\]\[27\] VGND VGND VPWR VPWR net1517 sky130_fd_sc_hd__dlygate4sd3_1
X_11538_ clknet_leaf_22_clk _01369_ VGND VGND VPWR VPWR picorv32_core.cpuregs\[30\]\[19\]
+ sky130_fd_sc_hd__dfxtp_1
Xhold419 picorv32_core.cpuregs\[7\]\[29\] VGND VGND VPWR VPWR net1528 sky130_fd_sc_hd__dlygate4sd3_1
X_11469_ clknet_leaf_50_clk _01305_ VGND VGND VPWR VPWR picorv32_core.cpuregs\[24\]\[20\]
+ sky130_fd_sc_hd__dfxtp_1
XFILLER_98_757 VGND VGND VPWR VPWR sky130_fd_sc_hd__fill_1
XFILLER_31_3 VPWR VGND VPWR VGND sky130_ef_sc_hd__decap_12
XFILLER_85_418 VGND VGND VPWR VPWR sky130_fd_sc_hd__decap_6
X_05961_ net179 _02412_ VGND VGND VPWR VPWR _02429_ sky130_fd_sc_hd__or2_1
Xhold1108 picorv32_core.cpuregs\[2\]\[14\] VGND VGND VPWR VPWR net2217 sky130_fd_sc_hd__dlygate4sd3_1
Xhold1119 picorv32_core.cpuregs\[6\]\[8\] VGND VGND VPWR VPWR net2228 sky130_fd_sc_hd__dlygate4sd3_1
X_07700_ picorv32_core.cpuregs\[8\]\[10\] picorv32_core.cpuregs\[9\]\[10\] picorv32_core.cpuregs\[10\]\[10\]
+ picorv32_core.cpuregs\[11\]\[10\] net736 net703 VGND VGND VPWR VPWR _03795_ sky130_fd_sc_hd__mux4_1
X_08680_ net228 net1990 net389 VGND VGND VPWR VPWR _00830_ sky130_fd_sc_hd__mux2_1
XFILLER_66_643 VGND VGND VPWR VPWR sky130_fd_sc_hd__fill_1
X_05892_ net961 net204 net958 _02331_ net672 VGND VGND VPWR VPWR _02365_ sky130_fd_sc_hd__o41a_1
XTAP_TAPCELL_ROW_49_1016 VGND VPWR sky130_fd_sc_hd__tapvpwrvgnd_1
X_07631_ _03728_ _03729_ net457 _03726_ VGND VGND VPWR VPWR _03730_ sky130_fd_sc_hd__o211a_1
XFILLER_93_495 VGND VGND VPWR VPWR sky130_fd_sc_hd__fill_2
X_07562_ _03665_ _03666_ net632 VGND VGND VPWR VPWR _03667_ sky130_fd_sc_hd__mux2_1
X_06513_ net991 _02825_ _02826_ VGND VGND VPWR VPWR _00151_ sky130_fd_sc_hd__and3_1
X_09301_ _04486_ _04487_ _04490_ _04491_ net653 net830 VGND VGND VPWR VPWR _04495_
+ sky130_fd_sc_hd__mux4_1
X_07493_ net46 _03616_ net462 VGND VGND VPWR VPWR _00341_ sky130_fd_sc_hd__mux2_1
XFILLER_80_189 VGND VGND VPWR VPWR sky130_fd_sc_hd__fill_1
XTAP_TAPCELL_ROW_62_1205 VGND VPWR sky130_fd_sc_hd__tapvpwrvgnd_1
XFILLER_22_757 VPWR VGND VPWR VGND sky130_ef_sc_hd__decap_12
X_09232_ net817 _04428_ net282 VGND VGND VPWR VPWR _01321_ sky130_fd_sc_hd__mux2_1
X_06444_ net432 net2104 net418 VGND VGND VPWR VPWR _00110_ sky130_fd_sc_hd__mux2_1
X_06375_ picorv32_core.reg_out\[27\] picorv32_core.alu_out_q\[27\] net953 VGND VGND
+ VPWR VPWR _02774_ sky130_fd_sc_hd__mux2_1
X_09163_ picorv32_core.cpuregs\[28\]\[0\] picorv32_core.cpuregs\[29\]\[0\] picorv32_core.cpuregs\[30\]\[0\]
+ picorv32_core.cpuregs\[31\]\[0\] net884 net851 VGND VGND VPWR VPWR _04362_ sky130_fd_sc_hd__mux4_1
XTAP_TAPCELL_ROW_32_763 VGND VPWR sky130_fd_sc_hd__tapvpwrvgnd_1
XTAP_TAPCELL_ROW_32_774 VGND VPWR sky130_fd_sc_hd__tapvpwrvgnd_1
XFILLER_119_15 VPWR VGND VPWR VGND sky130_ef_sc_hd__decap_12
X_05326_ net921 _01832_ _01833_ _01825_ _01828_ VGND VGND VPWR VPWR _01577_ sky130_fd_sc_hd__a32o_1
X_08114_ net300 net1646 net414 VGND VGND VPWR VPWR _00407_ sky130_fd_sc_hd__mux2_1
X_09094_ net427 net2131 net332 VGND VGND VPWR VPWR _01261_ sky130_fd_sc_hd__mux2_1
X_08045_ _04111_ _04119_ _04120_ net622 net690 VGND VGND VPWR VPWR _04121_ sky130_fd_sc_hd__a221o_1
Xhold920 picorv32_core.cpuregs\[8\]\[15\] VGND VGND VPWR VPWR net2029 sky130_fd_sc_hd__dlygate4sd3_1
Xhold931 picorv32_core.cpuregs\[22\]\[13\] VGND VGND VPWR VPWR net2040 sky130_fd_sc_hd__dlygate4sd3_1
X_05257_ _01767_ _01768_ VGND VGND VPWR VPWR _01769_ sky130_fd_sc_hd__xnor2_1
Xhold953 picorv32_core.cpuregs\[13\]\[29\] VGND VGND VPWR VPWR net2062 sky130_fd_sc_hd__dlygate4sd3_1
Xhold964 picorv32_core.cpuregs\[22\]\[21\] VGND VGND VPWR VPWR net2073 sky130_fd_sc_hd__dlygate4sd3_1
Xhold942 picorv32_core.cpuregs\[13\]\[14\] VGND VGND VPWR VPWR net2051 sky130_fd_sc_hd__dlygate4sd3_1
XFILLER_1_617 VPWR VGND VPWR VGND sky130_ef_sc_hd__decap_12
X_05188_ _01590_ _01679_ _01704_ _01630_ VGND VGND VPWR VPWR _01710_ sky130_fd_sc_hd__o22a_1
XFILLER_131_821 VPWR VGND VPWR VGND sky130_ef_sc_hd__decap_12
Xhold997 net57 VGND VGND VPWR VPWR net2106 sky130_fd_sc_hd__dlygate4sd3_1
XFILLER_103_523 VGND VGND VPWR VPWR sky130_fd_sc_hd__fill_1
XTAP_TAPCELL_ROW_73_1367 VGND VPWR sky130_fd_sc_hd__tapvpwrvgnd_1
Xhold975 picorv32_core.cpuregs\[18\]\[6\] VGND VGND VPWR VPWR net2084 sky130_fd_sc_hd__dlygate4sd3_1
Xhold986 picorv32_core.cpuregs\[8\]\[12\] VGND VGND VPWR VPWR net2095 sky130_fd_sc_hd__dlygate4sd3_1
XFILLER_135_69 VPWR VGND VPWR VGND sky130_ef_sc_hd__decap_12
X_09996_ net2043 net237 net314 VGND VGND VPWR VPWR _01473_ sky130_fd_sc_hd__mux2_1
X_08947_ net222 net2190 net356 VGND VGND VPWR VPWR _01120_ sky130_fd_sc_hd__mux2_1
XFILLER_69_481 VGND VGND VPWR VPWR sky130_fd_sc_hd__decap_4
X_08878_ net232 net1770 net364 VGND VGND VPWR VPWR _01053_ sky130_fd_sc_hd__mux2_1
X_07829_ _03907_ _03908_ net634 VGND VGND VPWR VPWR _03917_ sky130_fd_sc_hd__mux2_1
X_10840_ clknet_leaf_25_clk _00691_ VGND VGND VPWR VPWR picorv32_core.cpuregs\[17\]\[17\]
+ sky130_fd_sc_hd__dfxtp_1
XFILLER_71_167 VGND VGND VPWR VPWR sky130_fd_sc_hd__fill_1
X_10771_ clknet_leaf_7_clk _00622_ VGND VGND VPWR VPWR picorv32_core.cpuregs\[14\]\[12\]
+ sky130_fd_sc_hd__dfxtp_1
XFILLER_25_595 VGND VGND VPWR VPWR sky130_fd_sc_hd__fill_1
XFILLER_40_587 VGND VGND VPWR VPWR sky130_fd_sc_hd__fill_1
XTAP_TAPCELL_ROW_10_457 VGND VPWR sky130_fd_sc_hd__tapvpwrvgnd_1
XTAP_TAPCELL_ROW_10_446 VGND VPWR sky130_fd_sc_hd__tapvpwrvgnd_1
XPHY_EDGE_ROW_97_Left_239 VGND VGND VPWR VPWR sky130_fd_sc_hd__decap_3
X_11323_ clknet_leaf_139_clk _01164_ VGND VGND VPWR VPWR picorv32_core.cpuregs\[29\]\[7\]
+ sky130_fd_sc_hd__dfxtp_1
Xclkbuf_4_0_0_clk clknet_0_clk VGND VGND VPWR VPWR clknet_4_0_0_clk sky130_fd_sc_hd__clkbuf_8
XFILLER_125_169 VGND VGND VPWR VPWR sky130_fd_sc_hd__fill_2
X_11254_ clknet_leaf_0_clk _01102_ VGND VGND VPWR VPWR picorv32_core.cpuregs\[4\]\[9\]
+ sky130_fd_sc_hd__dfxtp_1
XFILLER_140_139 VGND VGND VPWR VPWR sky130_fd_sc_hd__fill_1
XFILLER_122_821 VGND VGND VPWR VPWR sky130_fd_sc_hd__decap_3
X_10205_ clknet_leaf_49_clk _00124_ VGND VGND VPWR VPWR picorv32_core.cpuregs\[9\]\[21\]
+ sky130_fd_sc_hd__dfxtp_1
X_11185_ clknet_leaf_140_clk _01036_ VGND VGND VPWR VPWR picorv32_core.cpuregs\[6\]\[7\]
+ sky130_fd_sc_hd__dfxtp_1
XFILLER_95_749 VGND VGND VPWR VPWR sky130_fd_sc_hd__decap_6
X_10136_ clknet_leaf_28_clk _00058_ VGND VGND VPWR VPWR picorv32_core.cpuregs\[22\]\[19\]
+ sky130_fd_sc_hd__dfxtp_1
XFILLER_39_109 VGND VGND VPWR VPWR sky130_fd_sc_hd__decap_3
X_10067_ net1229 net219 net307 VGND VGND VPWR VPWR _01542_ sky130_fd_sc_hd__mux2_1
XFILLER_90_410 VGND VGND VPWR VPWR sky130_fd_sc_hd__decap_8
XFILLER_63_635 VGND VGND VPWR VPWR sky130_fd_sc_hd__fill_2
XFILLER_48_698 VGND VGND VPWR VPWR sky130_fd_sc_hd__fill_2
XFILLER_51_808 VGND VGND VPWR VPWR sky130_fd_sc_hd__fill_1
XTAP_TAPCELL_ROW_18_568 VGND VPWR sky130_fd_sc_hd__tapvpwrvgnd_1
X_10969_ clknet_leaf_14_clk _00820_ VGND VGND VPWR VPWR picorv32_core.cpuregs\[13\]\[15\]
+ sky130_fd_sc_hd__dfxtp_1
Xclkbuf_leaf_136_clk clknet_4_2_0_clk VGND VGND VPWR VPWR clknet_leaf_136_clk sky130_fd_sc_hd__clkbuf_8
XFILLER_16_584 VGND VGND VPWR VPWR sky130_fd_sc_hd__decap_4
XFILLER_79_3 VGND VGND VPWR VPWR sky130_fd_sc_hd__fill_1
X_06160_ picorv32_core.decoded_imm_j\[11\] _00761_ net438 VGND VGND VPWR VPWR _00020_
+ sky130_fd_sc_hd__mux2_1
Xhold205 picorv32_core.cpuregs\[12\]\[28\] VGND VGND VPWR VPWR net1314 sky130_fd_sc_hd__dlygate4sd3_1
X_06091_ _02545_ _02547_ _02548_ net508 VGND VGND VPWR VPWR _02549_ sky130_fd_sc_hd__o211a_1
Xhold216 picorv32_core.cpuregs\[27\]\[19\] VGND VGND VPWR VPWR net1325 sky130_fd_sc_hd__dlygate4sd3_1
X_05111_ net924 net613 _01640_ _01642_ VGND VGND VPWR VPWR _01643_ sky130_fd_sc_hd__o22a_1
XFILLER_104_309 VGND VGND VPWR VPWR sky130_fd_sc_hd__decap_4
Xhold249 picorv32_core.cpuregs\[15\]\[9\] VGND VGND VPWR VPWR net1358 sky130_fd_sc_hd__dlygate4sd3_1
Xhold227 picorv32_core.cpuregs\[22\]\[9\] VGND VGND VPWR VPWR net1336 sky130_fd_sc_hd__dlygate4sd3_1
Xhold238 picorv32_core.cpuregs\[27\]\[9\] VGND VGND VPWR VPWR net1347 sky130_fd_sc_hd__dlygate4sd3_1
XTAP_TAPCELL_ROW_113_1946 VGND VPWR sky130_fd_sc_hd__tapvpwrvgnd_1
X_09850_ picorv32_core.cpuregs\[0\]\[30\] picorv32_core.cpuregs\[1\]\[30\] picorv32_core.cpuregs\[2\]\[30\]
+ picorv32_core.cpuregs\[3\]\[30\] net901 net867 VGND VGND VPWR VPWR _05019_ sky130_fd_sc_hd__mux4_1
Xfanout729 net730 VGND VGND VPWR VPWR net729 sky130_fd_sc_hd__clkbuf_4
Xfanout718 net725 VGND VGND VPWR VPWR net718 sky130_fd_sc_hd__clkbuf_4
Xfanout707 net708 VGND VGND VPWR VPWR net707 sky130_fd_sc_hd__buf_2
X_09781_ picorv32_core.cpuregs\[28\]\[27\] picorv32_core.cpuregs\[29\]\[27\] picorv32_core.cpuregs\[30\]\[27\]
+ picorv32_core.cpuregs\[31\]\[27\] net898 net864 VGND VGND VPWR VPWR _04953_ sky130_fd_sc_hd__mux4_1
XFILLER_100_504 VPWR VGND VPWR VGND sky130_ef_sc_hd__decap_12
XFILLER_98_576 VGND VGND VPWR VPWR sky130_fd_sc_hd__fill_2
X_06993_ net678 _03203_ _03204_ VGND VGND VPWR VPWR _03205_ sky130_fd_sc_hd__or3_1
X_08801_ net274 net2030 net372 VGND VGND VPWR VPWR _00979_ sky130_fd_sc_hd__mux2_1
XTAP_TAPCELL_ROW_55_1097 VGND VPWR sky130_fd_sc_hd__tapvpwrvgnd_1
X_05944_ net669 _02412_ VGND VGND VPWR VPWR _02413_ sky130_fd_sc_hd__nand2_1
X_08732_ net1380 net292 net378 VGND VGND VPWR VPWR _00880_ sky130_fd_sc_hd__mux2_1
X_08663_ net426 net1961 net386 VGND VGND VPWR VPWR _00813_ sky130_fd_sc_hd__mux2_1
X_05875_ net803 net959 net606 _02349_ VGND VGND VPWR VPWR _02350_ sky130_fd_sc_hd__o22a_1
XFILLER_26_315 VGND VGND VPWR VPWR sky130_fd_sc_hd__fill_1
XFILLER_121_27 VPWR VGND VPWR VGND sky130_ef_sc_hd__decap_12
XFILLER_26_359 VGND VGND VPWR VPWR sky130_fd_sc_hd__decap_4
X_07614_ net964 net510 _03712_ _03713_ VGND VGND VPWR VPWR _00365_ sky130_fd_sc_hd__o22a_1
XTAP_TAPCELL_ROW_37_844 VGND VPWR sky130_fd_sc_hd__tapvpwrvgnd_1
X_08594_ net295 net2212 net394 VGND VGND VPWR VPWR _00717_ sky130_fd_sc_hd__mux2_1
XPHY_EDGE_ROW_138_Right_138 VGND VGND VPWR VPWR sky130_fd_sc_hd__decap_3
XFILLER_53_167 VGND VGND VPWR VPWR sky130_fd_sc_hd__fill_1
Xclkbuf_leaf_127_clk clknet_4_3_0_clk VGND VGND VPWR VPWR clknet_leaf_127_clk sky130_fd_sc_hd__clkbuf_8
X_07545_ picorv32_core.mem_do_rinst _03649_ _03650_ _03652_ _01699_ VGND VGND VPWR
+ VPWR _03653_ sky130_fd_sc_hd__o221a_1
X_07476_ picorv32_core.reg_out\[12\] picorv32_core.reg_next_pc\[12\] net557 VGND VGND
+ VPWR VPWR _03605_ sky130_fd_sc_hd__mux2_1
XFILLER_22_521 VGND VGND VPWR VPWR sky130_fd_sc_hd__decap_3
X_06427_ net233 net1921 net424 VGND VGND VPWR VPWR _00095_ sky130_fd_sc_hd__mux2_1
XFILLER_10_705 VGND VGND VPWR VPWR sky130_fd_sc_hd__fill_1
X_09215_ picorv32_core.cpuregs\[28\]\[2\] picorv32_core.cpuregs\[29\]\[2\] picorv32_core.cpuregs\[30\]\[2\]
+ picorv32_core.cpuregs\[31\]\[2\] net876 net843 VGND VGND VPWR VPWR _04412_ sky130_fd_sc_hd__mux4_1
XFILLER_10_738 VPWR VGND VPWR VGND sky130_ef_sc_hd__decap_12
X_06358_ net1855 net238 net436 VGND VGND VPWR VPWR _00062_ sky130_fd_sc_hd__mux2_1
X_09146_ net1621 net221 net331 VGND VGND VPWR VPWR _01312_ sky130_fd_sc_hd__mux2_1
X_09077_ net1258 net234 net338 VGND VGND VPWR VPWR _01245_ sky130_fd_sc_hd__mux2_1
X_06289_ picorv32_core.reg_pc\[10\] _02701_ VGND VGND VPWR VPWR _02705_ sky130_fd_sc_hd__xor2_1
X_05309_ picorv32_core.latched_is_lb _01813_ VGND VGND VPWR VPWR _01817_ sky130_fd_sc_hd__and2_2
X_08028_ _04094_ _04095_ net637 VGND VGND VPWR VPWR _04105_ sky130_fd_sc_hd__mux2_1
Xhold750 picorv32_core.cpuregs\[29\]\[31\] VGND VGND VPWR VPWR net1859 sky130_fd_sc_hd__dlygate4sd3_1
Xhold761 picorv32_core.cpuregs\[16\]\[22\] VGND VGND VPWR VPWR net1870 sky130_fd_sc_hd__dlygate4sd3_1
XFILLER_104_821 VGND VGND VPWR VPWR sky130_fd_sc_hd__decap_3
Xhold772 picorv32_core.cpuregs\[3\]\[19\] VGND VGND VPWR VPWR net1881 sky130_fd_sc_hd__dlygate4sd3_1
XFILLER_89_521 VGND VGND VPWR VPWR sky130_fd_sc_hd__fill_1
Xhold794 picorv32_core.cpuregs\[21\]\[25\] VGND VGND VPWR VPWR net1903 sky130_fd_sc_hd__dlygate4sd3_1
Xhold783 picorv32_core.cpuregs\[12\]\[15\] VGND VGND VPWR VPWR net1892 sky130_fd_sc_hd__dlygate4sd3_1
XFILLER_130_150 VGND VGND VPWR VPWR sky130_fd_sc_hd__fill_1
XFILLER_103_375 VGND VGND VPWR VPWR sky130_fd_sc_hd__fill_1
XFILLER_89_576 VGND VGND VPWR VPWR sky130_fd_sc_hd__decap_3
X_09979_ net1857 net446 net312 VGND VGND VPWR VPWR _01456_ sky130_fd_sc_hd__mux2_1
XFILLER_130_172 VGND VGND VPWR VPWR sky130_fd_sc_hd__decap_4
XFILLER_76_248 VGND VGND VPWR VPWR sky130_fd_sc_hd__decap_4
XFILLER_18_805 VGND VGND VPWR VPWR sky130_fd_sc_hd__decap_4
XTAP_TAPCELL_ROW_86_1547 VGND VPWR sky130_fd_sc_hd__tapvpwrvgnd_1
XFILLER_72_421 VGND VGND VPWR VPWR sky130_fd_sc_hd__decap_4
XTAP_TAPCELL_ROW_86_1558 VGND VPWR sky130_fd_sc_hd__tapvpwrvgnd_1
XFILLER_72_432 VGND VGND VPWR VPWR sky130_fd_sc_hd__fill_1
XPHY_EDGE_ROW_105_Right_105 VGND VGND VPWR VPWR sky130_fd_sc_hd__decap_3
X_10823_ clknet_leaf_134_clk _00674_ VGND VGND VPWR VPWR picorv32_core.cpuregs\[17\]\[0\]
+ sky130_fd_sc_hd__dfxtp_1
XTAP_TAPCELL_ROW_15_516 VGND VPWR sky130_fd_sc_hd__tapvpwrvgnd_1
Xclkbuf_leaf_118_clk clknet_4_8_0_clk VGND VGND VPWR VPWR clknet_leaf_118_clk sky130_fd_sc_hd__clkbuf_8
XTAP_TAPCELL_ROW_15_527 VGND VPWR sky130_fd_sc_hd__tapvpwrvgnd_1
X_10754_ clknet_leaf_123_clk _00605_ VGND VGND VPWR VPWR picorv32_core.decoded_imm\[5\]
+ sky130_fd_sc_hd__dfxtp_2
XTAP_TAPCELL_ROW_117_2002 VGND VPWR sky130_fd_sc_hd__tapvpwrvgnd_1
X_10685_ clknet_leaf_92_clk net1145 VGND VGND VPWR VPWR picorv32_core.is_slti_blt_slt
+ sky130_fd_sc_hd__dfxtp_1
XFILLER_138_250 VGND VGND VPWR VPWR sky130_fd_sc_hd__fill_2
X_11306_ clknet_leaf_71_clk _01154_ VGND VGND VPWR VPWR picorv32_core.cpuregs\[3\]\[29\]
+ sky130_fd_sc_hd__dfxtp_1
XFILLER_5_753 VPWR VGND VPWR VGND sky130_ef_sc_hd__decap_12
XFILLER_107_692 VGND VGND VPWR VPWR sky130_fd_sc_hd__decap_8
XFILLER_107_670 VGND VGND VPWR VPWR sky130_fd_sc_hd__fill_2
XFILLER_5_797 VPWR VGND VPWR VGND sky130_ef_sc_hd__decap_12
XFILLER_4_285 VGND VGND VPWR VPWR sky130_fd_sc_hd__fill_1
X_11237_ clknet_leaf_42_clk _01088_ VGND VGND VPWR VPWR picorv32_core.cpuregs\[5\]\[27\]
+ sky130_fd_sc_hd__dfxtp_1
XFILLER_110_813 VGND VGND VPWR VPWR sky130_fd_sc_hd__decap_4
X_11168_ clknet_leaf_30_clk _01019_ VGND VGND VPWR VPWR picorv32_core.cpuregs\[7\]\[22\]
+ sky130_fd_sc_hd__dfxtp_1
XFILLER_122_695 VGND VGND VPWR VPWR sky130_fd_sc_hd__decap_4
XFILLER_110_835 VGND VGND VPWR VPWR sky130_fd_sc_hd__fill_2
XFILLER_96_83 VGND VGND VPWR VPWR sky130_fd_sc_hd__fill_1
X_10119_ clknet_leaf_136_clk _00041_ VGND VGND VPWR VPWR picorv32_core.cpuregs\[22\]\[2\]
+ sky130_fd_sc_hd__dfxtp_1
XTAP_TAPCELL_ROW_128_2164 VGND VPWR sky130_fd_sc_hd__tapvpwrvgnd_1
X_11099_ clknet_leaf_25_clk _00950_ VGND VGND VPWR VPWR picorv32_core.cpuregs\[0\]\[17\]
+ sky130_fd_sc_hd__dfxtp_1
XFILLER_83_719 VGND VGND VPWR VPWR sky130_fd_sc_hd__decap_6
XFILLER_36_635 VGND VGND VPWR VPWR sky130_fd_sc_hd__decap_8
XTAP_TAPCELL_ROW_141_2364 VGND VPWR sky130_fd_sc_hd__tapvpwrvgnd_1
XTAP_TAPCELL_ROW_141_2353 VGND VPWR sky130_fd_sc_hd__tapvpwrvgnd_1
X_05660_ _02142_ _02143_ VGND VGND VPWR VPWR _02144_ sky130_fd_sc_hd__and2_1
X_05591_ _02035_ _02075_ _02077_ _02078_ VGND VGND VPWR VPWR _02079_ sky130_fd_sc_hd__o211a_1
XFILLER_90_273 VGND VGND VPWR VPWR sky130_fd_sc_hd__decap_4
XFILLER_63_487 VGND VGND VPWR VPWR sky130_fd_sc_hd__decap_8
Xclkbuf_leaf_109_clk clknet_4_10_0_clk VGND VGND VPWR VPWR clknet_leaf_109_clk sky130_fd_sc_hd__clkbuf_8
XFILLER_23_307 VGND VGND VPWR VPWR sky130_fd_sc_hd__decap_4
XTAP_TAPCELL_ROW_34_803 VGND VPWR sky130_fd_sc_hd__tapvpwrvgnd_1
XFILLER_35_167 VGND VGND VPWR VPWR sky130_fd_sc_hd__fill_1
XFILLER_50_126 VGND VGND VPWR VPWR sky130_fd_sc_hd__decap_4
X_07330_ net813 picorv32_core.decoded_imm\[4\] _03469_ VGND VGND VPWR VPWR _03470_
+ sky130_fd_sc_hd__a21oi_1
XFILLER_44_690 VGND VGND VPWR VPWR sky130_fd_sc_hd__fill_2
X_07261_ net765 picorv32_core.decoded_imm\[29\] VGND VGND VPWR VPWR _03401_ sky130_fd_sc_hd__nand2_1
X_09000_ net277 net2207 net344 VGND VGND VPWR VPWR _01170_ sky130_fd_sc_hd__mux2_1
X_07192_ picorv32_core.count_cycle\[43\] _03349_ picorv32_core.count_cycle\[44\] VGND
+ VGND VPWR VPWR _03352_ sky130_fd_sc_hd__a21o_1
X_06212_ _01693_ _02624_ _02642_ net913 VGND VGND VPWR VPWR _00035_ sky130_fd_sc_hd__o22a_1
X_06143_ net954 net196 _02576_ net670 VGND VGND VPWR VPWR _02596_ sky130_fd_sc_hd__o31a_1
XTAP_TAPCELL_ROW_57_1137 VGND VPWR sky130_fd_sc_hd__tapvpwrvgnd_1
XTAP_TAPCELL_ROW_57_1126 VGND VPWR sky130_fd_sc_hd__tapvpwrvgnd_1
X_06074_ _02519_ _02522_ _02532_ VGND VGND VPWR VPWR _02533_ sky130_fd_sc_hd__a21oi_1
XFILLER_116_27 VGND VGND VPWR VPWR sky130_fd_sc_hd__fill_1
XFILLER_113_651 VGND VGND VPWR VPWR sky130_fd_sc_hd__fill_1
Xfanout515 _01636_ VGND VGND VPWR VPWR net515 sky130_fd_sc_hd__clkbuf_4
X_09902_ net496 net1812 net321 VGND VGND VPWR VPWR _01386_ sky130_fd_sc_hd__mux2_1
Xfanout504 net505 VGND VGND VPWR VPWR net504 sky130_fd_sc_hd__clkbuf_2
X_09833_ net839 _04997_ net829 VGND VGND VPWR VPWR _05003_ sky130_fd_sc_hd__o21a_1
XFILLER_98_362 VGND VGND VPWR VPWR sky130_fd_sc_hd__fill_2
Xfanout537 net539 VGND VGND VPWR VPWR net537 sky130_fd_sc_hd__clkbuf_4
XTAP_TAPCELL_ROW_70_1326 VGND VPWR sky130_fd_sc_hd__tapvpwrvgnd_1
XTAP_TAPCELL_ROW_70_1315 VGND VPWR sky130_fd_sc_hd__tapvpwrvgnd_1
Xfanout548 net550 VGND VGND VPWR VPWR net548 sky130_fd_sc_hd__clkbuf_4
XFILLER_58_215 VGND VGND VPWR VPWR sky130_fd_sc_hd__fill_2
Xfanout526 net527 VGND VGND VPWR VPWR net526 sky130_fd_sc_hd__buf_2
Xfanout559 net560 VGND VGND VPWR VPWR net559 sky130_fd_sc_hd__clkbuf_4
XFILLER_98_395 VGND VGND VPWR VPWR sky130_fd_sc_hd__fill_1
XFILLER_132_15 VPWR VGND VPWR VGND sky130_ef_sc_hd__decap_12
X_09764_ net660 _04936_ VGND VGND VPWR VPWR _04937_ sky130_fd_sc_hd__or2_1
X_06976_ _03188_ _03189_ net989 VGND VGND VPWR VPWR _00251_ sky130_fd_sc_hd__o21a_1
X_08715_ net1839 net221 net385 VGND VGND VPWR VPWR _00864_ sky130_fd_sc_hd__mux2_1
X_09695_ net611 _04866_ _04870_ net487 VGND VGND VPWR VPWR _04871_ sky130_fd_sc_hd__a211o_1
X_05927_ net607 _02189_ _02190_ net572 _02397_ VGND VGND VPWR VPWR _02398_ sky130_fd_sc_hd__a221o_1
XFILLER_26_101 VGND VGND VPWR VPWR sky130_fd_sc_hd__fill_1
XFILLER_39_473 VPWR VGND VPWR VGND sky130_ef_sc_hd__decap_12
X_08646_ net1408 net232 net392 VGND VGND VPWR VPWR _00797_ sky130_fd_sc_hd__mux2_1
X_05858_ net805 _02333_ VGND VGND VPWR VPWR _02334_ sky130_fd_sc_hd__nand2_1
XTAP_TAPCELL_ROW_68_1288 VGND VPWR sky130_fd_sc_hd__tapvpwrvgnd_1
XFILLER_26_189 VGND VGND VPWR VPWR sky130_fd_sc_hd__fill_1
X_08577_ net217 net1734 net401 VGND VGND VPWR VPWR _00702_ sky130_fd_sc_hd__mux2_1
XFILLER_25_57 VGND VGND VPWR VPWR sky130_fd_sc_hd__decap_4
X_05789_ _02269_ _02270_ VGND VGND VPWR VPWR _02271_ sky130_fd_sc_hd__xnor2_1
X_07528_ net162 _03639_ net534 VGND VGND VPWR VPWR _03640_ sky130_fd_sc_hd__mux2_1
XTAP_TAPCELL_ROW_81_1477 VGND VPWR sky130_fd_sc_hd__tapvpwrvgnd_1
X_07459_ net810 _03593_ net532 VGND VGND VPWR VPWR _03594_ sky130_fd_sc_hd__mux2_1
XFILLER_10_546 VGND VGND VPWR VPWR sky130_fd_sc_hd__fill_1
X_10470_ clknet_leaf_95_clk _00357_ VGND VGND VPWR VPWR picorv32_core.mem_do_rinst
+ sky130_fd_sc_hd__dfxtp_2
X_09129_ net1560 net297 net328 VGND VGND VPWR VPWR _01295_ sky130_fd_sc_hd__mux2_1
XTAP_TAPCELL_ROW_20_596 VGND VPWR sky130_fd_sc_hd__tapvpwrvgnd_1
XFILLER_123_426 VGND VGND VPWR VPWR sky130_fd_sc_hd__fill_2
XFILLER_2_701 VPWR VGND VPWR VGND sky130_ef_sc_hd__decap_12
Xhold580 picorv32_core.count_cycle\[0\] VGND VGND VPWR VPWR net1689 sky130_fd_sc_hd__dlygate4sd3_1
XFILLER_49_204 VGND VGND VPWR VPWR sky130_fd_sc_hd__decap_3
X_11022_ clknet_leaf_115_clk _00873_ VGND VGND VPWR VPWR picorv32_core.cpuregs\[11\]\[4\]
+ sky130_fd_sc_hd__dfxtp_1
Xhold591 net59 VGND VGND VPWR VPWR net1700 sky130_fd_sc_hd__dlygate4sd3_1
XFILLER_104_695 VGND VGND VPWR VPWR sky130_fd_sc_hd__decap_4
XFILLER_77_535 VGND VGND VPWR VPWR sky130_fd_sc_hd__fill_2
XTAP_TAPCELL_ROW_123_2083 VGND VPWR sky130_fd_sc_hd__tapvpwrvgnd_1
XFILLER_122_81 VGND VGND VPWR VPWR sky130_fd_sc_hd__decap_3
XFILLER_60_402 VPWR VGND VPWR VGND sky130_ef_sc_hd__decap_12
XFILLER_17_178 VGND VGND VPWR VPWR sky130_fd_sc_hd__fill_2
XTAP_TAPCELL_ROW_123_2094 VGND VPWR sky130_fd_sc_hd__tapvpwrvgnd_1
X_11855_ net58 VGND VGND VPWR VPWR net90 sky130_fd_sc_hd__clkbuf_1
X_10806_ clknet_leaf_9_clk _00657_ VGND VGND VPWR VPWR picorv32_core.cpuregs\[15\]\[15\]
+ sky130_fd_sc_hd__dfxtp_1
X_10737_ clknet_leaf_89_clk _00588_ VGND VGND VPWR VPWR picorv32_core.decoded_imm\[22\]
+ sky130_fd_sc_hd__dfxtp_2
XFILLER_41_671 VGND VGND VPWR VPWR sky130_fd_sc_hd__fill_1
XTAP_TAPCELL_ROW_99_1738 VGND VPWR sky130_fd_sc_hd__tapvpwrvgnd_1
X_10668_ clknet_leaf_106_clk _00522_ VGND VGND VPWR VPWR picorv32_core.decoded_rd\[4\]
+ sky130_fd_sc_hd__dfxtp_1
Xoutput107 net107 VGND VGND VPWR VPWR mem_axi_wdata[12] sky130_fd_sc_hd__buf_2
X_10599_ clknet_leaf_107_clk net1187 VGND VGND VPWR VPWR picorv32_core.latched_rd\[1\]
+ sky130_fd_sc_hd__dfxtp_1
Xoutput118 net118 VGND VGND VPWR VPWR mem_axi_wdata[22] sky130_fd_sc_hd__buf_2
Xoutput129 net129 VGND VGND VPWR VPWR mem_axi_wdata[3] sky130_fd_sc_hd__buf_2
XTAP_TAPCELL_ROW_110_1905 VGND VPWR sky130_fd_sc_hd__tapvpwrvgnd_1
XFILLER_5_594 VGND VGND VPWR VPWR sky130_fd_sc_hd__fill_1
XFILLER_96_811 VGND VGND VPWR VPWR sky130_fd_sc_hd__fill_1
XTAP_TAPCELL_ROW_52_1056 VGND VPWR sky130_fd_sc_hd__tapvpwrvgnd_1
XFILLER_110_654 VGND VGND VPWR VPWR sky130_fd_sc_hd__fill_2
XFILLER_83_505 VGND VGND VPWR VPWR sky130_fd_sc_hd__decap_3
X_06830_ net668 picorv32_core.reg_next_pc\[11\] _02923_ net491 VGND VGND VPWR VPWR
+ _03055_ sky130_fd_sc_hd__a22o_1
XFILLER_49_760 VGND VGND VPWR VPWR sky130_fd_sc_hd__fill_1
X_06761_ _02976_ _02980_ VGND VGND VPWR VPWR _02991_ sky130_fd_sc_hd__or2_1
XTAP_TAPCELL_ROW_108_1867 VGND VPWR sky130_fd_sc_hd__tapvpwrvgnd_1
X_06692_ picorv32_core.reg_pc\[23\] net553 _02935_ net516 VGND VGND VPWR VPWR _00221_
+ sky130_fd_sc_hd__a22o_1
X_08500_ net1591 net247 net408 VGND VGND VPWR VPWR _00630_ sky130_fd_sc_hd__mux2_1
X_05712_ _02194_ _02195_ VGND VGND VPWR VPWR _02196_ sky130_fd_sc_hd__and2_1
X_09480_ picorv32_core.cpuregs\[24\]\[13\] picorv32_core.cpuregs\[25\]\[13\] picorv32_core.cpuregs\[26\]\[13\]
+ picorv32_core.cpuregs\[27\]\[13\] net881 net848 VGND VGND VPWR VPWR _04666_ sky130_fd_sc_hd__mux4_1
XFILLER_36_421 VGND VGND VPWR VPWR sky130_fd_sc_hd__fill_2
XFILLER_36_443 VGND VGND VPWR VPWR sky130_fd_sc_hd__fill_1
XTAP_TAPCELL_ROW_108_1878 VGND VPWR sky130_fd_sc_hd__tapvpwrvgnd_1
XFILLER_102_29 VGND VGND VPWR VPWR sky130_fd_sc_hd__decap_8
XFILLER_91_582 VGND VGND VPWR VPWR sky130_fd_sc_hd__decap_8
X_08431_ picorv32_core.mem_rdata_q\[21\] net614 VGND VGND VPWR VPWR _04296_ sky130_fd_sc_hd__and2_1
XFILLER_24_605 VGND VGND VPWR VPWR sky130_fd_sc_hd__fill_2
X_05643_ net813 net965 VGND VGND VPWR VPWR _02127_ sky130_fd_sc_hd__xnor2_1
XTAP_TAPCELL_ROW_47_983 VGND VPWR sky130_fd_sc_hd__tapvpwrvgnd_1
X_05574_ net922 _02056_ _02057_ _02063_ VGND VGND VPWR VPWR _01565_ sky130_fd_sc_hd__a31o_1
X_08362_ net966 net183 net582 VGND VGND VPWR VPWR _04256_ sky130_fd_sc_hd__mux2_1
X_08293_ net1257 net208 net413 VGND VGND VPWR VPWR _00517_ sky130_fd_sc_hd__mux2_1
X_07313_ net811 picorv32_core.decoded_imm\[5\] VGND VGND VPWR VPWR _03453_ sky130_fd_sc_hd__or2_1
X_07244_ picorv32_core.count_cycle\[61\] picorv32_core.count_cycle\[62\] picorv32_core.count_cycle\[63\]
+ _03380_ net977 VGND VGND VPWR VPWR _03385_ sky130_fd_sc_hd__a41o_1
XFILLER_127_15 VPWR VGND VPWR VGND sky130_ef_sc_hd__decap_12
X_07175_ picorv32_core.count_cycle\[37\] _03339_ _03341_ VGND VGND VPWR VPWR _00298_
+ sky130_fd_sc_hd__o21a_1
XFILLER_117_275 VGND VGND VPWR VPWR sky130_fd_sc_hd__decap_4
X_06126_ _01601_ _02577_ _02579_ VGND VGND VPWR VPWR _02581_ sky130_fd_sc_hd__a21boi_1
X_06057_ net188 _02507_ net670 VGND VGND VPWR VPWR _02517_ sky130_fd_sc_hd__o21a_1
XFILLER_87_19 VGND VGND VPWR VPWR sky130_fd_sc_hd__fill_1
Xfanout323 _05033_ VGND VGND VPWR VPWR net323 sky130_fd_sc_hd__clkbuf_8
XFILLER_99_671 VGND VGND VPWR VPWR sky130_fd_sc_hd__fill_1
Xfanout312 net313 VGND VGND VPWR VPWR net312 sky130_fd_sc_hd__buf_4
Xfanout301 _02703_ VGND VGND VPWR VPWR net301 sky130_fd_sc_hd__dlymetal6s2s_1
XFILLER_141_790 VGND VGND VPWR VPWR sky130_fd_sc_hd__decap_4
Xfanout334 net335 VGND VGND VPWR VPWR net334 sky130_fd_sc_hd__clkbuf_8
Xfanout356 net357 VGND VGND VPWR VPWR net356 sky130_fd_sc_hd__clkbuf_8
Xfanout345 _04347_ VGND VGND VPWR VPWR net345 sky130_fd_sc_hd__buf_4
Xfanout389 _04335_ VGND VGND VPWR VPWR net389 sky130_fd_sc_hd__buf_4
X_09816_ picorv32_core.reg_pc\[28\] net538 _04986_ net483 VGND VGND VPWR VPWR _04987_
+ sky130_fd_sc_hd__a211o_1
XFILLER_101_654 VGND VGND VPWR VPWR sky130_fd_sc_hd__fill_2
Xfanout367 net368 VGND VGND VPWR VPWR net367 sky130_fd_sc_hd__clkbuf_8
Xfanout378 net381 VGND VGND VPWR VPWR net378 sky130_fd_sc_hd__buf_4
X_09747_ net651 _04920_ VGND VGND VPWR VPWR _04921_ sky130_fd_sc_hd__or2_1
X_06959_ _02933_ _03157_ VGND VGND VPWR VPWR _03174_ sky130_fd_sc_hd__xor2_1
X_09678_ picorv32_core.cpuregs\[0\]\[22\] picorv32_core.cpuregs\[1\]\[22\] picorv32_core.cpuregs\[2\]\[22\]
+ picorv32_core.cpuregs\[3\]\[22\] net890 net856 VGND VGND VPWR VPWR _04855_ sky130_fd_sc_hd__mux4_1
XTAP_TAPCELL_ROW_83_1506 VGND VPWR sky130_fd_sc_hd__tapvpwrvgnd_1
XFILLER_70_711 VGND VGND VPWR VPWR sky130_fd_sc_hd__fill_1
X_08629_ net1265 net430 net390 VGND VGND VPWR VPWR _00780_ sky130_fd_sc_hd__mux2_1
X_11640_ clknet_leaf_47_clk _01471_ VGND VGND VPWR VPWR picorv32_core.cpuregs\[28\]\[21\]
+ sky130_fd_sc_hd__dfxtp_1
XTAP_TAPCELL_ROW_25_666 VGND VPWR sky130_fd_sc_hd__tapvpwrvgnd_1
X_11571_ clknet_leaf_50_clk _01402_ VGND VGND VPWR VPWR picorv32_core.cpuregs\[2\]\[18\]
+ sky130_fd_sc_hd__dfxtp_1
X_10522_ clknet_leaf_126_clk picorv32_core.alu_out\[10\] VGND VGND VPWR VPWR picorv32_core.alu_out_q\[10\]
+ sky130_fd_sc_hd__dfxtp_1
XFILLER_109_710 VGND VGND VPWR VPWR sky130_fd_sc_hd__fill_2
XFILLER_10_365 VGND VGND VPWR VPWR sky130_fd_sc_hd__fill_1
X_10453_ clknet_leaf_79_clk _00340_ VGND VGND VPWR VPWR net45 sky130_fd_sc_hd__dfxtp_1
XFILLER_6_369 VGND VGND VPWR VPWR sky130_fd_sc_hd__fill_1
XFILLER_6_336 VGND VGND VPWR VPWR sky130_fd_sc_hd__decap_4
X_10384_ clknet_leaf_101_clk _00303_ VGND VGND VPWR VPWR picorv32_core.count_cycle\[42\]
+ sky130_fd_sc_hd__dfxtp_1
XFILLER_124_757 VPWR VGND VPWR VGND sky130_ef_sc_hd__decap_12
XTAP_TAPCELL_ROW_94_1668 VGND VPWR sky130_fd_sc_hd__tapvpwrvgnd_1
XFILLER_104_470 VGND VGND VPWR VPWR sky130_fd_sc_hd__decap_6
X_11005_ clknet_leaf_31_clk _00856_ VGND VGND VPWR VPWR picorv32_core.cpuregs\[12\]\[19\]
+ sky130_fd_sc_hd__dfxtp_1
XTAP_TAPCELL_ROW_125_2123 VGND VPWR sky130_fd_sc_hd__tapvpwrvgnd_1
XTAP_TAPCELL_ROW_125_2112 VGND VPWR sky130_fd_sc_hd__tapvpwrvgnd_1
Xfanout890 net891 VGND VGND VPWR VPWR net890 sky130_fd_sc_hd__buf_4
XTAP_TAPCELL_ROW_5_380 VGND VPWR sky130_fd_sc_hd__tapvpwrvgnd_1
XFILLER_37_207 VGND VGND VPWR VPWR sky130_fd_sc_hd__decap_3
XFILLER_18_421 VGND VGND VPWR VPWR sky130_fd_sc_hd__fill_2
XFILLER_46_741 VGND VGND VPWR VPWR sky130_fd_sc_hd__fill_2
XFILLER_46_774 VGND VGND VPWR VPWR sky130_fd_sc_hd__decap_3
XFILLER_33_435 VGND VGND VPWR VPWR sky130_fd_sc_hd__fill_2
XTAP_TAPCELL_ROW_44_942 VGND VPWR sky130_fd_sc_hd__tapvpwrvgnd_1
X_11838_ net41 VGND VGND VPWR VPWR net73 sky130_fd_sc_hd__clkbuf_1
XFILLER_61_766 VGND VGND VPWR VPWR sky130_fd_sc_hd__fill_2
XTAP_TAPCELL_ROW_103_1797 VGND VPWR sky130_fd_sc_hd__tapvpwrvgnd_1
Xclkbuf_leaf_40_clk clknet_4_5_0_clk VGND VGND VPWR VPWR clknet_leaf_40_clk sky130_fd_sc_hd__clkbuf_8
XFILLER_9_130 VPWR VGND VPWR VGND sky130_ef_sc_hd__decap_12
X_05290_ picorv32_core.count_instr\[38\] net935 net943 picorv32_core.count_cycle\[38\]
+ VGND VGND VPWR VPWR _01800_ sky130_fd_sc_hd__a22o_1
XTAP_TAPCELL_ROW_136_2274 VGND VPWR sky130_fd_sc_hd__tapvpwrvgnd_1
XFILLER_115_735 VPWR VGND VPWR VGND sky130_ef_sc_hd__decap_12
X_08980_ net1250 net222 net351 VGND VGND VPWR VPWR _01152_ sky130_fd_sc_hd__mux2_1
XFILLER_102_418 VGND VGND VPWR VPWR sky130_fd_sc_hd__fill_2
XFILLER_130_749 VGND VGND VPWR VPWR sky130_fd_sc_hd__decap_6
X_07931_ picorv32_core.cpuregs\[8\]\[23\] picorv32_core.cpuregs\[9\]\[23\] picorv32_core.cpuregs\[10\]\[23\]
+ picorv32_core.cpuregs\[11\]\[23\] net757 net724 VGND VGND VPWR VPWR _04013_ sky130_fd_sc_hd__mux4_1
X_07862_ net634 _03947_ VGND VGND VPWR VPWR _03948_ sky130_fd_sc_hd__or2_1
XFILLER_68_365 VGND VGND VPWR VPWR sky130_fd_sc_hd__decap_6
XFILLER_95_173 VGND VGND VPWR VPWR sky130_fd_sc_hd__fill_1
X_09601_ _03507_ _04758_ _03504_ _03506_ VGND VGND VPWR VPWR _04781_ sky130_fd_sc_hd__a211o_1
X_06813_ _03037_ _03038_ VGND VGND VPWR VPWR _03039_ sky130_fd_sc_hd__xor2_1
XFILLER_3_93 VPWR VGND VPWR VGND sky130_ef_sc_hd__decap_12
XFILLER_113_39 VGND VGND VPWR VPWR sky130_fd_sc_hd__fill_1
X_09532_ _03494_ _03496_ _03497_ _01637_ VGND VGND VPWR VPWR _04715_ sky130_fd_sc_hd__a31o_1
X_07793_ _03872_ _03873_ net630 VGND VGND VPWR VPWR _03883_ sky130_fd_sc_hd__mux2_1
XFILLER_83_379 VGND VGND VPWR VPWR sky130_fd_sc_hd__fill_2
XFILLER_36_262 VGND VGND VPWR VPWR sky130_fd_sc_hd__decap_3
X_06744_ picorv32_core.decoded_imm_j\[5\] _02917_ VGND VGND VPWR VPWR _02975_ sky130_fd_sc_hd__nor2_1
X_06675_ _02724_ picorv32_core.reg_next_pc\[15\] net558 VGND VGND VPWR VPWR _02927_
+ sky130_fd_sc_hd__mux2_2
XTAP_TAPCELL_ROW_65_1247 VGND VPWR sky130_fd_sc_hd__tapvpwrvgnd_1
X_09463_ _04645_ _04648_ _04649_ net826 net648 VGND VGND VPWR VPWR _04650_ sky130_fd_sc_hd__a221o_1
XFILLER_24_435 VGND VGND VPWR VPWR sky130_fd_sc_hd__fill_1
X_05626_ net910 net303 _02108_ net764 net916 VGND VGND VPWR VPWR _02112_ sky130_fd_sc_hd__a32o_1
X_08414_ picorv32_core.decoded_imm\[30\] net529 net442 _04287_ VGND VGND VPWR VPWR
+ _00580_ sky130_fd_sc_hd__o22a_1
X_09394_ net835 _04578_ net825 VGND VGND VPWR VPWR _04584_ sky130_fd_sc_hd__o21a_1
X_05557_ picorv32_core.count_instr\[57\] net937 net941 picorv32_core.count_instr\[25\]
+ VGND VGND VPWR VPWR _02048_ sky130_fd_sc_hd__a22o_1
X_08345_ _01595_ net176 net451 _04245_ VGND VGND VPWR VPWR _04246_ sky130_fd_sc_hd__a211o_1
XTAP_TAPCELL_ROW_22_625 VGND VPWR sky130_fd_sc_hd__tapvpwrvgnd_1
XFILLER_138_805 VGND VGND VPWR VPWR sky130_fd_sc_hd__decap_6
Xclkbuf_leaf_31_clk clknet_4_4_0_clk VGND VGND VPWR VPWR clknet_leaf_31_clk sky130_fd_sc_hd__clkbuf_8
XFILLER_137_337 VGND VGND VPWR VPWR sky130_fd_sc_hd__decap_3
X_05488_ _01934_ _01944_ _01981_ _01983_ VGND VGND VPWR VPWR _01984_ sky130_fd_sc_hd__a31oi_1
X_08276_ net1899 net273 net410 VGND VGND VPWR VPWR _00500_ sky130_fd_sc_hd__mux2_1
X_07227_ _03374_ net994 _03373_ VGND VGND VPWR VPWR _00317_ sky130_fd_sc_hd__and3b_1
XFILLER_98_29 VGND VGND VPWR VPWR sky130_fd_sc_hd__decap_3
X_07158_ picorv32_core.count_cycle\[31\] _03329_ net976 VGND VGND VPWR VPWR _03331_
+ sky130_fd_sc_hd__a21oi_1
XFILLER_106_757 VGND VGND VPWR VPWR sky130_fd_sc_hd__decap_4
XFILLER_105_223 VGND VGND VPWR VPWR sky130_fd_sc_hd__fill_1
X_06109_ _02530_ _02546_ _02563_ _02564_ _02552_ VGND VGND VPWR VPWR _02565_ sky130_fd_sc_hd__o311a_1
X_07089_ picorv32_core.count_cycle\[4\] picorv32_core.count_cycle\[5\] _03284_ VGND
+ VGND VPWR VPWR _03288_ sky130_fd_sc_hd__and3_1
Xclkbuf_leaf_98_clk clknet_4_11_0_clk VGND VGND VPWR VPWR clknet_leaf_98_clk sky130_fd_sc_hd__clkbuf_8
XFILLER_47_505 VGND VGND VPWR VPWR sky130_fd_sc_hd__fill_2
XFILLER_101_462 VGND VGND VPWR VPWR sky130_fd_sc_hd__fill_2
XFILLER_63_32 VGND VGND VPWR VPWR sky130_fd_sc_hd__fill_1
XTAP_TAPCELL_ROW_120_2042 VGND VPWR sky130_fd_sc_hd__tapvpwrvgnd_1
XFILLER_63_87 VGND VGND VPWR VPWR sky130_fd_sc_hd__fill_2
X_11623_ clknet_leaf_111_clk _01454_ VGND VGND VPWR VPWR picorv32_core.cpuregs\[28\]\[4\]
+ sky130_fd_sc_hd__dfxtp_1
XTAP_TAPCELL_ROW_41_901 VGND VPWR sky130_fd_sc_hd__tapvpwrvgnd_1
Xclkbuf_leaf_22_clk clknet_4_4_0_clk VGND VGND VPWR VPWR clknet_leaf_22_clk sky130_fd_sc_hd__clkbuf_8
XFILLER_8_27 VGND VGND VPWR VPWR sky130_fd_sc_hd__fill_1
X_11554_ clknet_leaf_109_clk _01385_ VGND VGND VPWR VPWR picorv32_core.cpuregs\[2\]\[1\]
+ sky130_fd_sc_hd__dfxtp_1
X_10505_ clknet_leaf_61_clk _00391_ VGND VGND VPWR VPWR net197 sky130_fd_sc_hd__dfxtp_2
XFILLER_6_133 VGND VGND VPWR VPWR sky130_fd_sc_hd__decap_6
X_11485_ clknet_leaf_119_clk _01321_ VGND VGND VPWR VPWR net163 sky130_fd_sc_hd__dfxtp_1
X_10436_ clknet_leaf_76_clk _01568_ VGND VGND VPWR VPWR picorv32_core.reg_out\[29\]
+ sky130_fd_sc_hd__dfxtp_1
XFILLER_6_177 VPWR VGND VPWR VGND sky130_ef_sc_hd__decap_12
X_10367_ clknet_leaf_86_clk _00286_ VGND VGND VPWR VPWR picorv32_core.count_cycle\[25\]
+ sky130_fd_sc_hd__dfxtp_1
XFILLER_124_587 VGND VGND VPWR VPWR sky130_fd_sc_hd__fill_1
X_10298_ clknet_leaf_87_clk _00217_ VGND VGND VPWR VPWR picorv32_core.reg_pc\[19\]
+ sky130_fd_sc_hd__dfxtp_1
Xclkbuf_leaf_89_clk clknet_4_12_0_clk VGND VGND VPWR VPWR clknet_leaf_89_clk sky130_fd_sc_hd__clkbuf_8
XFILLER_120_793 VPWR VGND VPWR VGND sky130_ef_sc_hd__decap_12
XFILLER_65_335 VGND VGND VPWR VPWR sky130_fd_sc_hd__fill_1
XTAP_TAPCELL_ROW_0_309 VGND VPWR sky130_fd_sc_hd__tapvpwrvgnd_1
XFILLER_19_741 VPWR VGND VPWR VGND sky130_ef_sc_hd__decap_12
XFILLER_38_549 VGND VGND VPWR VPWR sky130_fd_sc_hd__decap_3
XFILLER_19_785 VPWR VGND VPWR VGND sky130_ef_sc_hd__decap_12
XTAP_TAPCELL_ROW_105_1826 VGND VPWR sky130_fd_sc_hd__tapvpwrvgnd_1
XFILLER_18_262 VGND VGND VPWR VPWR sky130_fd_sc_hd__decap_4
X_06460_ net236 net2061 net419 VGND VGND VPWR VPWR _00126_ sky130_fd_sc_hd__mux2_1
XTAP_TAPCELL_ROW_138_2303 VGND VPWR sky130_fd_sc_hd__tapvpwrvgnd_1
X_05411_ _01891_ _01894_ _01911_ VGND VGND VPWR VPWR _01913_ sky130_fd_sc_hd__nand3_1
X_08130_ net230 net1537 net417 VGND VGND VPWR VPWR _00423_ sky130_fd_sc_hd__mux2_1
X_06391_ picorv32_core.reg_out\[30\] picorv32_core.alu_out_q\[30\] net953 VGND VGND
+ VPWR VPWR _02787_ sky130_fd_sc_hd__mux2_1
Xclkbuf_leaf_13_clk clknet_4_3_0_clk VGND VGND VPWR VPWR clknet_leaf_13_clk sky130_fd_sc_hd__clkbuf_8
XFILLER_119_337 VGND VGND VPWR VPWR sky130_fd_sc_hd__decap_6
XPHY_EDGE_ROW_117_Left_259 VGND VGND VPWR VPWR sky130_fd_sc_hd__decap_3
XTAP_TAPCELL_ROW_60_1177 VGND VPWR sky130_fd_sc_hd__tapvpwrvgnd_1
X_05342_ net5 _01818_ VGND VGND VPWR VPWR _01848_ sky130_fd_sc_hd__or2_1
X_08061_ picorv32_core.cpuregs\[8\]\[30\] picorv32_core.cpuregs\[9\]\[30\] picorv32_core.cpuregs\[10\]\[30\]
+ picorv32_core.cpuregs\[11\]\[30\] net759 net726 VGND VGND VPWR VPWR _04136_ sky130_fd_sc_hd__mux4_1
X_05273_ net820 net8 _01718_ _01783_ VGND VGND VPWR VPWR _01784_ sky130_fd_sc_hd__o211a_1
X_07012_ _03221_ _03222_ net990 VGND VGND VPWR VPWR _00254_ sky130_fd_sc_hd__o21a_1
XFILLER_127_381 VGND VGND VPWR VPWR sky130_fd_sc_hd__decap_3
XTAP_TAPCELL_ROW_116_1988 VGND VPWR sky130_fd_sc_hd__tapvpwrvgnd_1
XFILLER_103_705 VPWR VGND VPWR VGND sky130_ef_sc_hd__decap_12
XFILLER_0_309 VGND VGND VPWR VPWR sky130_fd_sc_hd__fill_2
XFILLER_102_215 VGND VGND VPWR VPWR sky130_fd_sc_hd__fill_1
XFILLER_88_427 VPWR VGND VPWR VGND sky130_ef_sc_hd__decap_12
X_08963_ net1838 net294 net348 VGND VGND VPWR VPWR _01135_ sky130_fd_sc_hd__mux2_1
XPHY_EDGE_ROW_126_Left_268 VGND VGND VPWR VPWR sky130_fd_sc_hd__decap_3
XFILLER_124_27 VGND VGND VPWR VPWR sky130_fd_sc_hd__fill_1
X_07914_ picorv32_core.cpuregs\[16\]\[22\] picorv32_core.cpuregs\[17\]\[22\] picorv32_core.cpuregs\[18\]\[22\]
+ picorv32_core.cpuregs\[19\]\[22\] net752 net719 VGND VGND VPWR VPWR _03997_ sky130_fd_sc_hd__mux4_1
X_08894_ net429 net1446 net358 VGND VGND VPWR VPWR _01068_ sky130_fd_sc_hd__mux2_1
X_07845_ net635 _03922_ net685 VGND VGND VPWR VPWR _03932_ sky130_fd_sc_hd__o21a_1
XFILLER_84_633 VGND VGND VPWR VPWR sky130_fd_sc_hd__fill_1
XFILLER_83_110 VGND VGND VPWR VPWR sky130_fd_sc_hd__fill_2
XFILLER_68_195 VGND VGND VPWR VPWR sky130_fd_sc_hd__fill_1
XFILLER_140_15 VPWR VGND VPWR VGND sky130_ef_sc_hd__decap_12
X_07776_ _03857_ _03858_ net629 VGND VGND VPWR VPWR _03867_ sky130_fd_sc_hd__mux2_1
X_09515_ net612 _04693_ _04694_ _04698_ net488 VGND VGND VPWR VPWR _04699_ sky130_fd_sc_hd__a311o_1
XFILLER_17_69 VGND VGND VPWR VPWR sky130_fd_sc_hd__decap_6
XFILLER_25_722 VGND VGND VPWR VPWR sky130_fd_sc_hd__decap_6
X_06727_ _02914_ _02915_ VGND VGND VPWR VPWR _02960_ sky130_fd_sc_hd__and2_1
X_09446_ _03432_ _03486_ VGND VGND VPWR VPWR _04633_ sky130_fd_sc_hd__xor2_1
XFILLER_25_777 VGND VGND VPWR VPWR sky130_fd_sc_hd__decap_6
X_06658_ picorv32_core.reg_pc\[6\] net551 _02918_ net514 VGND VGND VPWR VPWR _00204_
+ sky130_fd_sc_hd__a22o_1
XPHY_EDGE_ROW_135_Left_277 VGND VGND VPWR VPWR sky130_fd_sc_hd__decap_3
X_05609_ net25 net584 net575 VGND VGND VPWR VPWR _02096_ sky130_fd_sc_hd__a21o_1
X_06589_ net2260 _02873_ net992 VGND VGND VPWR VPWR _02875_ sky130_fd_sc_hd__o21ai_1
X_09377_ _01598_ net282 VGND VGND VPWR VPWR _04567_ sky130_fd_sc_hd__nor2_1
XFILLER_33_57 VGND VGND VPWR VPWR sky130_fd_sc_hd__fill_2
X_08328_ net965 net2298 net453 VGND VGND VPWR VPWR _00545_ sky130_fd_sc_hd__mux2_1
XFILLER_33_79 VGND VGND VPWR VPWR sky130_fd_sc_hd__fill_1
X_08259_ net934 _00772_ net439 VGND VGND VPWR VPWR _00485_ sky130_fd_sc_hd__mux2_1
XFILLER_137_167 VGND VGND VPWR VPWR sky130_fd_sc_hd__fill_1
XTAP_TAPCELL_ROW_78_1438 VGND VPWR sky130_fd_sc_hd__tapvpwrvgnd_1
X_11270_ clknet_leaf_71_clk _01118_ VGND VGND VPWR VPWR picorv32_core.cpuregs\[4\]\[25\]
+ sky130_fd_sc_hd__dfxtp_1
XFILLER_109_3 VPWR VGND VPWR VGND sky130_ef_sc_hd__decap_12
XFILLER_4_637 VGND VGND VPWR VPWR sky130_fd_sc_hd__fill_1
XFILLER_3_125 VPWR VGND VPWR VGND sky130_ef_sc_hd__decap_12
XFILLER_106_576 VPWR VGND VPWR VGND sky130_ef_sc_hd__decap_12
XFILLER_106_554 VGND VGND VPWR VPWR sky130_fd_sc_hd__decap_6
XTAP_TAPCELL_ROW_91_1627 VGND VPWR sky130_fd_sc_hd__tapvpwrvgnd_1
XFILLER_79_416 VGND VGND VPWR VPWR sky130_fd_sc_hd__fill_1
X_10221_ clknet_leaf_102_clk _00140_ VGND VGND VPWR VPWR picorv32_core.count_instr\[5\]
+ sky130_fd_sc_hd__dfxtp_1
XFILLER_3_169 VPWR VGND VPWR VGND sky130_ef_sc_hd__decap_12
X_10152_ clknet_leaf_118_clk _00071_ VGND VGND VPWR VPWR picorv32_core.cpuregs\[21\]\[0\]
+ sky130_fd_sc_hd__dfxtp_1
X_10083_ net1146 VGND VGND VPWR VPWR _00933_ sky130_fd_sc_hd__clkbuf_1
XFILLER_59_140 VGND VGND VPWR VPWR sky130_fd_sc_hd__decap_4
Xhold9 picorv32_core.cpuregs\[0\]\[6\] VGND VGND VPWR VPWR net1118 sky130_fd_sc_hd__dlygate4sd3_1
XTAP_TAPCELL_ROW_89_1589 VGND VPWR sky130_fd_sc_hd__tapvpwrvgnd_1
XFILLER_74_64 VGND VGND VPWR VPWR sky130_fd_sc_hd__decap_3
XFILLER_16_733 VPWR VGND VPWR VGND sky130_ef_sc_hd__decap_12
X_10985_ clknet_leaf_62_clk _00836_ VGND VGND VPWR VPWR picorv32_core.cpuregs\[13\]\[31\]
+ sky130_fd_sc_hd__dfxtp_1
XFILLER_129_613 VGND VGND VPWR VPWR sky130_fd_sc_hd__decap_3
XTAP_TAPCELL_ROW_100_1756 VGND VPWR sky130_fd_sc_hd__tapvpwrvgnd_1
X_11606_ clknet_leaf_28_clk _01437_ VGND VGND VPWR VPWR picorv32_core.cpuregs\[23\]\[19\]
+ sky130_fd_sc_hd__dfxtp_1
X_11537_ clknet_leaf_20_clk _01368_ VGND VGND VPWR VPWR picorv32_core.cpuregs\[30\]\[18\]
+ sky130_fd_sc_hd__dfxtp_1
XTAP_TAPCELL_ROW_13_488 VGND VPWR sky130_fd_sc_hd__tapvpwrvgnd_1
XTAP_TAPCELL_ROW_13_499 VGND VPWR sky130_fd_sc_hd__tapvpwrvgnd_1
XTAP_TAPCELL_ROW_133_2233 VGND VPWR sky130_fd_sc_hd__tapvpwrvgnd_1
Xhold409 picorv32_core.cpuregs\[9\]\[25\] VGND VGND VPWR VPWR net1518 sky130_fd_sc_hd__dlygate4sd3_1
X_11468_ clknet_leaf_21_clk _01304_ VGND VGND VPWR VPWR picorv32_core.cpuregs\[24\]\[19\]
+ sky130_fd_sc_hd__dfxtp_1
XFILLER_140_811 VGND VGND VPWR VPWR sky130_fd_sc_hd__fill_1
XFILLER_99_94 VGND VGND VPWR VPWR sky130_fd_sc_hd__fill_1
X_10419_ clknet_leaf_90_clk _01550_ VGND VGND VPWR VPWR picorv32_core.reg_out\[12\]
+ sky130_fd_sc_hd__dfxtp_1
X_11399_ clknet_leaf_9_clk _01235_ VGND VGND VPWR VPWR picorv32_core.cpuregs\[31\]\[14\]
+ sky130_fd_sc_hd__dfxtp_1
XFILLER_100_708 VGND VGND VPWR VPWR sky130_fd_sc_hd__fill_1
XFILLER_98_769 VGND VGND VPWR VPWR sky130_fd_sc_hd__decap_6
Xhold1109 picorv32_core.cpuregs\[6\]\[23\] VGND VGND VPWR VPWR net2218 sky130_fd_sc_hd__dlygate4sd3_1
XFILLER_66_611 VGND VGND VPWR VPWR sky130_fd_sc_hd__decap_4
X_05960_ _02330_ _02427_ _02426_ _02424_ VGND VGND VPWR VPWR _02428_ sky130_fd_sc_hd__a211o_1
XFILLER_24_3 VPWR VGND VPWR VGND sky130_ef_sc_hd__decap_12
Xclkbuf_leaf_2_clk clknet_4_1_0_clk VGND VGND VPWR VPWR clknet_leaf_2_clk sky130_fd_sc_hd__clkbuf_8
XPHY_EDGE_ROW_119_Right_119 VGND VGND VPWR VPWR sky130_fd_sc_hd__decap_3
XFILLER_93_430 VGND VGND VPWR VPWR sky130_fd_sc_hd__fill_1
X_05891_ net607 _02195_ _02196_ net572 _02363_ VGND VGND VPWR VPWR _02364_ sky130_fd_sc_hd__a221o_1
XFILLER_65_165 VGND VGND VPWR VPWR sky130_fd_sc_hd__decap_3
XTAP_TAPCELL_ROW_49_1017 VGND VPWR sky130_fd_sc_hd__tapvpwrvgnd_1
X_07630_ net681 _03727_ net623 VGND VGND VPWR VPWR _03729_ sky130_fd_sc_hd__a21o_1
X_07561_ picorv32_core.cpuregs\[16\]\[0\] picorv32_core.cpuregs\[17\]\[0\] picorv32_core.cpuregs\[18\]\[0\]
+ picorv32_core.cpuregs\[19\]\[0\] net742 net709 VGND VGND VPWR VPWR _03666_ sky130_fd_sc_hd__mux4_1
X_06512_ picorv32_core.count_instr\[16\] _02824_ VGND VGND VPWR VPWR _02826_ sky130_fd_sc_hd__nand2_1
X_09300_ picorv32_core.cpuregs\[24\]\[5\] picorv32_core.cpuregs\[25\]\[5\] picorv32_core.cpuregs\[26\]\[5\]
+ picorv32_core.cpuregs\[27\]\[5\] net875 net842 VGND VGND VPWR VPWR _04494_ sky130_fd_sc_hd__mux4_1
XFILLER_34_552 VGND VGND VPWR VPWR sky130_fd_sc_hd__fill_2
XFILLER_110_29 VGND VGND VPWR VPWR sky130_fd_sc_hd__decap_3
X_07492_ net788 _03615_ net533 VGND VGND VPWR VPWR _03616_ sky130_fd_sc_hd__mux2_1
XTAP_TAPCELL_ROW_62_1206 VGND VPWR sky130_fd_sc_hd__tapvpwrvgnd_1
XFILLER_61_382 VGND VGND VPWR VPWR sky130_fd_sc_hd__fill_2
X_06443_ net445 net2168 net418 VGND VGND VPWR VPWR _00109_ sky130_fd_sc_hd__mux2_1
XFILLER_22_769 VPWR VGND VPWR VGND sky130_ef_sc_hd__decap_12
X_09231_ net485 net479 _04420_ _04424_ _04427_ VGND VGND VPWR VPWR _04428_ sky130_fd_sc_hd__a311o_1
X_06374_ net1895 net226 net435 VGND VGND VPWR VPWR _00065_ sky130_fd_sc_hd__mux2_1
XFILLER_9_81 VPWR VGND VPWR VGND sky130_ef_sc_hd__decap_12
X_09162_ net835 _04360_ VGND VGND VPWR VPWR _04361_ sky130_fd_sc_hd__nor2_1
XTAP_TAPCELL_ROW_32_764 VGND VPWR sky130_fd_sc_hd__tapvpwrvgnd_1
XTAP_TAPCELL_ROW_32_775 VGND VPWR sky130_fd_sc_hd__tapvpwrvgnd_1
XFILLER_119_27 VGND VGND VPWR VPWR sky130_fd_sc_hd__decap_3
X_05325_ _01804_ _01809_ _01831_ VGND VGND VPWR VPWR _01833_ sky130_fd_sc_hd__o21ai_1
X_08113_ net428 net1868 net414 VGND VGND VPWR VPWR _00406_ sky130_fd_sc_hd__mux2_1
XFILLER_119_38 VGND VGND VPWR VPWR sky130_fd_sc_hd__fill_1
X_09093_ net429 net1952 net332 VGND VGND VPWR VPWR _01260_ sky130_fd_sc_hd__mux2_1
X_08044_ _04114_ _04115_ net639 VGND VGND VPWR VPWR _04120_ sky130_fd_sc_hd__mux2_1
Xhold921 picorv32_core.cpuregs\[8\]\[14\] VGND VGND VPWR VPWR net2030 sky130_fd_sc_hd__dlygate4sd3_1
Xhold910 picorv32_core.cpuregs\[21\]\[17\] VGND VGND VPWR VPWR net2019 sky130_fd_sc_hd__dlygate4sd3_1
X_05256_ _01752_ _01754_ _01753_ VGND VGND VPWR VPWR _01768_ sky130_fd_sc_hd__a21bo_1
Xhold932 picorv32_core.cpuregs\[9\]\[31\] VGND VGND VPWR VPWR net2041 sky130_fd_sc_hd__dlygate4sd3_1
Xhold943 picorv32_core.cpuregs\[29\]\[5\] VGND VGND VPWR VPWR net2052 sky130_fd_sc_hd__dlygate4sd3_1
Xhold954 net137 VGND VGND VPWR VPWR net2063 sky130_fd_sc_hd__dlygate4sd3_1
X_05187_ net924 _01702_ _01708_ VGND VGND VPWR VPWR _01709_ sky130_fd_sc_hd__a21oi_1
Xhold998 picorv32_core.cpuregs\[13\]\[27\] VGND VGND VPWR VPWR net2107 sky130_fd_sc_hd__dlygate4sd3_1
XFILLER_135_15 VPWR VGND VPWR VGND sky130_ef_sc_hd__decap_12
Xhold987 picorv32_core.cpuregs\[27\]\[31\] VGND VGND VPWR VPWR net2096 sky130_fd_sc_hd__dlygate4sd3_1
Xhold965 picorv32_core.cpuregs\[25\]\[14\] VGND VGND VPWR VPWR net2074 sky130_fd_sc_hd__dlygate4sd3_1
XTAP_TAPCELL_ROW_73_1357 VGND VPWR sky130_fd_sc_hd__tapvpwrvgnd_1
XFILLER_1_629 VPWR VGND VPWR VGND sky130_ef_sc_hd__decap_12
Xhold976 picorv32_core.cpuregs\[8\]\[10\] VGND VGND VPWR VPWR net2085 sky130_fd_sc_hd__dlygate4sd3_1
XFILLER_103_557 VGND VGND VPWR VPWR sky130_fd_sc_hd__decap_3
X_09995_ net1879 net242 net314 VGND VGND VPWR VPWR _01472_ sky130_fd_sc_hd__mux2_1
XFILLER_89_769 VGND VGND VPWR VPWR sky130_fd_sc_hd__decap_4
XTAP_TAPCELL_ROW_73_1368 VGND VPWR sky130_fd_sc_hd__tapvpwrvgnd_1
X_08946_ net227 net1658 net356 VGND VGND VPWR VPWR _01119_ sky130_fd_sc_hd__mux2_1
XFILLER_130_365 VGND VGND VPWR VPWR sky130_fd_sc_hd__fill_2
X_08877_ net238 net2218 net363 VGND VGND VPWR VPWR _01052_ sky130_fd_sc_hd__mux2_1
XFILLER_56_121 VGND VGND VPWR VPWR sky130_fd_sc_hd__fill_2
XFILLER_29_346 VGND VGND VPWR VPWR sky130_fd_sc_hd__fill_2
X_07828_ _03906_ _03914_ _03915_ net620 net689 VGND VGND VPWR VPWR _03916_ sky130_fd_sc_hd__a221o_1
XFILLER_45_806 VGND VGND VPWR VPWR sky130_fd_sc_hd__fill_1
X_07759_ _03846_ _03847_ net630 VGND VGND VPWR VPWR _03851_ sky130_fd_sc_hd__mux2_1
X_10770_ clknet_leaf_11_clk _00621_ VGND VGND VPWR VPWR picorv32_core.cpuregs\[14\]\[11\]
+ sky130_fd_sc_hd__dfxtp_1
XFILLER_13_725 VGND VGND VPWR VPWR sky130_fd_sc_hd__decap_3
XFILLER_40_533 VGND VGND VPWR VPWR sky130_fd_sc_hd__fill_1
X_09429_ picorv32_core.cpuregs\[8\]\[11\] picorv32_core.cpuregs\[9\]\[11\] picorv32_core.cpuregs\[10\]\[11\]
+ picorv32_core.cpuregs\[11\]\[11\] net880 net847 VGND VGND VPWR VPWR _04617_ sky130_fd_sc_hd__mux4_1
XFILLER_9_729 VPWR VGND VPWR VGND sky130_ef_sc_hd__decap_12
XTAP_TAPCELL_ROW_10_447 VGND VPWR sky130_fd_sc_hd__tapvpwrvgnd_1
XFILLER_119_690 VGND VGND VPWR VPWR sky130_fd_sc_hd__decap_4
X_11322_ clknet_leaf_141_clk _01163_ VGND VGND VPWR VPWR picorv32_core.cpuregs\[29\]\[6\]
+ sky130_fd_sc_hd__dfxtp_1
X_11253_ clknet_leaf_130_clk _01101_ VGND VGND VPWR VPWR picorv32_core.cpuregs\[4\]\[8\]
+ sky130_fd_sc_hd__dfxtp_1
XFILLER_122_811 VGND VGND VPWR VPWR sky130_fd_sc_hd__fill_1
X_10204_ clknet_leaf_21_clk _00123_ VGND VGND VPWR VPWR picorv32_core.cpuregs\[9\]\[20\]
+ sky130_fd_sc_hd__dfxtp_1
X_11184_ clknet_leaf_143_clk _01035_ VGND VGND VPWR VPWR picorv32_core.cpuregs\[6\]\[6\]
+ sky130_fd_sc_hd__dfxtp_1
X_10135_ clknet_leaf_50_clk _00057_ VGND VGND VPWR VPWR picorv32_core.cpuregs\[22\]\[18\]
+ sky130_fd_sc_hd__dfxtp_1
XFILLER_0_673 VGND VGND VPWR VPWR sky130_fd_sc_hd__fill_2
X_10066_ net2088 net224 net306 VGND VGND VPWR VPWR _01541_ sky130_fd_sc_hd__mux2_1
XFILLER_90_455 VGND VGND VPWR VPWR sky130_fd_sc_hd__decap_4
XFILLER_90_444 VGND VGND VPWR VPWR sky130_fd_sc_hd__fill_2
X_10968_ clknet_leaf_24_clk _00819_ VGND VGND VPWR VPWR picorv32_core.cpuregs\[13\]\[14\]
+ sky130_fd_sc_hd__dfxtp_1
XTAP_TAPCELL_ROW_18_569 VGND VPWR sky130_fd_sc_hd__tapvpwrvgnd_1
XFILLER_31_577 VGND VGND VPWR VPWR sky130_fd_sc_hd__fill_1
X_10899_ clknet_leaf_106_clk _00750_ VGND VGND VPWR VPWR picorv32_core.mem_rdata_q\[9\]
+ sky130_fd_sc_hd__dfxtp_1
XFILLER_117_605 VGND VGND VPWR VPWR sky130_fd_sc_hd__fill_2
X_05110_ picorv32_core.instr_lhu picorv32_core.instr_lw picorv32_core.instr_lh _01641_
+ VGND VGND VPWR VPWR _01642_ sky130_fd_sc_hd__or4_1
XFILLER_116_126 VGND VGND VPWR VPWR sky130_fd_sc_hd__fill_1
Xhold217 picorv32_core.cpuregs\[27\]\[22\] VGND VGND VPWR VPWR net1326 sky130_fd_sc_hd__dlygate4sd3_1
X_06090_ _02545_ _02547_ VGND VGND VPWR VPWR _02548_ sky130_fd_sc_hd__nand2_1
Xhold206 picorv32_core.cpuregs\[14\]\[12\] VGND VGND VPWR VPWR net1315 sky130_fd_sc_hd__dlygate4sd3_1
Xhold239 picorv32_core.cpuregs\[14\]\[29\] VGND VGND VPWR VPWR net1348 sky130_fd_sc_hd__dlygate4sd3_1
Xhold228 picorv32_core.cpuregs\[20\]\[4\] VGND VGND VPWR VPWR net1337 sky130_fd_sc_hd__dlygate4sd3_1
XTAP_TAPCELL_ROW_113_1947 VGND VPWR sky130_fd_sc_hd__tapvpwrvgnd_1
Xfanout719 net721 VGND VGND VPWR VPWR net719 sky130_fd_sc_hd__clkbuf_4
X_08800_ net278 net2129 net370 VGND VGND VPWR VPWR _00978_ sky130_fd_sc_hd__mux2_1
Xfanout708 net713 VGND VGND VPWR VPWR net708 sky130_fd_sc_hd__buf_2
X_09780_ picorv32_core.cpuregs\[16\]\[27\] picorv32_core.cpuregs\[17\]\[27\] picorv32_core.cpuregs\[18\]\[27\]
+ picorv32_core.cpuregs\[19\]\[27\] net898 net864 VGND VGND VPWR VPWR _04952_ sky130_fd_sc_hd__mux4_1
XFILLER_100_516 VGND VGND VPWR VPWR sky130_fd_sc_hd__decap_3
X_06992_ _02935_ _03185_ _02936_ VGND VGND VPWR VPWR _03204_ sky130_fd_sc_hd__a21oi_1
XFILLER_86_717 VGND VGND VPWR VPWR sky130_fd_sc_hd__decap_3
XTAP_TAPCELL_ROW_55_1098 VGND VPWR sky130_fd_sc_hd__tapvpwrvgnd_1
XPHY_EDGE_ROW_7_Right_7 VGND VGND VPWR VPWR sky130_fd_sc_hd__decap_3
X_05943_ net178 _02331_ _02374_ _02399_ VGND VGND VPWR VPWR _02412_ sky130_fd_sc_hd__or4_1
X_08731_ net1842 net296 net378 VGND VGND VPWR VPWR _00879_ sky130_fd_sc_hd__mux2_1
X_08662_ net431 net1587 net386 VGND VGND VPWR VPWR _00812_ sky130_fd_sc_hd__mux2_1
XFILLER_39_655 VGND VGND VPWR VPWR sky130_fd_sc_hd__fill_1
XFILLER_66_496 VGND VGND VPWR VPWR sky130_fd_sc_hd__fill_1
X_05874_ net803 net959 net573 VGND VGND VPWR VPWR _02349_ sky130_fd_sc_hd__a21oi_1
X_07613_ picorv32_core.decoded_imm\[5\] net590 net594 VGND VGND VPWR VPWR _03713_
+ sky130_fd_sc_hd__a21o_1
XFILLER_121_39 VGND VGND VPWR VPWR sky130_fd_sc_hd__fill_1
XFILLER_19_390 VGND VGND VPWR VPWR sky130_fd_sc_hd__fill_2
X_08593_ net299 net2110 net394 VGND VGND VPWR VPWR _00716_ sky130_fd_sc_hd__mux2_1
XTAP_TAPCELL_ROW_37_845 VGND VPWR sky130_fd_sc_hd__tapvpwrvgnd_1
X_07544_ _03649_ _03651_ VGND VGND VPWR VPWR _03652_ sky130_fd_sc_hd__nand2_1
X_07475_ net1728 _03604_ net464 VGND VGND VPWR VPWR _00335_ sky130_fd_sc_hd__mux2_1
XFILLER_14_26 VGND VGND VPWR VPWR sky130_fd_sc_hd__fill_2
X_06426_ net239 net1874 net425 VGND VGND VPWR VPWR _00094_ sky130_fd_sc_hd__mux2_1
XFILLER_139_229 VGND VGND VPWR VPWR sky130_fd_sc_hd__fill_1
X_09214_ picorv32_core.cpuregs\[24\]\[2\] picorv32_core.cpuregs\[25\]\[2\] picorv32_core.cpuregs\[26\]\[2\]
+ picorv32_core.cpuregs\[27\]\[2\] net876 net843 VGND VGND VPWR VPWR _04411_ sky130_fd_sc_hd__mux4_1
XFILLER_22_555 VGND VGND VPWR VPWR sky130_fd_sc_hd__decap_8
X_09145_ net1661 net225 net330 VGND VGND VPWR VPWR _01311_ sky130_fd_sc_hd__mux2_1
XFILLER_108_627 VGND VGND VPWR VPWR sky130_fd_sc_hd__decap_4
X_06357_ _02758_ _02759_ net564 VGND VGND VPWR VPWR _02760_ sky130_fd_sc_hd__mux2_2
X_09076_ net1746 net236 net338 VGND VGND VPWR VPWR _01244_ sky130_fd_sc_hd__mux2_1
X_06288_ picorv32_core.reg_out\[10\] picorv32_core.alu_out_q\[10\] net951 VGND VGND
+ VPWR VPWR _02704_ sky130_fd_sc_hd__mux2_1
X_05308_ net909 _01813_ _01816_ _01810_ VGND VGND VPWR VPWR _01576_ sky130_fd_sc_hd__a211o_1
X_08027_ net695 _04100_ _04099_ net621 VGND VGND VPWR VPWR _04104_ sky130_fd_sc_hd__o211a_1
X_05239_ picorv32_core.reg_pc\[1\] picorv32_core.decoded_imm\[1\] _01744_ _01742_
+ VGND VGND VPWR VPWR _01752_ sky130_fd_sc_hd__a31o_1
Xhold762 picorv32_core.cpuregs\[16\]\[20\] VGND VGND VPWR VPWR net1871 sky130_fd_sc_hd__dlygate4sd3_1
XFILLER_89_500 VGND VGND VPWR VPWR sky130_fd_sc_hd__decap_4
Xhold740 picorv32_core.cpuregs\[23\]\[13\] VGND VGND VPWR VPWR net1849 sky130_fd_sc_hd__dlygate4sd3_1
Xhold751 picorv32_core.cpuregs\[27\]\[1\] VGND VGND VPWR VPWR net1860 sky130_fd_sc_hd__dlygate4sd3_1
Xhold773 picorv32_core.cpuregs\[9\]\[10\] VGND VGND VPWR VPWR net1882 sky130_fd_sc_hd__dlygate4sd3_1
Xhold784 picorv32_core.cpuregs\[18\]\[31\] VGND VGND VPWR VPWR net1893 sky130_fd_sc_hd__dlygate4sd3_1
Xhold795 picorv32_core.cpuregs\[10\]\[9\] VGND VGND VPWR VPWR net1904 sky130_fd_sc_hd__dlygate4sd3_1
XFILLER_89_588 VGND VGND VPWR VPWR sky130_fd_sc_hd__decap_4
X_09978_ net1535 net450 net312 VGND VGND VPWR VPWR _01455_ sky130_fd_sc_hd__mux2_1
X_08929_ net298 net1962 net354 VGND VGND VPWR VPWR _01102_ sky130_fd_sc_hd__mux2_1
XFILLER_84_271 VGND VGND VPWR VPWR sky130_fd_sc_hd__decap_6
XFILLER_55_22 VGND VGND VPWR VPWR sky130_fd_sc_hd__fill_1
XFILLER_29_187 VGND VGND VPWR VPWR sky130_fd_sc_hd__decap_3
XTAP_TAPCELL_ROW_86_1559 VGND VPWR sky130_fd_sc_hd__tapvpwrvgnd_1
XTAP_TAPCELL_ROW_86_1548 VGND VPWR sky130_fd_sc_hd__tapvpwrvgnd_1
XFILLER_17_349 VGND VGND VPWR VPWR sky130_fd_sc_hd__fill_2
XFILLER_33_809 VGND VGND VPWR VPWR sky130_fd_sc_hd__decap_6
X_10822_ clknet_leaf_62_clk _00673_ VGND VGND VPWR VPWR picorv32_core.cpuregs\[15\]\[31\]
+ sky130_fd_sc_hd__dfxtp_1
XFILLER_72_477 VGND VGND VPWR VPWR sky130_fd_sc_hd__decap_8
XFILLER_60_617 VGND VGND VPWR VPWR sky130_fd_sc_hd__fill_1
XTAP_TAPCELL_ROW_15_517 VGND VPWR sky130_fd_sc_hd__tapvpwrvgnd_1
XTAP_TAPCELL_ROW_15_528 VGND VPWR sky130_fd_sc_hd__tapvpwrvgnd_1
XFILLER_25_393 VGND VGND VPWR VPWR sky130_fd_sc_hd__fill_1
X_10753_ clknet_leaf_94_clk _00604_ VGND VGND VPWR VPWR picorv32_core.decoded_imm\[6\]
+ sky130_fd_sc_hd__dfxtp_2
XFILLER_139_741 VPWR VGND VPWR VGND sky130_ef_sc_hd__decap_12
XTAP_TAPCELL_ROW_117_2003 VGND VPWR sky130_fd_sc_hd__tapvpwrvgnd_1
X_10684_ clknet_leaf_94_clk _00537_ VGND VGND VPWR VPWR picorv32_core.is_sll_srl_sra
+ sky130_fd_sc_hd__dfxtp_1
XFILLER_9_559 VGND VGND VPWR VPWR sky130_fd_sc_hd__fill_1
XFILLER_40_385 VGND VGND VPWR VPWR sky130_fd_sc_hd__decap_8
XFILLER_139_785 VPWR VGND VPWR VGND sky130_ef_sc_hd__decap_12
XFILLER_5_721 VGND VGND VPWR VPWR sky130_fd_sc_hd__decap_6
X_11305_ clknet_leaf_37_clk _01153_ VGND VGND VPWR VPWR picorv32_core.cpuregs\[3\]\[28\]
+ sky130_fd_sc_hd__dfxtp_1
XFILLER_114_619 VGND VGND VPWR VPWR sky130_fd_sc_hd__decap_3
XFILLER_5_765 VPWR VGND VPWR VGND sky130_ef_sc_hd__decap_12
XFILLER_107_682 VGND VGND VPWR VPWR sky130_fd_sc_hd__decap_3
X_11236_ clknet_leaf_64_clk _01087_ VGND VGND VPWR VPWR picorv32_core.cpuregs\[5\]\[26\]
+ sky130_fd_sc_hd__dfxtp_1
XFILLER_134_490 VGND VGND VPWR VPWR sky130_fd_sc_hd__decap_4
X_11167_ clknet_leaf_50_clk _01018_ VGND VGND VPWR VPWR picorv32_core.cpuregs\[7\]\[21\]
+ sky130_fd_sc_hd__dfxtp_1
XFILLER_95_503 VGND VGND VPWR VPWR sky130_fd_sc_hd__fill_1
XFILLER_0_481 VGND VGND VPWR VPWR sky130_fd_sc_hd__fill_1
X_10118_ clknet_leaf_113_clk _00040_ VGND VGND VPWR VPWR picorv32_core.cpuregs\[22\]\[1\]
+ sky130_fd_sc_hd__dfxtp_1
XTAP_TAPCELL_ROW_128_2165 VGND VPWR sky130_fd_sc_hd__tapvpwrvgnd_1
XTAP_TAPCELL_ROW_128_2154 VGND VPWR sky130_fd_sc_hd__tapvpwrvgnd_1
X_11098_ clknet_leaf_21_clk _00949_ VGND VGND VPWR VPWR picorv32_core.cpuregs\[0\]\[16\]
+ sky130_fd_sc_hd__dfxtp_1
XFILLER_48_430 VGND VGND VPWR VPWR sky130_fd_sc_hd__decap_3
X_10049_ net1278 net297 net304 VGND VGND VPWR VPWR _01524_ sky130_fd_sc_hd__mux2_1
XTAP_TAPCELL_ROW_141_2354 VGND VPWR sky130_fd_sc_hd__tapvpwrvgnd_1
XTAP_TAPCELL_ROW_141_2343 VGND VPWR sky130_fd_sc_hd__tapvpwrvgnd_1
XFILLER_35_124 VGND VGND VPWR VPWR sky130_fd_sc_hd__fill_2
XTAP_TAPCELL_ROW_141_2365 VGND VPWR sky130_fd_sc_hd__tapvpwrvgnd_1
X_05590_ _02054_ _02064_ _02065_ VGND VGND VPWR VPWR _02078_ sky130_fd_sc_hd__o21a_1
XFILLER_51_617 VGND VGND VPWR VPWR sky130_fd_sc_hd__decap_8
XFILLER_51_606 VGND VGND VPWR VPWR sky130_fd_sc_hd__decap_8
XTAP_TAPCELL_ROW_34_804 VGND VPWR sky130_fd_sc_hd__tapvpwrvgnd_1
X_07260_ net162 picorv32_core.decoded_imm\[29\] VGND VGND VPWR VPWR _03400_ sky130_fd_sc_hd__and2_1
XFILLER_117_402 VGND VGND VPWR VPWR sky130_fd_sc_hd__fill_1
X_07191_ net2353 _03349_ _03351_ VGND VGND VPWR VPWR _00304_ sky130_fd_sc_hd__o21a_1
X_06211_ _02641_ picorv32_core.decoded_imm_j\[3\] picorv32_core.is_slli_srli_srai
+ VGND VGND VPWR VPWR _02642_ sky130_fd_sc_hd__mux2_1
XFILLER_117_424 VGND VGND VPWR VPWR sky130_fd_sc_hd__decap_6
X_06142_ _01602_ _02586_ _02588_ VGND VGND VPWR VPWR _02595_ sky130_fd_sc_hd__o21ai_1
XFILLER_105_608 VGND VGND VPWR VPWR sky130_fd_sc_hd__decap_8
X_06073_ _02529_ _02531_ VGND VGND VPWR VPWR _02532_ sky130_fd_sc_hd__nand2_1
XTAP_TAPCELL_ROW_57_1127 VGND VPWR sky130_fd_sc_hd__tapvpwrvgnd_1
XTAP_TAPCELL_ROW_57_1138 VGND VPWR sky130_fd_sc_hd__tapvpwrvgnd_1
X_09901_ net500 net1896 net321 VGND VGND VPWR VPWR _01385_ sky130_fd_sc_hd__mux2_1
Xfanout505 _02670_ VGND VGND VPWR VPWR net505 sky130_fd_sc_hd__dlymetal6s2s_1
X_09832_ _04993_ _04994_ _04998_ _04999_ net661 net647 VGND VGND VPWR VPWR _05002_
+ sky130_fd_sc_hd__mux4_1
Xfanout516 net517 VGND VGND VPWR VPWR net516 sky130_fd_sc_hd__clkbuf_4
Xfanout538 net539 VGND VGND VPWR VPWR net538 sky130_fd_sc_hd__buf_2
XTAP_TAPCELL_ROW_70_1327 VGND VPWR sky130_fd_sc_hd__tapvpwrvgnd_1
XTAP_TAPCELL_ROW_70_1316 VGND VPWR sky130_fd_sc_hd__tapvpwrvgnd_1
Xfanout527 _04177_ VGND VGND VPWR VPWR net527 sky130_fd_sc_hd__buf_2
X_09763_ picorv32_core.cpuregs\[28\]\[26\] picorv32_core.cpuregs\[29\]\[26\] picorv32_core.cpuregs\[30\]\[26\]
+ picorv32_core.cpuregs\[31\]\[26\] net902 net868 VGND VGND VPWR VPWR _04936_ sky130_fd_sc_hd__mux4_1
XFILLER_132_27 VGND VGND VPWR VPWR sky130_fd_sc_hd__fill_1
X_08714_ net1544 net226 net385 VGND VGND VPWR VPWR _00863_ sky130_fd_sc_hd__mux2_1
X_06975_ net666 picorv32_core.reg_next_pc\[22\] _02934_ net489 VGND VGND VPWR VPWR
+ _03189_ sky130_fd_sc_hd__a22o_1
X_09694_ net470 _04804_ _04869_ _04868_ VGND VGND VPWR VPWR _04870_ sky130_fd_sc_hd__a31o_1
X_05926_ net795 net177 net568 VGND VGND VPWR VPWR _02397_ sky130_fd_sc_hd__and3_1
XFILLER_39_485 VGND VGND VPWR VPWR sky130_fd_sc_hd__decap_8
X_08645_ net1991 net238 net393 VGND VGND VPWR VPWR _00796_ sky130_fd_sc_hd__mux2_1
X_05857_ net960 _02332_ VGND VGND VPWR VPWR _02333_ sky130_fd_sc_hd__xnor2_1
XFILLER_15_809 VPWR VGND VPWR VGND sky130_ef_sc_hd__decap_12
X_08576_ net223 net2067 net400 VGND VGND VPWR VPWR _00701_ sky130_fd_sc_hd__mux2_1
XTAP_TAPCELL_ROW_68_1289 VGND VPWR sky130_fd_sc_hd__tapvpwrvgnd_1
X_07527_ picorv32_core.reg_out\[29\] picorv32_core.reg_next_pc\[29\] net559 VGND VGND
+ VPWR VPWR _03639_ sky130_fd_sc_hd__mux2_1
X_05788_ _02131_ _02260_ _02259_ VGND VGND VPWR VPWR _02270_ sky130_fd_sc_hd__a21o_1
XTAP_TAPCELL_ROW_81_1478 VGND VPWR sky130_fd_sc_hd__tapvpwrvgnd_1
XFILLER_50_683 VGND VGND VPWR VPWR sky130_fd_sc_hd__decap_3
X_07458_ picorv32_core.reg_out\[6\] picorv32_core.reg_next_pc\[6\] net555 VGND VGND
+ VPWR VPWR _03593_ sky130_fd_sc_hd__mux2_1
X_07389_ _03525_ _03527_ _03409_ _03410_ VGND VGND VPWR VPWR _03529_ sky130_fd_sc_hd__o211a_1
X_06409_ net444 net1944 net422 VGND VGND VPWR VPWR _00077_ sky130_fd_sc_hd__mux2_1
XFILLER_108_413 VGND VGND VPWR VPWR sky130_fd_sc_hd__decap_6
X_09128_ net1572 net301 net328 VGND VGND VPWR VPWR _01294_ sky130_fd_sc_hd__mux2_1
XFILLER_136_755 VGND VGND VPWR VPWR sky130_fd_sc_hd__fill_1
XTAP_TAPCELL_ROW_20_597 VGND VPWR sky130_fd_sc_hd__tapvpwrvgnd_1
XFILLER_2_713 VPWR VGND VPWR VGND sky130_ef_sc_hd__decap_12
X_09059_ net1584 net446 net336 VGND VGND VPWR VPWR _01227_ sky130_fd_sc_hd__mux2_1
Xhold581 picorv32_core.cpuregs\[21\]\[22\] VGND VGND VPWR VPWR net1690 sky130_fd_sc_hd__dlygate4sd3_1
Xhold570 picorv32_core.cpuregs\[30\]\[15\] VGND VGND VPWR VPWR net1679 sky130_fd_sc_hd__dlygate4sd3_1
XFILLER_2_757 VPWR VGND VPWR VGND sky130_ef_sc_hd__decap_12
XFILLER_1_223 VGND VGND VPWR VPWR sky130_fd_sc_hd__fill_1
Xhold592 picorv32_core.cpuregs\[23\]\[26\] VGND VGND VPWR VPWR net1701 sky130_fd_sc_hd__dlygate4sd3_1
X_11021_ clknet_leaf_135_clk _00872_ VGND VGND VPWR VPWR picorv32_core.cpuregs\[11\]\[3\]
+ sky130_fd_sc_hd__dfxtp_1
XFILLER_2_18 VGND VGND VPWR VPWR sky130_fd_sc_hd__decap_8
XFILLER_2_29 VPWR VGND VPWR VGND sky130_ef_sc_hd__decap_12
X_11854_ net57 VGND VGND VPWR VPWR net89 sky130_fd_sc_hd__clkbuf_1
XFILLER_60_414 VGND VGND VPWR VPWR sky130_fd_sc_hd__decap_6
XFILLER_33_617 VGND VGND VPWR VPWR sky130_fd_sc_hd__fill_1
XTAP_TAPCELL_ROW_123_2095 VGND VPWR sky130_fd_sc_hd__tapvpwrvgnd_1
XTAP_TAPCELL_ROW_123_2084 VGND VPWR sky130_fd_sc_hd__tapvpwrvgnd_1
XFILLER_82_53 VGND VGND VPWR VPWR sky130_fd_sc_hd__decap_4
X_10805_ clknet_leaf_25_clk _00656_ VGND VGND VPWR VPWR picorv32_core.cpuregs\[15\]\[14\]
+ sky130_fd_sc_hd__dfxtp_1
X_10736_ clknet_leaf_89_clk _00587_ VGND VGND VPWR VPWR picorv32_core.decoded_imm\[23\]
+ sky130_fd_sc_hd__dfxtp_2
XTAP_TAPCELL_ROW_99_1739 VGND VPWR sky130_fd_sc_hd__tapvpwrvgnd_1
X_10667_ clknet_leaf_106_clk _00521_ VGND VGND VPWR VPWR picorv32_core.decoded_rd\[3\]
+ sky130_fd_sc_hd__dfxtp_1
XFILLER_40_193 VGND VGND VPWR VPWR sky130_fd_sc_hd__decap_3
XFILLER_127_722 VGND VGND VPWR VPWR sky130_fd_sc_hd__decap_6
X_10598_ clknet_leaf_107_clk _00452_ VGND VGND VPWR VPWR picorv32_core.latched_rd\[0\]
+ sky130_fd_sc_hd__dfxtp_1
XFILLER_126_287 VGND VGND VPWR VPWR sky130_fd_sc_hd__decap_4
Xoutput119 net119 VGND VGND VPWR VPWR mem_axi_wdata[23] sky130_fd_sc_hd__buf_2
Xoutput108 net108 VGND VGND VPWR VPWR mem_axi_wdata[13] sky130_fd_sc_hd__buf_2
XTAP_TAPCELL_ROW_110_1906 VGND VPWR sky130_fd_sc_hd__tapvpwrvgnd_1
XFILLER_141_279 VGND VGND VPWR VPWR sky130_fd_sc_hd__fill_1
XFILLER_141_257 VGND VGND VPWR VPWR sky130_fd_sc_hd__fill_1
X_11219_ clknet_leaf_144_clk _01070_ VGND VGND VPWR VPWR picorv32_core.cpuregs\[5\]\[9\]
+ sky130_fd_sc_hd__dfxtp_1
Xoutput90 net90 VGND VGND VPWR VPWR mem_axi_awaddr[29] sky130_fd_sc_hd__buf_2
XTAP_TAPCELL_ROW_52_1057 VGND VPWR sky130_fd_sc_hd__tapvpwrvgnd_1
XFILLER_49_783 VGND VGND VPWR VPWR sky130_fd_sc_hd__fill_1
X_06760_ picorv32_core.decoded_imm_j\[6\] _02918_ VGND VGND VPWR VPWR _02990_ sky130_fd_sc_hd__nand2_1
X_06691_ _02758_ picorv32_core.reg_next_pc\[23\] net561 VGND VGND VPWR VPWR _02935_
+ sky130_fd_sc_hd__mux2_2
X_05711_ net799 net175 VGND VGND VPWR VPWR _02195_ sky130_fd_sc_hd__or2_1
XTAP_TAPCELL_ROW_108_1868 VGND VPWR sky130_fd_sc_hd__tapvpwrvgnd_1
X_08430_ net2354 net528 net442 _04295_ VGND VGND VPWR VPWR _00588_ sky130_fd_sc_hd__o22a_1
X_05642_ net811 net964 VGND VGND VPWR VPWR _02126_ sky130_fd_sc_hd__xnor2_1
XTAP_TAPCELL_ROW_47_984 VGND VPWR sky130_fd_sc_hd__tapvpwrvgnd_1
XFILLER_51_447 VGND VGND VPWR VPWR sky130_fd_sc_hd__fill_1
X_05573_ net912 net302 _02058_ _02062_ VGND VGND VPWR VPWR _02063_ sky130_fd_sc_hd__a31o_1
X_08361_ net1176 _04255_ net454 VGND VGND VPWR VPWR _00559_ sky130_fd_sc_hd__mux2_1
X_08292_ net1322 net212 net413 VGND VGND VPWR VPWR _00516_ sky130_fd_sc_hd__mux2_1
X_07312_ _03450_ _03451_ VGND VGND VPWR VPWR _03452_ sky130_fd_sc_hd__and2_1
X_07243_ picorv32_core.count_cycle\[61\] picorv32_core.count_cycle\[62\] _03380_ picorv32_core.count_cycle\[63\]
+ VGND VGND VPWR VPWR _03384_ sky130_fd_sc_hd__a31o_1
XFILLER_118_755 VGND VGND VPWR VPWR sky130_fd_sc_hd__fill_1
X_07174_ picorv32_core.count_cycle\[37\] _03339_ net973 VGND VGND VPWR VPWR _03341_
+ sky130_fd_sc_hd__a21oi_1
XFILLER_127_27 VPWR VGND VPWR VGND sky130_ef_sc_hd__decap_12
X_06125_ _01601_ _02577_ VGND VGND VPWR VPWR _02580_ sky130_fd_sc_hd__and2_1
XFILLER_105_449 VGND VGND VPWR VPWR sky130_fd_sc_hd__fill_1
X_06056_ net507 _02513_ _02514_ _02516_ VGND VGND VPWR VPWR picorv32_core.alu_out\[23\]
+ sky130_fd_sc_hd__a31o_1
XFILLER_120_419 VGND VGND VPWR VPWR sky130_fd_sc_hd__fill_1
Xfanout302 net303 VGND VGND VPWR VPWR net302 sky130_fd_sc_hd__buf_2
XFILLER_59_503 VGND VGND VPWR VPWR sky130_fd_sc_hd__fill_1
Xfanout313 _05040_ VGND VGND VPWR VPWR net313 sky130_fd_sc_hd__buf_4
X_09815_ net651 _04983_ _04985_ net480 VGND VGND VPWR VPWR _04986_ sky130_fd_sc_hd__o211a_1
Xfanout346 net347 VGND VGND VPWR VPWR net346 sky130_fd_sc_hd__clkbuf_8
Xfanout335 _04350_ VGND VGND VPWR VPWR net335 sky130_fd_sc_hd__clkbuf_8
XFILLER_59_547 VGND VGND VPWR VPWR sky130_fd_sc_hd__decap_6
Xfanout357 _04344_ VGND VGND VPWR VPWR net357 sky130_fd_sc_hd__buf_4
Xfanout324 net325 VGND VGND VPWR VPWR net324 sky130_fd_sc_hd__buf_4
Xfanout368 net369 VGND VGND VPWR VPWR net368 sky130_fd_sc_hd__buf_6
Xfanout379 net380 VGND VGND VPWR VPWR net379 sky130_fd_sc_hd__buf_4
X_09746_ _04913_ _04914_ _04917_ _04918_ net660 net647 VGND VGND VPWR VPWR _04920_
+ sky130_fd_sc_hd__mux4_1
X_06958_ _03171_ _03172_ net664 VGND VGND VPWR VPWR _03173_ sky130_fd_sc_hd__a21o_1
X_09677_ picorv32_core.cpuregs\[4\]\[22\] picorv32_core.cpuregs\[5\]\[22\] picorv32_core.cpuregs\[6\]\[22\]
+ picorv32_core.cpuregs\[7\]\[22\] net890 net856 VGND VGND VPWR VPWR _04854_ sky130_fd_sc_hd__mux4_1
X_05909_ _02356_ _02370_ VGND VGND VPWR VPWR _02381_ sky130_fd_sc_hd__or2_1
XTAP_TAPCELL_ROW_83_1507 VGND VPWR sky130_fd_sc_hd__tapvpwrvgnd_1
X_06889_ _03092_ _03100_ _03108_ VGND VGND VPWR VPWR _03109_ sky130_fd_sc_hd__a21oi_1
XFILLER_70_701 VGND VGND VPWR VPWR sky130_fd_sc_hd__decap_3
X_08628_ net1539 net444 net390 VGND VGND VPWR VPWR _00779_ sky130_fd_sc_hd__mux2_1
XFILLER_54_274 VGND VGND VPWR VPWR sky130_fd_sc_hd__fill_2
XFILLER_14_127 VGND VGND VPWR VPWR sky130_fd_sc_hd__decap_4
XFILLER_27_488 VGND VGND VPWR VPWR sky130_fd_sc_hd__decap_4
XTAP_TAPCELL_ROW_25_667 VGND VPWR sky130_fd_sc_hd__tapvpwrvgnd_1
X_08559_ net295 net1645 net398 VGND VGND VPWR VPWR _00684_ sky130_fd_sc_hd__mux2_1
X_11570_ clknet_leaf_27_clk _01401_ VGND VGND VPWR VPWR picorv32_core.cpuregs\[2\]\[17\]
+ sky130_fd_sc_hd__dfxtp_1
XFILLER_139_3 VPWR VGND VPWR VGND sky130_ef_sc_hd__decap_12
X_10521_ clknet_leaf_126_clk picorv32_core.alu_out\[9\] VGND VGND VPWR VPWR picorv32_core.alu_out_q\[9\]
+ sky130_fd_sc_hd__dfxtp_1
X_10452_ clknet_leaf_80_clk _00339_ VGND VGND VPWR VPWR net44 sky130_fd_sc_hd__dfxtp_1
XFILLER_124_714 VPWR VGND VPWR VGND sky130_ef_sc_hd__decap_12
X_10383_ clknet_leaf_101_clk _00302_ VGND VGND VPWR VPWR picorv32_core.count_cycle\[41\]
+ sky130_fd_sc_hd__dfxtp_1
XFILLER_124_769 VPWR VGND VPWR VGND sky130_ef_sc_hd__decap_12
XTAP_TAPCELL_ROW_94_1669 VGND VPWR sky130_fd_sc_hd__tapvpwrvgnd_1
XFILLER_111_419 VGND VGND VPWR VPWR sky130_fd_sc_hd__fill_2
X_11004_ clknet_leaf_20_clk _00855_ VGND VGND VPWR VPWR picorv32_core.cpuregs\[12\]\[18\]
+ sky130_fd_sc_hd__dfxtp_1
XFILLER_2_587 VGND VGND VPWR VPWR sky130_fd_sc_hd__fill_1
XTAP_TAPCELL_ROW_125_2124 VGND VPWR sky130_fd_sc_hd__tapvpwrvgnd_1
XTAP_TAPCELL_ROW_125_2113 VGND VPWR sky130_fd_sc_hd__tapvpwrvgnd_1
XFILLER_92_303 VGND VGND VPWR VPWR sky130_fd_sc_hd__decap_4
Xfanout891 net900 VGND VGND VPWR VPWR net891 sky130_fd_sc_hd__buf_2
Xfanout880 net883 VGND VGND VPWR VPWR net880 sky130_fd_sc_hd__buf_4
XTAP_TAPCELL_ROW_5_381 VGND VPWR sky130_fd_sc_hd__tapvpwrvgnd_1
XFILLER_37_219 VGND VGND VPWR VPWR sky130_fd_sc_hd__decap_4
XFILLER_133_81 VPWR VGND VPWR VGND sky130_ef_sc_hd__decap_12
XFILLER_93_30 VGND VGND VPWR VPWR sky130_fd_sc_hd__decap_3
XFILLER_73_561 VGND VGND VPWR VPWR sky130_fd_sc_hd__decap_3
XFILLER_61_701 VGND VGND VPWR VPWR sky130_fd_sc_hd__fill_2
XFILLER_45_296 VGND VGND VPWR VPWR sky130_fd_sc_hd__fill_1
X_11837_ net40 VGND VGND VPWR VPWR net72 sky130_fd_sc_hd__clkbuf_1
XTAP_TAPCELL_ROW_44_943 VGND VPWR sky130_fd_sc_hd__tapvpwrvgnd_1
XFILLER_61_789 VGND VGND VPWR VPWR sky130_fd_sc_hd__fill_1
XFILLER_60_277 VGND VGND VPWR VPWR sky130_fd_sc_hd__decap_4
XTAP_TAPCELL_ROW_103_1798 VGND VPWR sky130_fd_sc_hd__tapvpwrvgnd_1
X_10719_ clknet_leaf_26_clk _00570_ VGND VGND VPWR VPWR net125 sky130_fd_sc_hd__dfxtp_1
X_11699_ clknet_leaf_20_clk _01530_ VGND VGND VPWR VPWR picorv32_core.cpuregs\[27\]\[16\]
+ sky130_fd_sc_hd__dfxtp_1
XTAP_TAPCELL_ROW_136_2275 VGND VPWR sky130_fd_sc_hd__tapvpwrvgnd_1
XFILLER_115_714 VGND VGND VPWR VPWR sky130_fd_sc_hd__fill_1
XFILLER_115_747 VPWR VGND VPWR VGND sky130_ef_sc_hd__decap_12
XFILLER_5_370 VGND VGND VPWR VPWR sky130_fd_sc_hd__fill_1
XPHY_EDGE_ROW_39_Left_181 VGND VGND VPWR VPWR sky130_fd_sc_hd__decap_3
X_07930_ picorv32_core.cpuregs\[12\]\[23\] picorv32_core.cpuregs\[13\]\[23\] picorv32_core.cpuregs\[14\]\[23\]
+ picorv32_core.cpuregs\[15\]\[23\] net756 net723 VGND VGND VPWR VPWR _04012_ sky130_fd_sc_hd__mux4_1
XFILLER_102_408 VGND VGND VPWR VPWR sky130_fd_sc_hd__decap_4
XFILLER_87_119 VGND VGND VPWR VPWR sky130_fd_sc_hd__fill_1
X_07861_ picorv32_core.cpuregs\[12\]\[19\] picorv32_core.cpuregs\[13\]\[19\] picorv32_core.cpuregs\[14\]\[19\]
+ picorv32_core.cpuregs\[15\]\[19\] net748 net715 VGND VGND VPWR VPWR _03947_ sky130_fd_sc_hd__mux4_1
X_09600_ net784 net280 VGND VGND VPWR VPWR _04780_ sky130_fd_sc_hd__and2_1
X_07792_ _03876_ _03877_ net635 VGND VGND VPWR VPWR _03882_ sky130_fd_sc_hd__mux2_1
X_06812_ picorv32_core.decoded_imm_j\[9\] _02921_ _03028_ VGND VGND VPWR VPWR _03038_
+ sky130_fd_sc_hd__a21oi_1
X_09531_ net285 _04699_ _04714_ _04692_ VGND VGND VPWR VPWR _01334_ sky130_fd_sc_hd__a31o_1
XFILLER_37_720 VGND VGND VPWR VPWR sky130_fd_sc_hd__decap_8
X_06743_ _02972_ _02974_ net981 VGND VGND VPWR VPWR _00233_ sky130_fd_sc_hd__o21a_1
X_06674_ net2355 net554 _02926_ net517 VGND VGND VPWR VPWR _00212_ sky130_fd_sc_hd__a22o_1
X_09462_ _04640_ _04641_ net654 VGND VGND VPWR VPWR _04649_ sky130_fd_sc_hd__mux2_1
XFILLER_52_745 VGND VGND VPWR VPWR sky130_fd_sc_hd__decap_8
XPHY_EDGE_ROW_48_Left_190 VGND VGND VPWR VPWR sky130_fd_sc_hd__decap_3
X_05625_ picorv32_core.count_cycle\[30\] net600 net579 _02110_ VGND VGND VPWR VPWR
+ _02111_ sky130_fd_sc_hd__o211a_1
X_08413_ picorv32_core.mem_rdata_q\[30\] net614 VGND VGND VPWR VPWR _04287_ sky130_fd_sc_hd__and2_1
XTAP_TAPCELL_ROW_65_1248 VGND VPWR sky130_fd_sc_hd__tapvpwrvgnd_1
X_09393_ _04574_ _04575_ _04579_ _04580_ net652 net642 VGND VGND VPWR VPWR _04583_
+ sky130_fd_sc_hd__mux4_1
X_05556_ net21 net583 net575 VGND VGND VPWR VPWR _02047_ sky130_fd_sc_hd__a21o_1
X_08344_ net928 net965 net957 net927 VGND VGND VPWR VPWR _04245_ sky130_fd_sc_hd__a22o_1
XTAP_TAPCELL_ROW_22_626 VGND VPWR sky130_fd_sc_hd__tapvpwrvgnd_1
XFILLER_22_15 VPWR VGND VPWR VGND sky130_ef_sc_hd__decap_12
XFILLER_138_15 VPWR VGND VPWR VGND sky130_ef_sc_hd__decap_12
XFILLER_137_327 VGND VGND VPWR VPWR sky130_fd_sc_hd__fill_1
X_05487_ _01956_ _01967_ _01968_ _01982_ VGND VGND VPWR VPWR _01983_ sky130_fd_sc_hd__a211o_1
X_08275_ net1682 net276 net411 VGND VGND VPWR VPWR _00499_ sky130_fd_sc_hd__mux2_1
X_07226_ picorv32_core.count_cycle\[55\] picorv32_core.count_cycle\[56\] _03370_ VGND
+ VGND VPWR VPWR _03374_ sky130_fd_sc_hd__and3_1
X_07157_ _03329_ _03330_ VGND VGND VPWR VPWR _00291_ sky130_fd_sc_hd__nor2_1
X_06108_ _01599_ _02551_ _02543_ VGND VGND VPWR VPWR _02564_ sky130_fd_sc_hd__a21o_1
X_07088_ picorv32_core.count_cycle\[4\] _03284_ picorv32_core.count_cycle\[5\] VGND
+ VGND VPWR VPWR _03287_ sky130_fd_sc_hd__a21o_1
XFILLER_120_216 VGND VGND VPWR VPWR sky130_fd_sc_hd__decap_3
XFILLER_105_279 VGND VGND VPWR VPWR sky130_fd_sc_hd__fill_1
X_06039_ _02499_ _02500_ VGND VGND VPWR VPWR _02501_ sky130_fd_sc_hd__nand2_1
XFILLER_101_430 VGND VGND VPWR VPWR sky130_fd_sc_hd__fill_2
X_09729_ picorv32_core.reg_pc\[24\] net538 _04903_ net483 VGND VGND VPWR VPWR _04904_
+ sky130_fd_sc_hd__a211o_1
XTAP_TAPCELL_ROW_2_340 VGND VPWR sky130_fd_sc_hd__tapvpwrvgnd_1
XFILLER_27_285 VGND VGND VPWR VPWR sky130_fd_sc_hd__fill_1
XFILLER_43_745 VGND VGND VPWR VPWR sky130_fd_sc_hd__decap_4
XTAP_TAPCELL_ROW_120_2043 VGND VPWR sky130_fd_sc_hd__tapvpwrvgnd_1
XFILLER_63_55 VGND VGND VPWR VPWR sky130_fd_sc_hd__fill_1
X_11622_ clknet_leaf_113_clk _01453_ VGND VGND VPWR VPWR picorv32_core.cpuregs\[28\]\[3\]
+ sky130_fd_sc_hd__dfxtp_1
XTAP_TAPCELL_ROW_41_902 VGND VPWR sky130_fd_sc_hd__tapvpwrvgnd_1
X_11553_ clknet_leaf_132_clk _01384_ VGND VGND VPWR VPWR picorv32_core.cpuregs\[2\]\[0\]
+ sky130_fd_sc_hd__dfxtp_1
X_10504_ clknet_leaf_62_clk _00390_ VGND VGND VPWR VPWR net196 sky130_fd_sc_hd__dfxtp_4
X_11484_ clknet_leaf_120_clk _01320_ VGND VGND VPWR VPWR net152 sky130_fd_sc_hd__dfxtp_1
X_10435_ clknet_leaf_86_clk _01567_ VGND VGND VPWR VPWR picorv32_core.reg_out\[28\]
+ sky130_fd_sc_hd__dfxtp_1
XFILLER_6_189 VGND VGND VPWR VPWR sky130_fd_sc_hd__decap_6
X_10366_ clknet_leaf_85_clk _00285_ VGND VGND VPWR VPWR picorv32_core.count_cycle\[24\]
+ sky130_fd_sc_hd__dfxtp_1
XFILLER_97_439 VGND VGND VPWR VPWR sky130_fd_sc_hd__fill_1
X_10297_ clknet_leaf_87_clk _00216_ VGND VGND VPWR VPWR picorv32_core.reg_pc\[18\]
+ sky130_fd_sc_hd__dfxtp_2
XFILLER_78_664 VGND VGND VPWR VPWR sky130_fd_sc_hd__decap_4
XFILLER_19_6 VPWR VGND VPWR VGND sky130_ef_sc_hd__decap_12
XFILLER_77_185 VGND VGND VPWR VPWR sky130_fd_sc_hd__fill_2
XFILLER_65_369 VGND VGND VPWR VPWR sky130_fd_sc_hd__fill_1
XFILLER_18_241 VGND VGND VPWR VPWR sky130_fd_sc_hd__fill_2
XFILLER_19_753 VPWR VGND VPWR VGND sky130_ef_sc_hd__decap_12
XFILLER_34_701 VGND VGND VPWR VPWR sky130_fd_sc_hd__fill_1
XTAP_TAPCELL_ROW_105_1827 VGND VPWR sky130_fd_sc_hd__tapvpwrvgnd_1
XFILLER_19_797 VGND VGND VPWR VPWR sky130_fd_sc_hd__decap_4
XTAP_TAPCELL_ROW_138_2304 VGND VPWR sky130_fd_sc_hd__tapvpwrvgnd_1
X_05410_ _01891_ _01894_ _01911_ VGND VGND VPWR VPWR _01912_ sky130_fd_sc_hd__a21o_1
X_06390_ net1577 net216 net436 VGND VGND VPWR VPWR _00068_ sky130_fd_sc_hd__mux2_1
X_05341_ net926 _01739_ net585 VGND VGND VPWR VPWR _01847_ sky130_fd_sc_hd__a21o_1
XFILLER_135_809 VPWR VGND VPWR VGND sky130_ef_sc_hd__decap_12
X_08060_ net640 _04134_ VGND VGND VPWR VPWR _04135_ sky130_fd_sc_hd__or2_1
X_05272_ net25 net820 VGND VGND VPWR VPWR _01783_ sky130_fd_sc_hd__nand2b_1
XTAP_TAPCELL_ROW_60_1178 VGND VPWR sky130_fd_sc_hd__tapvpwrvgnd_1
X_07011_ net666 picorv32_core.reg_next_pc\[25\] _02937_ net489 VGND VGND VPWR VPWR
+ _03222_ sky130_fd_sc_hd__a22o_1
XFILLER_127_393 VGND VGND VPWR VPWR sky130_fd_sc_hd__fill_2
XFILLER_108_29 VGND VGND VPWR VPWR sky130_fd_sc_hd__decap_4
XTAP_TAPCELL_ROW_116_1989 VGND VPWR sky130_fd_sc_hd__tapvpwrvgnd_1
XFILLER_103_717 VGND VGND VPWR VPWR sky130_fd_sc_hd__fill_2
XFILLER_88_439 VGND VGND VPWR VPWR sky130_fd_sc_hd__decap_3
X_08962_ net1279 net298 net348 VGND VGND VPWR VPWR _01134_ sky130_fd_sc_hd__mux2_1
X_07913_ picorv32_core.cpuregs\[20\]\[22\] picorv32_core.cpuregs\[21\]\[22\] picorv32_core.cpuregs\[22\]\[22\]
+ picorv32_core.cpuregs\[23\]\[22\] net752 net719 VGND VGND VPWR VPWR _03996_ sky130_fd_sc_hd__mux4_1
XFILLER_69_631 VGND VGND VPWR VPWR sky130_fd_sc_hd__decap_4
X_08893_ net443 net1310 net358 VGND VGND VPWR VPWR _01067_ sky130_fd_sc_hd__mux2_1
XFILLER_111_783 VGND VGND VPWR VPWR sky130_fd_sc_hd__fill_1
XFILLER_96_472 VGND VGND VPWR VPWR sky130_fd_sc_hd__decap_4
X_07844_ picorv32_core.cpuregs\[8\]\[18\] picorv32_core.cpuregs\[9\]\[18\] picorv32_core.cpuregs\[10\]\[18\]
+ picorv32_core.cpuregs\[11\]\[18\] net750 net717 VGND VGND VPWR VPWR _03931_ sky130_fd_sc_hd__mux4_1
XFILLER_68_141 VGND VGND VPWR VPWR sky130_fd_sc_hd__decap_4
XFILLER_110_282 VGND VGND VPWR VPWR sky130_fd_sc_hd__fill_1
XFILLER_84_645 VGND VGND VPWR VPWR sky130_fd_sc_hd__decap_8
XFILLER_83_122 VGND VGND VPWR VPWR sky130_fd_sc_hd__decap_3
X_07775_ _03855_ _03864_ _03865_ net618 net687 VGND VGND VPWR VPWR _03866_ sky130_fd_sc_hd__a221o_1
XFILLER_140_27 VGND VGND VPWR VPWR sky130_fd_sc_hd__fill_1
X_09514_ net471 _04634_ _04697_ _04696_ VGND VGND VPWR VPWR _04698_ sky130_fd_sc_hd__a31o_1
XFILLER_52_520 VGND VGND VPWR VPWR sky130_fd_sc_hd__decap_8
X_06726_ _02915_ _02947_ VGND VGND VPWR VPWR _02959_ sky130_fd_sc_hd__nand2b_1
X_09445_ net797 net281 VGND VGND VPWR VPWR _04632_ sky130_fd_sc_hd__and2_1
X_06657_ _02688_ picorv32_core.reg_next_pc\[6\] net555 VGND VGND VPWR VPWR _02918_
+ sky130_fd_sc_hd__mux2_2
X_05608_ _02091_ _02092_ _02093_ VGND VGND VPWR VPWR _02095_ sky130_fd_sc_hd__or3b_1
X_06588_ picorv32_core.count_instr\[44\] picorv32_core.count_instr\[43\] picorv32_core.count_instr\[42\]
+ _02869_ VGND VGND VPWR VPWR _02874_ sky130_fd_sc_hd__and4_1
X_09376_ net283 _04550_ _04565_ _04566_ VGND VGND VPWR VPWR _01327_ sky130_fd_sc_hd__a31o_1
XFILLER_137_113 VPWR VGND VPWR VGND sky130_ef_sc_hd__decap_12
X_05539_ picorv32_core.reg_pc\[24\] picorv32_core.decoded_imm\[24\] VGND VGND VPWR
+ VPWR _02031_ sky130_fd_sc_hd__or2_1
X_08327_ net966 net1184 net453 VGND VGND VPWR VPWR _00544_ sky130_fd_sc_hd__mux2_1
XFILLER_138_658 VGND VGND VPWR VPWR sky130_fd_sc_hd__fill_1
X_08258_ picorv32_core.mem_rdata_q\[31\] net28 net521 VGND VGND VPWR VPWR _00772_
+ sky130_fd_sc_hd__mux2_1
X_07209_ picorv32_core.count_cycle\[49\] picorv32_core.count_cycle\[50\] _03359_ VGND
+ VGND VPWR VPWR _03363_ sky130_fd_sc_hd__and3_1
XTAP_TAPCELL_ROW_78_1439 VGND VPWR sky130_fd_sc_hd__tapvpwrvgnd_1
XFILLER_106_533 VGND VGND VPWR VPWR sky130_fd_sc_hd__decap_8
XFILLER_106_522 VGND VGND VPWR VPWR sky130_fd_sc_hd__decap_8
X_08189_ net1144 net476 _04194_ _04199_ VGND VGND VPWR VPWR _00445_ sky130_fd_sc_hd__a22o_1
X_10220_ clknet_leaf_103_clk _00139_ VGND VGND VPWR VPWR picorv32_core.count_instr\[4\]
+ sky130_fd_sc_hd__dfxtp_1
XTAP_TAPCELL_ROW_91_1628 VGND VPWR sky130_fd_sc_hd__tapvpwrvgnd_1
XFILLER_3_137 VPWR VGND VPWR VGND sky130_ef_sc_hd__decap_12
XTAP_TAPCELL_ROW_7_410 VGND VPWR sky130_fd_sc_hd__tapvpwrvgnd_1
XFILLER_0_811 VGND VGND VPWR VPWR sky130_fd_sc_hd__fill_1
X_10151_ clknet_leaf_112_clk _00036_ VGND VGND VPWR VPWR picorv32_core.reg_sh\[4\]
+ sky130_fd_sc_hd__dfxtp_1
X_10082_ picorv32_core.decoded_imm_j\[3\] _00764_ net437 VGND VGND VPWR VPWR _00530_
+ sky130_fd_sc_hd__mux2_1
XFILLER_47_358 VGND VGND VPWR VPWR sky130_fd_sc_hd__fill_1
X_10984_ clknet_leaf_63_clk _00835_ VGND VGND VPWR VPWR picorv32_core.cpuregs\[13\]\[30\]
+ sky130_fd_sc_hd__dfxtp_1
XFILLER_28_572 VGND VGND VPWR VPWR sky130_fd_sc_hd__fill_1
XFILLER_16_745 VGND VGND VPWR VPWR sky130_fd_sc_hd__decap_8
XTAP_TAPCELL_ROW_100_1757 VGND VPWR sky130_fd_sc_hd__tapvpwrvgnd_1
X_11605_ clknet_leaf_50_clk _01436_ VGND VGND VPWR VPWR picorv32_core.cpuregs\[23\]\[18\]
+ sky130_fd_sc_hd__dfxtp_1
XFILLER_30_247 VGND VGND VPWR VPWR sky130_fd_sc_hd__decap_4
XFILLER_117_809 VPWR VGND VPWR VGND sky130_ef_sc_hd__decap_12
X_11536_ clknet_leaf_24_clk _01367_ VGND VGND VPWR VPWR picorv32_core.cpuregs\[30\]\[17\]
+ sky130_fd_sc_hd__dfxtp_1
XTAP_TAPCELL_ROW_13_489 VGND VPWR sky130_fd_sc_hd__tapvpwrvgnd_1
XTAP_TAPCELL_ROW_133_2234 VGND VPWR sky130_fd_sc_hd__tapvpwrvgnd_1
X_11467_ clknet_leaf_18_clk _01303_ VGND VGND VPWR VPWR picorv32_core.cpuregs\[24\]\[18\]
+ sky130_fd_sc_hd__dfxtp_1
X_10418_ clknet_leaf_90_clk _01549_ VGND VGND VPWR VPWR picorv32_core.reg_out\[11\]
+ sky130_fd_sc_hd__dfxtp_1
X_11398_ clknet_leaf_13_clk _01234_ VGND VGND VPWR VPWR picorv32_core.cpuregs\[31\]\[13\]
+ sky130_fd_sc_hd__dfxtp_1
XFILLER_124_385 VGND VGND VPWR VPWR sky130_fd_sc_hd__fill_2
XFILLER_112_514 VGND VGND VPWR VPWR sky130_fd_sc_hd__decap_4
X_10349_ clknet_leaf_102_clk _00268_ VGND VGND VPWR VPWR picorv32_core.count_cycle\[7\]
+ sky130_fd_sc_hd__dfxtp_1
XFILLER_3_671 VGND VGND VPWR VPWR sky130_fd_sc_hd__fill_1
XFILLER_112_569 VGND VGND VPWR VPWR sky130_fd_sc_hd__fill_1
XFILLER_112_558 VGND VGND VPWR VPWR sky130_fd_sc_hd__fill_2
X_05890_ net799 net175 net568 VGND VGND VPWR VPWR _02363_ sky130_fd_sc_hd__and3_1
XFILLER_81_626 VPWR VGND VPWR VGND sky130_ef_sc_hd__decap_12
XTAP_TAPCELL_ROW_49_1018 VGND VPWR sky130_fd_sc_hd__tapvpwrvgnd_1
X_07560_ picorv32_core.cpuregs\[20\]\[0\] picorv32_core.cpuregs\[21\]\[0\] picorv32_core.cpuregs\[22\]\[0\]
+ picorv32_core.cpuregs\[23\]\[0\] net742 net709 VGND VGND VPWR VPWR _03665_ sky130_fd_sc_hd__mux4_1
X_06511_ picorv32_core.count_instr\[16\] _02824_ VGND VGND VPWR VPWR _02825_ sky130_fd_sc_hd__or2_1
XFILLER_34_531 VGND VGND VPWR VPWR sky130_fd_sc_hd__fill_1
X_07491_ picorv32_core.reg_out\[17\] picorv32_core.reg_next_pc\[17\] net562 VGND VGND
+ VPWR VPWR _03615_ sky130_fd_sc_hd__mux2_1
XTAP_TAPCELL_ROW_62_1207 VGND VPWR sky130_fd_sc_hd__tapvpwrvgnd_1
X_09230_ net610 _03464_ _04426_ _04425_ VGND VGND VPWR VPWR _04427_ sky130_fd_sc_hd__a31o_1
X_06442_ net447 net1878 net418 VGND VGND VPWR VPWR _00108_ sky130_fd_sc_hd__mux2_1
X_06373_ _02771_ _02772_ net564 VGND VGND VPWR VPWR _02773_ sky130_fd_sc_hd__mux2_2
X_09161_ picorv32_core.cpuregs\[24\]\[0\] picorv32_core.cpuregs\[25\]\[0\] picorv32_core.cpuregs\[26\]\[0\]
+ picorv32_core.cpuregs\[27\]\[0\] net884 net851 VGND VGND VPWR VPWR _04360_ sky130_fd_sc_hd__mux4_1
XTAP_TAPCELL_ROW_32_765 VGND VPWR sky130_fd_sc_hd__tapvpwrvgnd_1
XTAP_TAPCELL_ROW_32_776 VGND VPWR sky130_fd_sc_hd__tapvpwrvgnd_1
XFILLER_119_113 VGND VGND VPWR VPWR sky130_fd_sc_hd__decap_3
X_05324_ _01804_ _01809_ _01831_ VGND VGND VPWR VPWR _01832_ sky130_fd_sc_hd__or3_1
X_09092_ net443 net1716 net332 VGND VGND VPWR VPWR _01259_ sky130_fd_sc_hd__mux2_1
XFILLER_9_93 VGND VGND VPWR VPWR sky130_fd_sc_hd__decap_8
X_08112_ net431 net2213 net414 VGND VGND VPWR VPWR _00405_ sky130_fd_sc_hd__mux2_1
XFILLER_30_781 VPWR VGND VPWR VGND sky130_ef_sc_hd__decap_12
X_08043_ net639 _04109_ net686 VGND VGND VPWR VPWR _04119_ sky130_fd_sc_hd__o21a_1
Xhold911 picorv32_core.cpuregs\[8\]\[30\] VGND VGND VPWR VPWR net2020 sky130_fd_sc_hd__dlygate4sd3_1
Xhold900 picorv32_core.cpuregs\[18\]\[28\] VGND VGND VPWR VPWR net2009 sky130_fd_sc_hd__dlygate4sd3_1
Xhold922 picorv32_core.cpuregs\[6\]\[17\] VGND VGND VPWR VPWR net2031 sky130_fd_sc_hd__dlygate4sd3_1
X_05255_ _01764_ _01766_ VGND VGND VPWR VPWR _01767_ sky130_fd_sc_hd__nand2_1
Xhold955 picorv32_core.cpuregs\[6\]\[29\] VGND VGND VPWR VPWR net2064 sky130_fd_sc_hd__dlygate4sd3_1
Xhold933 picorv32_core.cpuregs\[4\]\[5\] VGND VGND VPWR VPWR net2042 sky130_fd_sc_hd__dlygate4sd3_1
Xhold944 picorv32_core.cpuregs\[21\]\[10\] VGND VGND VPWR VPWR net2053 sky130_fd_sc_hd__dlygate4sd3_1
X_05186_ net931 _01580_ VGND VGND VPWR VPWR _01708_ sky130_fd_sc_hd__nor2_1
XFILLER_135_27 VPWR VGND VPWR VGND sky130_ef_sc_hd__decap_12
X_09994_ net1615 net246 net314 VGND VGND VPWR VPWR _01471_ sky130_fd_sc_hd__mux2_1
XFILLER_103_503 VGND VGND VPWR VPWR sky130_fd_sc_hd__fill_1
XFILLER_89_726 VGND VGND VPWR VPWR sky130_fd_sc_hd__fill_2
XTAP_TAPCELL_ROW_73_1358 VGND VPWR sky130_fd_sc_hd__tapvpwrvgnd_1
Xhold977 picorv32_core.instr_sh VGND VGND VPWR VPWR net2086 sky130_fd_sc_hd__dlygate4sd3_1
Xhold988 picorv32_core.cpuregs\[18\]\[4\] VGND VGND VPWR VPWR net2097 sky130_fd_sc_hd__dlygate4sd3_1
Xhold966 picorv32_core.cpuregs\[25\]\[0\] VGND VGND VPWR VPWR net2075 sky130_fd_sc_hd__dlygate4sd3_1
Xhold999 picorv32_core.cpuregs\[5\]\[30\] VGND VGND VPWR VPWR net2108 sky130_fd_sc_hd__dlygate4sd3_1
XFILLER_130_322 VGND VGND VPWR VPWR sky130_fd_sc_hd__fill_1
XTAP_TAPCELL_ROW_73_1369 VGND VPWR sky130_fd_sc_hd__tapvpwrvgnd_1
X_08945_ net231 net1824 net356 VGND VGND VPWR VPWR _01118_ sky130_fd_sc_hd__mux2_1
XFILLER_57_612 VGND VGND VPWR VPWR sky130_fd_sc_hd__decap_4
X_08876_ net240 net1946 net363 VGND VGND VPWR VPWR _01051_ sky130_fd_sc_hd__mux2_1
XFILLER_57_645 VGND VGND VPWR VPWR sky130_fd_sc_hd__fill_1
XFILLER_57_623 VGND VGND VPWR VPWR sky130_fd_sc_hd__fill_1
XFILLER_84_442 VGND VGND VPWR VPWR sky130_fd_sc_hd__fill_1
X_07827_ _03909_ _03910_ net634 VGND VGND VPWR VPWR _03915_ sky130_fd_sc_hd__mux2_1
XFILLER_84_475 VGND VGND VPWR VPWR sky130_fd_sc_hd__fill_1
X_07758_ _03842_ _03843_ net630 VGND VGND VPWR VPWR _03850_ sky130_fd_sc_hd__mux2_1
X_06709_ net673 net970 picorv32_core.decoded_imm_j\[1\] VGND VGND VPWR VPWR _02944_
+ sky130_fd_sc_hd__and3_1
XFILLER_37_391 VGND VGND VPWR VPWR sky130_fd_sc_hd__fill_1
XFILLER_52_361 VGND VGND VPWR VPWR sky130_fd_sc_hd__decap_3
X_07689_ picorv32_core.decoded_imm\[9\] net590 net594 VGND VGND VPWR VPWR _03785_
+ sky130_fd_sc_hd__a21o_1
X_09428_ net610 _04611_ _04615_ net486 VGND VGND VPWR VPWR _04616_ sky130_fd_sc_hd__a211o_1
XFILLER_52_383 VGND VGND VPWR VPWR sky130_fd_sc_hd__fill_1
XFILLER_40_512 VGND VGND VPWR VPWR sky130_fd_sc_hd__fill_2
XFILLER_40_556 VGND VGND VPWR VPWR sky130_fd_sc_hd__fill_1
X_09359_ net610 _04546_ _04547_ net474 _04549_ VGND VGND VPWR VPWR _04550_ sky130_fd_sc_hd__a221o_1
XFILLER_40_589 VGND VGND VPWR VPWR sky130_fd_sc_hd__fill_2
XFILLER_121_3 VPWR VGND VPWR VGND sky130_ef_sc_hd__decap_12
XTAP_TAPCELL_ROW_10_448 VGND VPWR sky130_fd_sc_hd__tapvpwrvgnd_1
X_11321_ clknet_leaf_138_clk _01162_ VGND VGND VPWR VPWR picorv32_core.cpuregs\[29\]\[5\]
+ sky130_fd_sc_hd__dfxtp_1
XFILLER_5_18 VPWR VGND VPWR VGND sky130_ef_sc_hd__decap_12
XFILLER_118_190 VGND VGND VPWR VPWR sky130_fd_sc_hd__decap_6
XFILLER_69_32 VGND VGND VPWR VPWR sky130_fd_sc_hd__fill_1
XFILLER_4_457 VGND VGND VPWR VPWR sky130_fd_sc_hd__decap_6
X_11252_ clknet_leaf_130_clk _01100_ VGND VGND VPWR VPWR picorv32_core.cpuregs\[4\]\[7\]
+ sky130_fd_sc_hd__dfxtp_1
XFILLER_106_363 VGND VGND VPWR VPWR sky130_fd_sc_hd__fill_1
X_10203_ clknet_leaf_31_clk _00122_ VGND VGND VPWR VPWR picorv32_core.cpuregs\[9\]\[19\]
+ sky130_fd_sc_hd__dfxtp_1
X_11183_ clknet_leaf_137_clk _01034_ VGND VGND VPWR VPWR picorv32_core.cpuregs\[6\]\[5\]
+ sky130_fd_sc_hd__dfxtp_1
X_10134_ clknet_leaf_25_clk _00056_ VGND VGND VPWR VPWR picorv32_core.cpuregs\[22\]\[17\]
+ sky130_fd_sc_hd__dfxtp_1
XFILLER_69_87 VGND VGND VPWR VPWR sky130_fd_sc_hd__fill_1
XFILLER_121_388 VGND VGND VPWR VPWR sky130_fd_sc_hd__decap_4
X_10065_ net1485 net225 net307 VGND VGND VPWR VPWR _01540_ sky130_fd_sc_hd__mux2_1
XFILLER_0_685 VGND VGND VPWR VPWR sky130_fd_sc_hd__decap_4
XFILLER_141_81 VGND VGND VPWR VPWR sky130_fd_sc_hd__decap_3
XFILLER_16_531 VGND VGND VPWR VPWR sky130_fd_sc_hd__fill_1
XTAP_TAPCELL_ROW_18_559 VGND VPWR sky130_fd_sc_hd__tapvpwrvgnd_1
X_10967_ clknet_leaf_13_clk _00818_ VGND VGND VPWR VPWR picorv32_core.cpuregs\[13\]\[13\]
+ sky130_fd_sc_hd__dfxtp_1
XFILLER_71_681 VGND VGND VPWR VPWR sky130_fd_sc_hd__fill_1
XFILLER_31_523 VGND VGND VPWR VPWR sky130_fd_sc_hd__fill_1
X_10898_ clknet_leaf_106_clk _00749_ VGND VGND VPWR VPWR picorv32_core.mem_rdata_q\[8\]
+ sky130_fd_sc_hd__dfxtp_1
XFILLER_12_781 VPWR VGND VPWR VGND sky130_ef_sc_hd__decap_12
Xhold207 picorv32_core.cpuregs\[24\]\[22\] VGND VGND VPWR VPWR net1316 sky130_fd_sc_hd__dlygate4sd3_1
X_11519_ clknet_leaf_134_clk _01350_ VGND VGND VPWR VPWR picorv32_core.cpuregs\[30\]\[0\]
+ sky130_fd_sc_hd__dfxtp_1
Xhold229 picorv32_core.cpuregs\[12\]\[22\] VGND VGND VPWR VPWR net1338 sky130_fd_sc_hd__dlygate4sd3_1
Xhold218 picorv32_core.cpuregs\[1\]\[15\] VGND VGND VPWR VPWR net1327 sky130_fd_sc_hd__dlygate4sd3_1
XFILLER_113_801 VGND VGND VPWR VPWR sky130_fd_sc_hd__fill_1
XTAP_TAPCELL_ROW_113_1948 VGND VPWR sky130_fd_sc_hd__tapvpwrvgnd_1
XTAP_TAPCELL_ROW_113_1937 VGND VPWR sky130_fd_sc_hd__tapvpwrvgnd_1
Xfanout709 net710 VGND VGND VPWR VPWR net709 sky130_fd_sc_hd__clkbuf_4
XFILLER_98_589 VGND VGND VPWR VPWR sky130_fd_sc_hd__decap_4
X_06991_ _02935_ _02936_ _03185_ VGND VGND VPWR VPWR _03203_ sky130_fd_sc_hd__and3_1
XFILLER_85_217 VGND VGND VPWR VPWR sky130_fd_sc_hd__fill_1
XTAP_TAPCELL_ROW_55_1099 VGND VPWR sky130_fd_sc_hd__tapvpwrvgnd_1
X_05942_ net609 _02183_ _02184_ net571 _02410_ VGND VGND VPWR VPWR _02411_ sky130_fd_sc_hd__a221o_1
X_08730_ net1353 net300 net378 VGND VGND VPWR VPWR _00878_ sky130_fd_sc_hd__mux2_1
XFILLER_39_634 VGND VGND VPWR VPWR sky130_fd_sc_hd__fill_2
XFILLER_94_773 VGND VGND VPWR VPWR sky130_fd_sc_hd__fill_1
X_05873_ _02345_ _02346_ VGND VGND VPWR VPWR _02348_ sky130_fd_sc_hd__nand2_1
X_08661_ net445 net1449 net386 VGND VGND VPWR VPWR _00811_ sky130_fd_sc_hd__mux2_1
XFILLER_39_667 VGND VGND VPWR VPWR sky130_fd_sc_hd__decap_4
XFILLER_94_795 VGND VGND VPWR VPWR sky130_fd_sc_hd__fill_1
XFILLER_66_475 VGND VGND VPWR VPWR sky130_fd_sc_hd__fill_1
X_07612_ net617 _03711_ _03710_ net457 VGND VGND VPWR VPWR _03712_ sky130_fd_sc_hd__o211a_1
XFILLER_93_294 VGND VGND VPWR VPWR sky130_fd_sc_hd__fill_1
XFILLER_81_456 VGND VGND VPWR VPWR sky130_fd_sc_hd__fill_2
XTAP_TAPCELL_ROW_37_835 VGND VPWR sky130_fd_sc_hd__tapvpwrvgnd_1
XTAP_TAPCELL_ROW_37_846 VGND VPWR sky130_fd_sc_hd__tapvpwrvgnd_1
X_08592_ net428 net2203 net394 VGND VGND VPWR VPWR _00715_ sky130_fd_sc_hd__mux2_1
XFILLER_53_169 VGND VGND VPWR VPWR sky130_fd_sc_hd__decap_3
X_07543_ _01677_ _01684_ picorv32_core.cpu_state\[2\] VGND VGND VPWR VPWR _03651_
+ sky130_fd_sc_hd__o21ai_1
X_07474_ net800 _03603_ net533 VGND VGND VPWR VPWR _03604_ sky130_fd_sc_hd__mux2_1
XFILLER_50_832 VGND VGND VPWR VPWR sky130_fd_sc_hd__fill_1
X_06425_ net241 net1690 net424 VGND VGND VPWR VPWR _00093_ sky130_fd_sc_hd__mux2_1
X_09213_ _04404_ _04405_ _04408_ _04409_ net825 VGND VGND VPWR VPWR _04410_ sky130_fd_sc_hd__a221o_1
X_09144_ net1262 net230 net331 VGND VGND VPWR VPWR _01310_ sky130_fd_sc_hd__mux2_1
X_06356_ picorv32_core.reg_pc\[23\] _02755_ VGND VGND VPWR VPWR _02759_ sky130_fd_sc_hd__xor2_1
X_09075_ net1362 net242 net338 VGND VGND VPWR VPWR _01243_ sky130_fd_sc_hd__mux2_1
X_05307_ net914 net807 net577 _01815_ VGND VGND VPWR VPWR _01816_ sky130_fd_sc_hd__a22o_1
X_06287_ net1336 net299 net433 VGND VGND VPWR VPWR _00048_ sky130_fd_sc_hd__mux2_1
XFILLER_30_15 VPWR VGND VPWR VGND sky130_ef_sc_hd__decap_12
XFILLER_30_37 VGND VGND VPWR VPWR sky130_fd_sc_hd__fill_2
Xhold730 picorv32_core.cpuregs\[12\]\[27\] VGND VGND VPWR VPWR net1839 sky130_fd_sc_hd__dlygate4sd3_1
X_08026_ _04092_ _04101_ _04102_ net621 net689 VGND VGND VPWR VPWR _04103_ sky130_fd_sc_hd__a221o_1
XFILLER_135_458 VGND VGND VPWR VPWR sky130_fd_sc_hd__decap_4
X_05238_ net908 _01741_ _01750_ _01751_ VGND VGND VPWR VPWR _01569_ sky130_fd_sc_hd__a211o_1
Xhold763 picorv32_core.cpuregs\[13\]\[30\] VGND VGND VPWR VPWR net1872 sky130_fd_sc_hd__dlygate4sd3_1
Xhold741 picorv32_core.cpuregs\[31\]\[27\] VGND VGND VPWR VPWR net1850 sky130_fd_sc_hd__dlygate4sd3_1
Xhold752 picorv32_core.cpuregs\[16\]\[14\] VGND VGND VPWR VPWR net1861 sky130_fd_sc_hd__dlygate4sd3_1
XFILLER_1_405 VPWR VGND VPWR VGND sky130_ef_sc_hd__decap_12
Xhold774 picorv32_core.cpuregs\[17\]\[31\] VGND VGND VPWR VPWR net1883 sky130_fd_sc_hd__dlygate4sd3_1
Xhold785 picorv32_core.cpuregs\[2\]\[19\] VGND VGND VPWR VPWR net1894 sky130_fd_sc_hd__dlygate4sd3_1
X_05169_ picorv32_core.is_lb_lh_lw_lbu_lhu picorv32_core.is_sll_srl_sra _01682_ VGND
+ VGND VPWR VPWR _01694_ sky130_fd_sc_hd__and3b_1
XFILLER_1_449 VGND VGND VPWR VPWR sky130_fd_sc_hd__fill_1
Xhold796 picorv32_core.cpuregs\[14\]\[10\] VGND VGND VPWR VPWR net1905 sky130_fd_sc_hd__dlygate4sd3_1
XFILLER_130_130 VGND VGND VPWR VPWR sky130_fd_sc_hd__fill_1
XFILLER_77_729 VGND VGND VPWR VPWR sky130_fd_sc_hd__decap_4
X_09977_ net1248 net467 net313 VGND VGND VPWR VPWR _01454_ sky130_fd_sc_hd__mux2_1
XFILLER_29_111 VGND VGND VPWR VPWR sky130_fd_sc_hd__fill_1
X_08928_ net427 net2024 net354 VGND VGND VPWR VPWR _01101_ sky130_fd_sc_hd__mux2_1
XFILLER_57_497 VGND VGND VPWR VPWR sky130_fd_sc_hd__decap_6
X_08859_ net448 net2000 net362 VGND VGND VPWR VPWR _01034_ sky130_fd_sc_hd__mux2_1
XFILLER_45_626 VGND VGND VPWR VPWR sky130_fd_sc_hd__decap_4
XTAP_TAPCELL_ROW_86_1549 VGND VPWR sky130_fd_sc_hd__tapvpwrvgnd_1
XFILLER_55_78 VGND VGND VPWR VPWR sky130_fd_sc_hd__fill_2
X_10821_ clknet_leaf_63_clk _00672_ VGND VGND VPWR VPWR picorv32_core.cpuregs\[15\]\[30\]
+ sky130_fd_sc_hd__dfxtp_1
X_10752_ clknet_leaf_94_clk _00603_ VGND VGND VPWR VPWR picorv32_core.decoded_imm\[7\]
+ sky130_fd_sc_hd__dfxtp_2
XTAP_TAPCELL_ROW_15_518 VGND VPWR sky130_fd_sc_hd__tapvpwrvgnd_1
XTAP_TAPCELL_ROW_15_529 VGND VPWR sky130_fd_sc_hd__tapvpwrvgnd_1
XFILLER_52_191 VGND VGND VPWR VPWR sky130_fd_sc_hd__decap_4
XFILLER_9_505 VGND VGND VPWR VPWR sky130_fd_sc_hd__decap_3
XTAP_TAPCELL_ROW_117_2004 VGND VPWR sky130_fd_sc_hd__tapvpwrvgnd_1
X_10683_ clknet_leaf_99_clk _00536_ VGND VGND VPWR VPWR picorv32_core.is_sb_sh_sw
+ sky130_fd_sc_hd__dfxtp_2
XFILLER_139_753 VPWR VGND VPWR VGND sky130_ef_sc_hd__decap_12
XFILLER_139_797 VPWR VGND VPWR VGND sky130_ef_sc_hd__decap_12
XFILLER_138_274 VGND VGND VPWR VPWR sky130_fd_sc_hd__decap_6
X_11304_ clknet_leaf_37_clk _01152_ VGND VGND VPWR VPWR picorv32_core.cpuregs\[3\]\[27\]
+ sky130_fd_sc_hd__dfxtp_1
XFILLER_4_221 VPWR VGND VPWR VGND sky130_ef_sc_hd__decap_12
X_11235_ clknet_leaf_71_clk _01086_ VGND VGND VPWR VPWR picorv32_core.cpuregs\[5\]\[25\]
+ sky130_fd_sc_hd__dfxtp_1
XFILLER_5_777 VGND VGND VPWR VPWR sky130_fd_sc_hd__decap_6
X_11166_ clknet_leaf_32_clk _01017_ VGND VGND VPWR VPWR picorv32_core.cpuregs\[7\]\[20\]
+ sky130_fd_sc_hd__dfxtp_1
XFILLER_96_52 VGND VGND VPWR VPWR sky130_fd_sc_hd__decap_6
X_11097_ clknet_leaf_17_clk _00948_ VGND VGND VPWR VPWR picorv32_core.cpuregs\[0\]\[15\]
+ sky130_fd_sc_hd__dfxtp_1
X_10117_ clknet_leaf_134_clk _00039_ VGND VGND VPWR VPWR picorv32_core.cpuregs\[22\]\[0\]
+ sky130_fd_sc_hd__dfxtp_1
XTAP_TAPCELL_ROW_128_2166 VGND VPWR sky130_fd_sc_hd__tapvpwrvgnd_1
XTAP_TAPCELL_ROW_128_2155 VGND VPWR sky130_fd_sc_hd__tapvpwrvgnd_1
X_10048_ net1347 net301 net304 VGND VGND VPWR VPWR _01523_ sky130_fd_sc_hd__mux2_1
Xhold90 picorv32_core.cpuregs\[26\]\[25\] VGND VGND VPWR VPWR net1199 sky130_fd_sc_hd__dlygate4sd3_1
XFILLER_91_710 VGND VGND VPWR VPWR sky130_fd_sc_hd__fill_1
XFILLER_48_464 VPWR VGND VPWR VGND sky130_ef_sc_hd__decap_12
XFILLER_48_486 VGND VGND VPWR VPWR sky130_fd_sc_hd__fill_1
XTAP_TAPCELL_ROW_141_2355 VGND VPWR sky130_fd_sc_hd__tapvpwrvgnd_1
XTAP_TAPCELL_ROW_141_2344 VGND VPWR sky130_fd_sc_hd__tapvpwrvgnd_1
XFILLER_35_147 VGND VGND VPWR VPWR sky130_fd_sc_hd__decap_4
XTAP_TAPCELL_ROW_141_2366 VGND VPWR sky130_fd_sc_hd__tapvpwrvgnd_1
XFILLER_90_253 VGND VGND VPWR VPWR sky130_fd_sc_hd__decap_4
XPHY_EDGE_ROW_11_Left_153 VGND VGND VPWR VPWR sky130_fd_sc_hd__decap_3
XTAP_TAPCELL_ROW_34_805 VGND VPWR sky130_fd_sc_hd__tapvpwrvgnd_1
XFILLER_50_139 VGND VGND VPWR VPWR sky130_fd_sc_hd__fill_1
XFILLER_84_3 VGND VGND VPWR VPWR sky130_fd_sc_hd__decap_3
X_06210_ _02611_ _02632_ _02640_ VGND VGND VPWR VPWR _02641_ sky130_fd_sc_hd__and3b_1
XFILLER_129_241 VGND VGND VPWR VPWR sky130_fd_sc_hd__decap_3
X_07190_ picorv32_core.count_cycle\[43\] _03349_ net974 VGND VGND VPWR VPWR _03351_
+ sky130_fd_sc_hd__a21oi_1
X_06141_ net608 _02164_ _02165_ _02249_ _02593_ VGND VGND VPWR VPWR _02594_ sky130_fd_sc_hd__a221o_1
X_06072_ _02530_ VGND VGND VPWR VPWR _02531_ sky130_fd_sc_hd__inv_2
XTAP_TAPCELL_ROW_57_1128 VGND VPWR sky130_fd_sc_hd__tapvpwrvgnd_1
XPHY_EDGE_ROW_20_Left_162 VGND VGND VPWR VPWR sky130_fd_sc_hd__decap_3
XFILLER_6_83 VGND VGND VPWR VPWR sky130_fd_sc_hd__fill_1
X_09900_ net502 net2071 net321 VGND VGND VPWR VPWR _01384_ sky130_fd_sc_hd__mux2_1
Xfanout506 net509 VGND VGND VPWR VPWR net506 sky130_fd_sc_hd__clkbuf_4
X_09831_ picorv32_core.cpuregs\[8\]\[29\] picorv32_core.cpuregs\[9\]\[29\] picorv32_core.cpuregs\[10\]\[29\]
+ picorv32_core.cpuregs\[11\]\[29\] net903 net871 VGND VGND VPWR VPWR _05001_ sky130_fd_sc_hd__mux4_1
Xfanout517 _01636_ VGND VGND VPWR VPWR net517 sky130_fd_sc_hd__clkbuf_4
XFILLER_86_515 VGND VGND VPWR VPWR sky130_fd_sc_hd__decap_8
Xfanout528 net530 VGND VGND VPWR VPWR net528 sky130_fd_sc_hd__buf_2
XTAP_TAPCELL_ROW_70_1317 VGND VPWR sky130_fd_sc_hd__tapvpwrvgnd_1
Xfanout539 _03575_ VGND VGND VPWR VPWR net539 sky130_fd_sc_hd__buf_2
XFILLER_59_729 VGND VGND VPWR VPWR sky130_fd_sc_hd__decap_8
X_09762_ picorv32_core.cpuregs\[16\]\[26\] picorv32_core.cpuregs\[17\]\[26\] picorv32_core.cpuregs\[18\]\[26\]
+ picorv32_core.cpuregs\[19\]\[26\] net901 net867 VGND VGND VPWR VPWR _04935_ sky130_fd_sc_hd__mux4_1
X_06974_ _03183_ _03187_ net587 VGND VGND VPWR VPWR _03188_ sky130_fd_sc_hd__a21oi_1
XFILLER_86_537 VGND VGND VPWR VPWR sky130_fd_sc_hd__fill_1
X_08713_ net1547 net230 net385 VGND VGND VPWR VPWR _00862_ sky130_fd_sc_hd__mux2_1
XFILLER_100_336 VGND VGND VPWR VPWR sky130_fd_sc_hd__decap_8
X_05925_ _02393_ _02394_ VGND VGND VPWR VPWR _02396_ sky130_fd_sc_hd__nand2_1
X_09693_ net778 net542 VGND VGND VPWR VPWR _04869_ sky130_fd_sc_hd__or2_1
XFILLER_82_721 VGND VGND VPWR VPWR sky130_fd_sc_hd__fill_1
X_08644_ net1296 net240 net392 VGND VGND VPWR VPWR _00795_ sky130_fd_sc_hd__mux2_1
X_05856_ net669 _02331_ VGND VGND VPWR VPWR _02332_ sky130_fd_sc_hd__and2_1
X_08575_ net226 net2151 net401 VGND VGND VPWR VPWR _00700_ sky130_fd_sc_hd__mux2_1
XFILLER_82_798 VGND VGND VPWR VPWR sky130_fd_sc_hd__fill_2
XFILLER_25_15 VPWR VGND VPWR VGND sky130_ef_sc_hd__decap_12
XFILLER_26_169 VGND VGND VPWR VPWR sky130_fd_sc_hd__decap_4
X_05787_ _02267_ _02268_ VGND VGND VPWR VPWR _02269_ sky130_fd_sc_hd__nand2_1
X_07526_ net2106 _03638_ net463 VGND VGND VPWR VPWR _00352_ sky130_fd_sc_hd__mux2_1
XTAP_TAPCELL_ROW_81_1479 VGND VPWR sky130_fd_sc_hd__tapvpwrvgnd_1
X_07457_ net1527 _03592_ net460 VGND VGND VPWR VPWR _00329_ sky130_fd_sc_hd__mux2_1
XFILLER_136_701 VPWR VGND VPWR VGND sky130_ef_sc_hd__decap_12
X_07388_ _03525_ _03527_ _03410_ VGND VGND VPWR VPWR _03528_ sky130_fd_sc_hd__o21a_1
X_06408_ net449 net1581 net422 VGND VGND VPWR VPWR _00076_ sky130_fd_sc_hd__mux2_1
XFILLER_108_403 VGND VGND VPWR VPWR sky130_fd_sc_hd__fill_2
X_06339_ picorv32_core.reg_out\[20\] picorv32_core.alu_out_q\[20\] net952 VGND VGND
+ VPWR VPWR _02745_ sky130_fd_sc_hd__mux2_1
X_09127_ net1333 net428 net328 VGND VGND VPWR VPWR _01293_ sky130_fd_sc_hd__mux2_1
X_09058_ net1254 net449 net336 VGND VGND VPWR VPWR _01226_ sky130_fd_sc_hd__mux2_1
XTAP_TAPCELL_ROW_20_598 VGND VPWR sky130_fd_sc_hd__tapvpwrvgnd_1
X_08009_ _04080_ _04085_ _04086_ net625 net621 VGND VGND VPWR VPWR _04087_ sky130_fd_sc_hd__a221o_1
XFILLER_104_642 VGND VGND VPWR VPWR sky130_fd_sc_hd__fill_2
Xhold560 picorv32_core.cpuregs\[20\]\[19\] VGND VGND VPWR VPWR net1669 sky130_fd_sc_hd__dlygate4sd3_1
XFILLER_2_725 VPWR VGND VPWR VGND sky130_ef_sc_hd__decap_12
Xhold571 picorv32_core.cpuregs\[2\]\[9\] VGND VGND VPWR VPWR net1680 sky130_fd_sc_hd__dlygate4sd3_1
Xhold593 picorv32_core.cpuregs\[6\]\[25\] VGND VGND VPWR VPWR net1702 sky130_fd_sc_hd__dlygate4sd3_1
XFILLER_89_364 VGND VGND VPWR VPWR sky130_fd_sc_hd__fill_1
Xhold582 picorv32_core.cpuregs\[25\]\[12\] VGND VGND VPWR VPWR net1691 sky130_fd_sc_hd__dlygate4sd3_1
X_11020_ clknet_leaf_136_clk _00871_ VGND VGND VPWR VPWR picorv32_core.cpuregs\[11\]\[2\]
+ sky130_fd_sc_hd__dfxtp_1
XFILLER_2_769 VPWR VGND VPWR VGND sky130_ef_sc_hd__decap_12
X_11853_ net56 VGND VGND VPWR VPWR net88 sky130_fd_sc_hd__buf_1
XFILLER_72_253 VGND VGND VPWR VPWR sky130_fd_sc_hd__fill_1
XFILLER_17_158 VGND VGND VPWR VPWR sky130_fd_sc_hd__fill_1
XFILLER_33_607 VGND VGND VPWR VPWR sky130_fd_sc_hd__fill_1
XTAP_TAPCELL_ROW_123_2085 VGND VPWR sky130_fd_sc_hd__tapvpwrvgnd_1
X_10804_ clknet_leaf_13_clk _00655_ VGND VGND VPWR VPWR picorv32_core.cpuregs\[15\]\[13\]
+ sky130_fd_sc_hd__dfxtp_1
XTAP_TAPCELL_ROW_0_290 VGND VPWR sky130_fd_sc_hd__tapvpwrvgnd_1
X_10735_ clknet_leaf_89_clk _00586_ VGND VGND VPWR VPWR picorv32_core.decoded_imm\[24\]
+ sky130_fd_sc_hd__dfxtp_2
XFILLER_41_673 VGND VGND VPWR VPWR sky130_fd_sc_hd__fill_2
XFILLER_9_335 VGND VGND VPWR VPWR sky130_fd_sc_hd__fill_1
X_10666_ clknet_leaf_106_clk _00520_ VGND VGND VPWR VPWR picorv32_core.decoded_rd\[2\]
+ sky130_fd_sc_hd__dfxtp_1
XFILLER_9_379 VGND VGND VPWR VPWR sky130_fd_sc_hd__fill_1
XFILLER_127_745 VPWR VGND VPWR VGND sky130_ef_sc_hd__decap_12
X_10597_ clknet_leaf_93_clk _00451_ VGND VGND VPWR VPWR picorv32_core.instr_slli sky130_fd_sc_hd__dfxtp_1
Xoutput109 net109 VGND VGND VPWR VPWR mem_axi_wdata[14] sky130_fd_sc_hd__buf_2
XFILLER_141_225 VGND VGND VPWR VPWR sky130_fd_sc_hd__decap_8
XTAP_TAPCELL_ROW_110_1907 VGND VPWR sky130_fd_sc_hd__tapvpwrvgnd_1
X_11218_ clknet_leaf_12_clk _01069_ VGND VGND VPWR VPWR picorv32_core.cpuregs\[5\]\[8\]
+ sky130_fd_sc_hd__dfxtp_1
Xoutput80 net80 VGND VGND VPWR VPWR mem_axi_awaddr[19] sky130_fd_sc_hd__buf_2
XFILLER_95_301 VGND VGND VPWR VPWR sky130_fd_sc_hd__fill_1
XTAP_TAPCELL_ROW_52_1058 VGND VPWR sky130_fd_sc_hd__tapvpwrvgnd_1
X_11149_ clknet_leaf_116_clk _01000_ VGND VGND VPWR VPWR picorv32_core.cpuregs\[7\]\[3\]
+ sky130_fd_sc_hd__dfxtp_1
Xoutput91 net91 VGND VGND VPWR VPWR mem_axi_awaddr[2] sky130_fd_sc_hd__buf_2
XFILLER_110_645 VGND VGND VPWR VPWR sky130_fd_sc_hd__decap_6
XFILLER_95_334 VGND VGND VPWR VPWR sky130_fd_sc_hd__fill_2
XFILLER_83_529 VGND VGND VPWR VPWR sky130_fd_sc_hd__fill_1
X_06690_ picorv32_core.reg_pc\[22\] net553 _02934_ net516 VGND VGND VPWR VPWR _00220_
+ sky130_fd_sc_hd__a22o_1
X_05710_ net799 net175 VGND VGND VPWR VPWR _02194_ sky130_fd_sc_hd__nand2_1
XTAP_TAPCELL_ROW_108_1869 VGND VPWR sky130_fd_sc_hd__tapvpwrvgnd_1
X_05641_ _02123_ _02124_ _02122_ VGND VGND VPWR VPWR _02125_ sky130_fd_sc_hd__a21oi_1
X_08360_ picorv32_core.mem_la_wdata\[2\] net182 net582 VGND VGND VPWR VPWR _04255_
+ sky130_fd_sc_hd__mux2_1
XTAP_TAPCELL_ROW_47_985 VGND VPWR sky130_fd_sc_hd__tapvpwrvgnd_1
X_05572_ net580 _02060_ _02061_ net770 net916 VGND VGND VPWR VPWR _02062_ sky130_fd_sc_hd__a32o_1
X_07311_ net809 picorv32_core.decoded_imm\[6\] VGND VGND VPWR VPWR _03451_ sky130_fd_sc_hd__or2_1
X_08291_ net1423 net216 net413 VGND VGND VPWR VPWR _00515_ sky130_fd_sc_hd__mux2_1
X_07242_ picorv32_core.count_cycle\[61\] net2319 _03380_ _03383_ net977 VGND VGND
+ VPWR VPWR _00323_ sky130_fd_sc_hd__a311oi_1
X_07173_ _03339_ _03340_ VGND VGND VPWR VPWR _00297_ sky130_fd_sc_hd__nor2_1
X_06124_ _02566_ _02570_ _02569_ VGND VGND VPWR VPWR _02579_ sky130_fd_sc_hd__o21bai_1
XFILLER_127_39 VPWR VGND VPWR VGND sky130_ef_sc_hd__decap_12
X_06055_ net608 _02171_ _02172_ net571 _02515_ VGND VGND VPWR VPWR _02516_ sky130_fd_sc_hd__a221o_1
Xfanout314 net315 VGND VGND VPWR VPWR net314 sky130_fd_sc_hd__clkbuf_8
Xfanout303 _01921_ VGND VGND VPWR VPWR net303 sky130_fd_sc_hd__buf_2
X_09814_ net832 _04984_ VGND VGND VPWR VPWR _04985_ sky130_fd_sc_hd__or2_1
Xfanout347 _04347_ VGND VGND VPWR VPWR net347 sky130_fd_sc_hd__buf_4
XFILLER_98_150 VGND VGND VPWR VPWR sky130_fd_sc_hd__decap_4
Xfanout336 net337 VGND VGND VPWR VPWR net336 sky130_fd_sc_hd__buf_4
Xfanout325 _05029_ VGND VGND VPWR VPWR net325 sky130_fd_sc_hd__buf_4
XFILLER_113_494 VGND VGND VPWR VPWR sky130_fd_sc_hd__decap_3
Xfanout369 _04341_ VGND VGND VPWR VPWR net369 sky130_fd_sc_hd__buf_4
Xfanout358 _04343_ VGND VGND VPWR VPWR net358 sky130_fd_sc_hd__clkbuf_8
X_09745_ _04911_ _04912_ _04915_ _04916_ net660 net647 VGND VGND VPWR VPWR _04919_
+ sky130_fd_sc_hd__mux4_1
XFILLER_101_689 VPWR VGND VPWR VGND sky130_ef_sc_hd__decap_12
X_06957_ _03165_ _03170_ VGND VGND VPWR VPWR _03172_ sky130_fd_sc_hd__or2_1
XFILLER_74_507 VGND VGND VPWR VPWR sky130_fd_sc_hd__decap_3
X_09676_ picorv32_core.cpuregs\[24\]\[22\] picorv32_core.cpuregs\[25\]\[22\] picorv32_core.cpuregs\[26\]\[22\]
+ picorv32_core.cpuregs\[27\]\[22\] net895 net861 VGND VGND VPWR VPWR _04853_ sky130_fd_sc_hd__mux4_1
X_06888_ _03106_ _03107_ VGND VGND VPWR VPWR _03108_ sky130_fd_sc_hd__or2_1
X_05908_ _02354_ _02367_ _02368_ VGND VGND VPWR VPWR _02380_ sky130_fd_sc_hd__a21o_1
XTAP_TAPCELL_ROW_83_1508 VGND VPWR sky130_fd_sc_hd__tapvpwrvgnd_1
X_08627_ net1311 net449 net390 VGND VGND VPWR VPWR _00778_ sky130_fd_sc_hd__mux2_1
X_05839_ _02313_ _02316_ VGND VGND VPWR VPWR _02317_ sky130_fd_sc_hd__nand2_1
X_08558_ net298 net1853 net398 VGND VGND VPWR VPWR _00683_ sky130_fd_sc_hd__mux2_1
X_07509_ picorv32_core.reg_out\[23\] picorv32_core.reg_next_pc\[23\] net561 VGND VGND
+ VPWR VPWR _03627_ sky130_fd_sc_hd__mux2_1
XFILLER_52_35 VGND VGND VPWR VPWR sky130_fd_sc_hd__fill_1
X_08489_ net1992 net300 net406 VGND VGND VPWR VPWR _00619_ sky130_fd_sc_hd__mux2_1
XTAP_TAPCELL_ROW_25_668 VGND VPWR sky130_fd_sc_hd__tapvpwrvgnd_1
X_10520_ clknet_leaf_127_clk picorv32_core.alu_out\[8\] VGND VGND VPWR VPWR picorv32_core.alu_out_q\[8\]
+ sky130_fd_sc_hd__dfxtp_1
X_10451_ clknet_leaf_81_clk _00338_ VGND VGND VPWR VPWR net43 sky130_fd_sc_hd__dfxtp_1
XFILLER_108_233 VGND VGND VPWR VPWR sky130_fd_sc_hd__decap_3
XFILLER_124_726 VPWR VGND VPWR VGND sky130_ef_sc_hd__decap_12
X_10382_ clknet_leaf_101_clk _00301_ VGND VGND VPWR VPWR picorv32_core.count_cycle\[40\]
+ sky130_fd_sc_hd__dfxtp_1
Xhold390 picorv32_core.cpuregs\[14\]\[11\] VGND VGND VPWR VPWR net1499 sky130_fd_sc_hd__dlygate4sd3_1
XFILLER_132_781 VPWR VGND VPWR VGND sky130_ef_sc_hd__decap_12
X_11003_ clknet_leaf_24_clk _00854_ VGND VGND VPWR VPWR picorv32_core.cpuregs\[12\]\[17\]
+ sky130_fd_sc_hd__dfxtp_1
XFILLER_77_323 VGND VGND VPWR VPWR sky130_fd_sc_hd__decap_6
Xfanout870 net871 VGND VGND VPWR VPWR net870 sky130_fd_sc_hd__clkbuf_2
XTAP_TAPCELL_ROW_125_2114 VGND VPWR sky130_fd_sc_hd__tapvpwrvgnd_1
XFILLER_93_827 VGND VGND VPWR VPWR sky130_fd_sc_hd__fill_2
XFILLER_93_816 VGND VGND VPWR VPWR sky130_fd_sc_hd__fill_2
Xfanout892 net893 VGND VGND VPWR VPWR net892 sky130_fd_sc_hd__buf_4
XFILLER_77_378 VGND VGND VPWR VPWR sky130_fd_sc_hd__decap_6
Xfanout881 net883 VGND VGND VPWR VPWR net881 sky130_fd_sc_hd__buf_4
XTAP_TAPCELL_ROW_5_382 VGND VPWR sky130_fd_sc_hd__tapvpwrvgnd_1
XTAP_TAPCELL_ROW_5_371 VGND VPWR sky130_fd_sc_hd__tapvpwrvgnd_1
XFILLER_133_93 VGND VGND VPWR VPWR sky130_fd_sc_hd__decap_8
XFILLER_93_20 VGND VGND VPWR VPWR sky130_fd_sc_hd__fill_2
Xhold1090 picorv32_core.cpuregs\[6\]\[21\] VGND VGND VPWR VPWR net2199 sky130_fd_sc_hd__dlygate4sd3_1
XFILLER_45_286 VGND VGND VPWR VPWR sky130_fd_sc_hd__fill_1
X_11836_ net39 VGND VGND VPWR VPWR net71 sky130_fd_sc_hd__clkbuf_1
XTAP_TAPCELL_ROW_44_944 VGND VPWR sky130_fd_sc_hd__tapvpwrvgnd_1
XTAP_TAPCELL_ROW_103_1799 VGND VPWR sky130_fd_sc_hd__tapvpwrvgnd_1
X_10718_ clknet_leaf_6_clk _00569_ VGND VGND VPWR VPWR net124 sky130_fd_sc_hd__dfxtp_1
X_11698_ clknet_leaf_15_clk _01529_ VGND VGND VPWR VPWR picorv32_core.cpuregs\[27\]\[15\]
+ sky130_fd_sc_hd__dfxtp_1
XFILLER_139_391 VGND VGND VPWR VPWR sky130_fd_sc_hd__fill_1
XTAP_TAPCELL_ROW_136_2276 VGND VPWR sky130_fd_sc_hd__tapvpwrvgnd_1
X_10649_ clknet_leaf_24_clk _00503_ VGND VGND VPWR VPWR picorv32_core.cpuregs\[20\]\[17\]
+ sky130_fd_sc_hd__dfxtp_1
XFILLER_115_726 VGND VGND VPWR VPWR sky130_fd_sc_hd__fill_2
XFILLER_115_759 VPWR VGND VPWR VGND sky130_ef_sc_hd__decap_12
XFILLER_5_393 VGND VGND VPWR VPWR sky130_fd_sc_hd__fill_2
XFILLER_69_835 VGND VGND VPWR VPWR sky130_fd_sc_hd__fill_2
X_07860_ picorv32_core.cpuregs\[0\]\[19\] picorv32_core.cpuregs\[1\]\[19\] picorv32_core.cpuregs\[2\]\[19\]
+ picorv32_core.cpuregs\[3\]\[19\] net748 net715 VGND VGND VPWR VPWR _03946_ sky130_fd_sc_hd__mux4_1
XFILLER_3_51 VGND VGND VPWR VPWR sky130_fd_sc_hd__decap_4
X_07791_ _03878_ _03879_ net635 VGND VGND VPWR VPWR _03881_ sky130_fd_sc_hd__mux2_1
X_06811_ _03035_ _03036_ VGND VGND VPWR VPWR _03037_ sky130_fd_sc_hd__and2_1
X_09530_ picorv32_core.reg_pc\[15\] net537 _04713_ net484 VGND VGND VPWR VPWR _04714_
+ sky130_fd_sc_hd__a211o_1
XFILLER_37_732 VPWR VGND VPWR VGND sky130_ef_sc_hd__decap_12
X_06742_ net665 picorv32_core.reg_next_pc\[4\] _02916_ net491 VGND VGND VPWR VPWR
+ _02974_ sky130_fd_sc_hd__a22o_1
X_09461_ net836 _04646_ net643 VGND VGND VPWR VPWR _04648_ sky130_fd_sc_hd__o21a_1
XFILLER_91_370 VGND VGND VPWR VPWR sky130_fd_sc_hd__fill_1
X_06673_ _02721_ picorv32_core.reg_next_pc\[14\] net558 VGND VGND VPWR VPWR _02926_
+ sky130_fd_sc_hd__mux2_1
X_05624_ net945 picorv32_core.count_cycle\[62\] net604 _02109_ VGND VGND VPWR VPWR
+ _02110_ sky130_fd_sc_hd__a211o_1
X_08412_ picorv32_core.decoded_imm\[31\] net529 net442 _04286_ VGND VGND VPWR VPWR
+ _00579_ sky130_fd_sc_hd__o22a_1
XTAP_TAPCELL_ROW_65_1249 VGND VPWR sky130_fd_sc_hd__tapvpwrvgnd_1
XFILLER_52_757 VGND VGND VPWR VPWR sky130_fd_sc_hd__fill_2
X_09392_ picorv32_core.cpuregs\[8\]\[9\] picorv32_core.cpuregs\[9\]\[9\] picorv32_core.cpuregs\[10\]\[9\]
+ picorv32_core.cpuregs\[11\]\[9\] net873 net840 VGND VGND VPWR VPWR _04582_ sky130_fd_sc_hd__mux4_1
X_05555_ _02032_ _02035_ _02044_ VGND VGND VPWR VPWR _02046_ sky130_fd_sc_hd__a21o_1
X_08343_ net1157 net456 _04244_ VGND VGND VPWR VPWR _00552_ sky130_fd_sc_hd__o21a_1
X_08274_ net1467 net287 net410 VGND VGND VPWR VPWR _00498_ sky130_fd_sc_hd__mux2_1
XFILLER_20_643 VGND VGND VPWR VPWR sky130_fd_sc_hd__fill_1
XTAP_TAPCELL_ROW_22_627 VGND VPWR sky130_fd_sc_hd__tapvpwrvgnd_1
X_07225_ picorv32_core.count_cycle\[55\] _03370_ picorv32_core.count_cycle\[56\] VGND
+ VGND VPWR VPWR _03373_ sky130_fd_sc_hd__a21o_1
X_05486_ _01943_ _01947_ _01981_ VGND VGND VPWR VPWR _01982_ sky130_fd_sc_hd__o21a_1
XFILLER_22_27 VGND VGND VPWR VPWR sky130_fd_sc_hd__fill_1
XFILLER_138_27 VGND VGND VPWR VPWR sky130_fd_sc_hd__fill_1
XFILLER_20_698 VGND VGND VPWR VPWR sky130_fd_sc_hd__fill_2
X_07156_ net2280 _03328_ net995 VGND VGND VPWR VPWR _03330_ sky130_fd_sc_hd__o21ai_1
X_06107_ _02545_ _02552_ _02553_ VGND VGND VPWR VPWR _02563_ sky130_fd_sc_hd__nand3_1
X_07087_ picorv32_core.count_cycle\[4\] _03284_ _03286_ VGND VGND VPWR VPWR _00265_
+ sky130_fd_sc_hd__o21a_1
X_06038_ _02472_ _02480_ _02486_ _02487_ VGND VGND VPWR VPWR _02500_ sky130_fd_sc_hd__a31o_1
XFILLER_121_729 VPWR VGND VPWR VGND sky130_ef_sc_hd__decap_12
XFILLER_120_206 VGND VGND VPWR VPWR sky130_fd_sc_hd__fill_1
XFILLER_114_781 VPWR VGND VPWR VGND sky130_ef_sc_hd__decap_12
XFILLER_99_481 VGND VGND VPWR VPWR sky130_fd_sc_hd__fill_1
XFILLER_75_805 VGND VGND VPWR VPWR sky130_fd_sc_hd__fill_2
XFILLER_59_334 VGND VGND VPWR VPWR sky130_fd_sc_hd__fill_2
XFILLER_101_453 VGND VGND VPWR VPWR sky130_fd_sc_hd__decap_4
XFILLER_74_304 VGND VGND VPWR VPWR sky130_fd_sc_hd__decap_4
X_07989_ net697 _04060_ net686 VGND VGND VPWR VPWR _04068_ sky130_fd_sc_hd__o21a_1
X_09728_ net651 _04900_ _04902_ net481 VGND VGND VPWR VPWR _04903_ sky130_fd_sc_hd__o211a_1
XFILLER_86_197 VGND VGND VPWR VPWR sky130_fd_sc_hd__fill_2
XTAP_TAPCELL_ROW_2_341 VGND VPWR sky130_fd_sc_hd__tapvpwrvgnd_1
XTAP_TAPCELL_ROW_2_330 VGND VPWR sky130_fd_sc_hd__tapvpwrvgnd_1
XPHY_EDGE_ROW_29_Right_29 VGND VGND VPWR VPWR sky130_fd_sc_hd__decap_3
XFILLER_47_57 VGND VGND VPWR VPWR sky130_fd_sc_hd__fill_1
X_09659_ _04828_ _04829_ _04832_ _04833_ net658 net646 VGND VGND VPWR VPWR _04837_
+ sky130_fd_sc_hd__mux4_1
XFILLER_15_404 VGND VGND VPWR VPWR sky130_fd_sc_hd__fill_1
XTAP_TAPCELL_ROW_120_2044 VGND VPWR sky130_fd_sc_hd__tapvpwrvgnd_1
XFILLER_70_543 VGND VGND VPWR VPWR sky130_fd_sc_hd__fill_1
X_11621_ clknet_leaf_134_clk _01452_ VGND VGND VPWR VPWR picorv32_core.cpuregs\[28\]\[2\]
+ sky130_fd_sc_hd__dfxtp_1
XTAP_TAPCELL_ROW_41_903 VGND VPWR sky130_fd_sc_hd__tapvpwrvgnd_1
XFILLER_8_29 VPWR VGND VPWR VGND sky130_ef_sc_hd__decap_12
XFILLER_10_131 VGND VGND VPWR VPWR sky130_fd_sc_hd__fill_1
X_11552_ clknet_leaf_107_clk _01383_ VGND VGND VPWR VPWR picorv32_core.mem_state\[1\]
+ sky130_fd_sc_hd__dfxtp_1
XPHY_EDGE_ROW_38_Right_38 VGND VGND VPWR VPWR sky130_fd_sc_hd__decap_3
X_10503_ clknet_leaf_62_clk _00389_ VGND VGND VPWR VPWR net194 sky130_fd_sc_hd__dfxtp_1
XFILLER_109_531 VGND VGND VPWR VPWR sky130_fd_sc_hd__decap_6
X_11483_ clknet_leaf_119_clk _01319_ VGND VGND VPWR VPWR net141 sky130_fd_sc_hd__dfxtp_1
X_10434_ clknet_leaf_86_clk _01566_ VGND VGND VPWR VPWR picorv32_core.reg_out\[27\]
+ sky130_fd_sc_hd__dfxtp_1
XFILLER_7_669 VGND VGND VPWR VPWR sky130_fd_sc_hd__decap_3
X_10365_ clknet_leaf_85_clk _00284_ VGND VGND VPWR VPWR picorv32_core.count_cycle\[23\]
+ sky130_fd_sc_hd__dfxtp_1
XFILLER_112_707 VGND VGND VPWR VPWR sky130_fd_sc_hd__decap_4
XFILLER_111_206 VGND VGND VPWR VPWR sky130_fd_sc_hd__fill_1
X_10296_ clknet_leaf_88_clk _00215_ VGND VGND VPWR VPWR picorv32_core.reg_pc\[17\]
+ sky130_fd_sc_hd__dfxtp_1
XFILLER_2_396 VPWR VGND VPWR VGND sky130_ef_sc_hd__decap_12
XFILLER_78_698 VGND VGND VPWR VPWR sky130_fd_sc_hd__fill_2
XPHY_EDGE_ROW_47_Right_47 VGND VGND VPWR VPWR sky130_fd_sc_hd__decap_3
XFILLER_93_668 VGND VGND VPWR VPWR sky130_fd_sc_hd__fill_1
XFILLER_19_765 VPWR VGND VPWR VGND sky130_ef_sc_hd__decap_12
XTAP_TAPCELL_ROW_105_1828 VGND VPWR sky130_fd_sc_hd__tapvpwrvgnd_1
XFILLER_33_234 VGND VGND VPWR VPWR sky130_fd_sc_hd__fill_2
XTAP_TAPCELL_ROW_138_2305 VGND VPWR sky130_fd_sc_hd__tapvpwrvgnd_1
XPHY_EDGE_ROW_56_Right_56 VGND VGND VPWR VPWR sky130_fd_sc_hd__decap_3
X_05340_ net921 _01838_ _01839_ _01846_ VGND VGND VPWR VPWR _01578_ sky130_fd_sc_hd__a31o_1
XTAP_TAPCELL_ROW_60_1168 VGND VPWR sky130_fd_sc_hd__tapvpwrvgnd_1
XTAP_TAPCELL_ROW_60_1179 VGND VPWR sky130_fd_sc_hd__tapvpwrvgnd_1
X_05271_ _01777_ _01780_ net920 VGND VGND VPWR VPWR _01782_ sky130_fd_sc_hd__o21a_1
XFILLER_134_309 VGND VGND VPWR VPWR sky130_fd_sc_hd__fill_2
X_07010_ net678 _03220_ _03217_ net589 VGND VGND VPWR VPWR _03221_ sky130_fd_sc_hd__o211a_1
XFILLER_115_567 VGND VGND VPWR VPWR sky130_fd_sc_hd__fill_2
XPHY_EDGE_ROW_65_Right_65 VGND VGND VPWR VPWR sky130_fd_sc_hd__decap_3
X_08961_ net1415 net427 net348 VGND VGND VPWR VPWR _01133_ sky130_fd_sc_hd__mux2_1
XFILLER_124_29 VPWR VGND VPWR VGND sky130_ef_sc_hd__decap_12
X_07912_ picorv32_core.cpuregs\[28\]\[22\] picorv32_core.cpuregs\[29\]\[22\] picorv32_core.cpuregs\[30\]\[22\]
+ picorv32_core.cpuregs\[31\]\[22\] net749 net716 VGND VGND VPWR VPWR _03995_ sky130_fd_sc_hd__mux4_1
XFILLER_96_440 VGND VGND VPWR VPWR sky130_fd_sc_hd__fill_2
X_08892_ net448 net1688 net358 VGND VGND VPWR VPWR _01066_ sky130_fd_sc_hd__mux2_1
XFILLER_96_462 VGND VGND VPWR VPWR sky130_fd_sc_hd__fill_1
X_07843_ net635 _03929_ VGND VGND VPWR VPWR _03930_ sky130_fd_sc_hd__or2_1
XFILLER_110_272 VGND VGND VPWR VPWR sky130_fd_sc_hd__fill_1
XPHY_EDGE_ROW_3_Left_145 VGND VGND VPWR VPWR sky130_fd_sc_hd__decap_3
X_07774_ _03859_ _03860_ net629 VGND VGND VPWR VPWR _03865_ sky130_fd_sc_hd__mux2_1
X_09513_ net794 net546 VGND VGND VPWR VPWR _04697_ sky130_fd_sc_hd__or2_1
XFILLER_24_201 VGND VGND VPWR VPWR sky130_fd_sc_hd__fill_1
X_06725_ _02956_ _02957_ VGND VGND VPWR VPWR _02958_ sky130_fd_sc_hd__and2_1
X_09444_ net283 _04616_ _04631_ _04609_ VGND VGND VPWR VPWR _01330_ sky130_fd_sc_hd__a31o_1
XFILLER_52_554 VGND VGND VPWR VPWR sky130_fd_sc_hd__fill_1
X_06656_ picorv32_core.reg_pc\[5\] net551 _02917_ net514 VGND VGND VPWR VPWR _00203_
+ sky130_fd_sc_hd__a22o_1
X_05607_ _02091_ _02092_ _02093_ VGND VGND VPWR VPWR _02094_ sky130_fd_sc_hd__o21bai_1
XPHY_EDGE_ROW_74_Right_74 VGND VGND VPWR VPWR sky130_fd_sc_hd__decap_3
XFILLER_33_15 VPWR VGND VPWR VGND sky130_ef_sc_hd__decap_12
X_06587_ _02873_ net992 _02872_ VGND VGND VPWR VPWR _00178_ sky130_fd_sc_hd__and3b_1
X_09375_ net806 net281 VGND VGND VPWR VPWR _04566_ sky130_fd_sc_hd__and2_1
X_05538_ _01986_ _01995_ _02028_ _02029_ VGND VGND VPWR VPWR _02030_ sky130_fd_sc_hd__o31a_1
X_08326_ net967 net1169 net453 VGND VGND VPWR VPWR _00543_ sky130_fd_sc_hd__mux2_1
XFILLER_137_125 VGND VGND VPWR VPWR sky130_fd_sc_hd__decap_8
X_05469_ picorv32_core.reg_pc\[19\] picorv32_core.decoded_imm\[19\] VGND VGND VPWR
+ VPWR _01966_ sky130_fd_sc_hd__nor2_1
X_08257_ net2340 _00755_ net439 VGND VGND VPWR VPWR _00483_ sky130_fd_sc_hd__mux2_1
XFILLER_137_169 VGND VGND VPWR VPWR sky130_fd_sc_hd__fill_2
X_07208_ _03362_ net991 _03361_ VGND VGND VPWR VPWR _00310_ sky130_fd_sc_hd__and3b_1
XTAP_TAPCELL_ROW_78_1429 VGND VPWR sky130_fd_sc_hd__tapvpwrvgnd_1
X_08188_ net1158 net477 _04180_ _04199_ VGND VGND VPWR VPWR _00444_ sky130_fd_sc_hd__a22o_1
XFILLER_106_501 VGND VGND VPWR VPWR sky130_fd_sc_hd__decap_4
X_07139_ picorv32_core.count_cycle\[22\] picorv32_core.count_cycle\[23\] picorv32_core.count_cycle\[24\]
+ _03314_ VGND VGND VPWR VPWR _03319_ sky130_fd_sc_hd__and4_1
XFILLER_3_105 VGND VGND VPWR VPWR sky130_fd_sc_hd__decap_6
XFILLER_106_545 VGND VGND VPWR VPWR sky130_fd_sc_hd__decap_3
XTAP_TAPCELL_ROW_91_1629 VGND VPWR sky130_fd_sc_hd__tapvpwrvgnd_1
XTAP_TAPCELL_ROW_91_1618 VGND VPWR sky130_fd_sc_hd__tapvpwrvgnd_1
XPHY_EDGE_ROW_83_Right_83 VGND VGND VPWR VPWR sky130_fd_sc_hd__decap_3
XFILLER_3_149 VPWR VGND VPWR VGND sky130_ef_sc_hd__decap_12
XTAP_TAPCELL_ROW_7_411 VGND VPWR sky130_fd_sc_hd__tapvpwrvgnd_1
XTAP_TAPCELL_ROW_7_400 VGND VPWR sky130_fd_sc_hd__tapvpwrvgnd_1
X_10150_ clknet_leaf_121_clk _00035_ VGND VGND VPWR VPWR picorv32_core.reg_sh\[3\]
+ sky130_fd_sc_hd__dfxtp_1
XFILLER_58_45 VGND VGND VPWR VPWR sky130_fd_sc_hd__fill_2
X_10081_ picorv32_core.decoded_imm_j\[2\] _00763_ net437 VGND VGND VPWR VPWR _00529_
+ sky130_fd_sc_hd__mux2_1
XFILLER_87_462 VGND VGND VPWR VPWR sky130_fd_sc_hd__decap_4
XFILLER_75_602 VGND VGND VPWR VPWR sky130_fd_sc_hd__decap_3
X_10983_ clknet_leaf_70_clk _00834_ VGND VGND VPWR VPWR picorv32_core.cpuregs\[13\]\[29\]
+ sky130_fd_sc_hd__dfxtp_1
XFILLER_28_584 VGND VGND VPWR VPWR sky130_fd_sc_hd__decap_4
XPHY_EDGE_ROW_92_Right_92 VGND VGND VPWR VPWR sky130_fd_sc_hd__decap_3
XFILLER_15_234 VGND VGND VPWR VPWR sky130_fd_sc_hd__decap_4
XFILLER_16_757 VPWR VGND VPWR VGND sky130_ef_sc_hd__decap_12
XPHY_EDGE_ROW_133_Right_133 VGND VGND VPWR VPWR sky130_fd_sc_hd__decap_3
XFILLER_15_278 VGND VGND VPWR VPWR sky130_fd_sc_hd__fill_2
XFILLER_130_83 VGND VGND VPWR VPWR sky130_fd_sc_hd__fill_1
XTAP_TAPCELL_ROW_100_1758 VGND VPWR sky130_fd_sc_hd__tapvpwrvgnd_1
X_11604_ clknet_leaf_25_clk _01435_ VGND VGND VPWR VPWR picorv32_core.cpuregs\[23\]\[17\]
+ sky130_fd_sc_hd__dfxtp_1
X_11535_ clknet_leaf_19_clk _01366_ VGND VGND VPWR VPWR picorv32_core.cpuregs\[30\]\[16\]
+ sky130_fd_sc_hd__dfxtp_1
XFILLER_23_70 VGND VGND VPWR VPWR sky130_fd_sc_hd__fill_1
XFILLER_139_81 VPWR VGND VPWR VGND sky130_ef_sc_hd__decap_12
XTAP_TAPCELL_ROW_133_2235 VGND VPWR sky130_fd_sc_hd__tapvpwrvgnd_1
Xwire353 _04345_ VGND VGND VPWR VPWR net353 sky130_fd_sc_hd__clkbuf_2
XFILLER_125_821 VPWR VGND VPWR VGND sky130_ef_sc_hd__decap_12
X_11466_ clknet_leaf_23_clk _01302_ VGND VGND VPWR VPWR picorv32_core.cpuregs\[24\]\[17\]
+ sky130_fd_sc_hd__dfxtp_1
X_10417_ clknet_leaf_91_clk _01548_ VGND VGND VPWR VPWR picorv32_core.reg_out\[10\]
+ sky130_fd_sc_hd__dfxtp_1
X_11397_ clknet_leaf_10_clk _01233_ VGND VGND VPWR VPWR picorv32_core.cpuregs\[31\]\[12\]
+ sky130_fd_sc_hd__dfxtp_1
XFILLER_140_813 VPWR VGND VPWR VGND sky130_ef_sc_hd__decap_12
X_10348_ clknet_leaf_104_clk _00267_ VGND VGND VPWR VPWR picorv32_core.count_cycle\[6\]
+ sky130_fd_sc_hd__dfxtp_1
X_10279_ clknet_leaf_74_clk _00198_ VGND VGND VPWR VPWR picorv32_core.count_instr\[63\]
+ sky130_fd_sc_hd__dfxtp_1
XFILLER_78_451 VGND VGND VPWR VPWR sky130_fd_sc_hd__fill_2
XFILLER_93_443 VGND VGND VPWR VPWR sky130_fd_sc_hd__decap_4
XFILLER_66_679 VGND VGND VPWR VPWR sky130_fd_sc_hd__decap_8
XFILLER_81_638 VGND VGND VPWR VPWR sky130_fd_sc_hd__fill_2
XFILLER_65_178 VGND VGND VPWR VPWR sky130_fd_sc_hd__decap_3
XTAP_TAPCELL_ROW_49_1019 VGND VPWR sky130_fd_sc_hd__tapvpwrvgnd_1
XFILLER_0_41 VPWR VGND VPWR VGND sky130_ef_sc_hd__decap_12
Xclkbuf_leaf_139_clk clknet_4_2_0_clk VGND VGND VPWR VPWR clknet_leaf_139_clk sky130_fd_sc_hd__clkbuf_8
X_07490_ net2346 _03614_ net462 VGND VGND VPWR VPWR _00340_ sky130_fd_sc_hd__mux2_1
XFILLER_81_649 VGND VGND VPWR VPWR sky130_fd_sc_hd__fill_1
X_06510_ _02824_ net991 _02823_ VGND VGND VPWR VPWR _00150_ sky130_fd_sc_hd__and3b_1
XFILLER_0_85 VPWR VGND VPWR VGND sky130_ef_sc_hd__decap_12
XTAP_TAPCELL_ROW_62_1208 VGND VPWR sky130_fd_sc_hd__tapvpwrvgnd_1
XFILLER_61_340 VGND VGND VPWR VPWR sky130_fd_sc_hd__fill_2
X_06441_ net465 net1571 net421 VGND VGND VPWR VPWR _00107_ sky130_fd_sc_hd__mux2_1
XPHY_EDGE_ROW_100_Right_100 VGND VGND VPWR VPWR sky130_fd_sc_hd__decap_3
X_06372_ picorv32_core.reg_pc\[26\] _02768_ VGND VGND VPWR VPWR _02772_ sky130_fd_sc_hd__xor2_1
X_09160_ net649 _04354_ _04358_ net827 VGND VGND VPWR VPWR _04359_ sky130_fd_sc_hd__a211o_1
XTAP_TAPCELL_ROW_32_766 VGND VPWR sky130_fd_sc_hd__tapvpwrvgnd_1
XFILLER_119_125 VGND VGND VPWR VPWR sky130_fd_sc_hd__decap_6
X_05323_ _01829_ _01830_ VGND VGND VPWR VPWR _01831_ sky130_fd_sc_hd__and2_1
X_09091_ net448 net2014 net332 VGND VGND VPWR VPWR _01258_ sky130_fd_sc_hd__mux2_1
X_08111_ net445 net1478 net414 VGND VGND VPWR VPWR _00404_ sky130_fd_sc_hd__mux2_1
XFILLER_30_793 VPWR VGND VPWR VGND sky130_ef_sc_hd__decap_12
X_08042_ picorv32_core.cpuregs\[8\]\[29\] picorv32_core.cpuregs\[9\]\[29\] picorv32_core.cpuregs\[10\]\[29\]
+ picorv32_core.cpuregs\[11\]\[29\] net762 net729 VGND VGND VPWR VPWR _04118_ sky130_fd_sc_hd__mux4_1
X_05254_ picorv32_core.reg_pc\[4\] picorv32_core.decoded_imm\[4\] VGND VGND VPWR VPWR
+ _01766_ sky130_fd_sc_hd__or2_1
Xhold901 picorv32_core.cpuregs\[8\]\[31\] VGND VGND VPWR VPWR net2010 sky130_fd_sc_hd__dlygate4sd3_1
Xhold912 picorv32_core.cpuregs\[2\]\[20\] VGND VGND VPWR VPWR net2021 sky130_fd_sc_hd__dlygate4sd3_1
Xhold945 picorv32_core.cpuregs\[19\]\[26\] VGND VGND VPWR VPWR net2054 sky130_fd_sc_hd__dlygate4sd3_1
Xhold934 picorv32_core.cpuregs\[28\]\[23\] VGND VGND VPWR VPWR net2043 sky130_fd_sc_hd__dlygate4sd3_1
Xhold923 picorv32_core.cpuregs\[10\]\[4\] VGND VGND VPWR VPWR net2032 sky130_fd_sc_hd__dlygate4sd3_1
X_05185_ _01692_ _01706_ VGND VGND VPWR VPWR _01707_ sky130_fd_sc_hd__or2_1
Xhold978 picorv32_core.cpuregs\[5\]\[27\] VGND VGND VPWR VPWR net2087 sky130_fd_sc_hd__dlygate4sd3_1
XFILLER_130_301 VGND VGND VPWR VPWR sky130_fd_sc_hd__decap_6
X_09993_ net2028 net247 net315 VGND VGND VPWR VPWR _01470_ sky130_fd_sc_hd__mux2_1
Xhold956 picorv32_core.cpuregs\[15\]\[18\] VGND VGND VPWR VPWR net2065 sky130_fd_sc_hd__dlygate4sd3_1
Xhold989 picorv32_core.is_lb_lh_lw_lbu_lhu VGND VGND VPWR VPWR net2098 sky130_fd_sc_hd__dlygate4sd3_1
Xhold967 picorv32_core.cpuregs\[19\]\[1\] VGND VGND VPWR VPWR net2076 sky130_fd_sc_hd__dlygate4sd3_1
XFILLER_135_39 VPWR VGND VPWR VGND sky130_ef_sc_hd__decap_12
X_08944_ net232 net1890 net356 VGND VGND VPWR VPWR _01117_ sky130_fd_sc_hd__mux2_1
XFILLER_103_537 VGND VGND VPWR VPWR sky130_fd_sc_hd__fill_1
XTAP_TAPCELL_ROW_73_1359 VGND VPWR sky130_fd_sc_hd__tapvpwrvgnd_1
XFILLER_69_462 VGND VGND VPWR VPWR sky130_fd_sc_hd__fill_1
XFILLER_111_581 VGND VGND VPWR VPWR sky130_fd_sc_hd__decap_3
X_08875_ net244 net2199 net363 VGND VGND VPWR VPWR _01050_ sky130_fd_sc_hd__mux2_1
XFILLER_28_15 VPWR VGND VPWR VGND sky130_ef_sc_hd__decap_12
XFILLER_28_37 VGND VGND VPWR VPWR sky130_fd_sc_hd__fill_1
XFILLER_29_315 VGND VGND VPWR VPWR sky130_fd_sc_hd__fill_2
XFILLER_84_432 VGND VGND VPWR VPWR sky130_fd_sc_hd__decap_3
X_07826_ net634 _03904_ net685 VGND VGND VPWR VPWR _03914_ sky130_fd_sc_hd__o21a_1
X_07757_ _03840_ _03841_ net630 VGND VGND VPWR VPWR _03849_ sky130_fd_sc_hd__mux2_1
X_06708_ picorv32_core.reg_pc\[31\] net553 _02943_ net516 VGND VGND VPWR VPWR _00229_
+ sky130_fd_sc_hd__a22o_1
XTAP_TAPCELL_ROW_88_1580 VGND VPWR sky130_fd_sc_hd__tapvpwrvgnd_1
X_07688_ _03781_ _03783_ net457 _03780_ VGND VGND VPWR VPWR _03784_ sky130_fd_sc_hd__o211a_1
X_06639_ picorv32_core.count_instr\[62\] _02905_ net977 VGND VGND VPWR VPWR _02907_
+ sky130_fd_sc_hd__a21oi_1
X_09427_ net474 _04548_ _04612_ _04614_ VGND VGND VPWR VPWR _04615_ sky130_fd_sc_hd__a31o_1
X_09358_ net469 _04482_ _04548_ net486 VGND VGND VPWR VPWR _04549_ sky130_fd_sc_hd__a31o_1
X_08309_ _04174_ _04230_ VGND VGND VPWR VPWR _04231_ sky130_fd_sc_hd__and2_1
XTAP_TAPCELL_ROW_10_449 VGND VPWR sky130_fd_sc_hd__tapvpwrvgnd_1
X_11320_ clknet_leaf_111_clk _01161_ VGND VGND VPWR VPWR picorv32_core.cpuregs\[29\]\[4\]
+ sky130_fd_sc_hd__dfxtp_1
X_09289_ net814 net810 net541 VGND VGND VPWR VPWR _04483_ sky130_fd_sc_hd__mux2_1
XFILLER_114_3 VPWR VGND VPWR VGND sky130_ef_sc_hd__decap_12
XFILLER_107_821 VGND VGND VPWR VPWR sky130_fd_sc_hd__decap_3
XFILLER_4_414 VGND VGND VPWR VPWR sky130_fd_sc_hd__decap_6
XFILLER_118_180 VGND VGND VPWR VPWR sky130_fd_sc_hd__fill_1
XFILLER_69_11 VGND VGND VPWR VPWR sky130_fd_sc_hd__decap_6
X_11251_ clknet_leaf_141_clk _01099_ VGND VGND VPWR VPWR picorv32_core.cpuregs\[4\]\[6\]
+ sky130_fd_sc_hd__dfxtp_1
XFILLER_140_109 VPWR VGND VPWR VGND sky130_ef_sc_hd__decap_12
XFILLER_133_150 VGND VGND VPWR VPWR sky130_fd_sc_hd__fill_2
XFILLER_122_813 VGND VGND VPWR VPWR sky130_fd_sc_hd__decap_8
X_10202_ clknet_leaf_20_clk _00121_ VGND VGND VPWR VPWR picorv32_core.cpuregs\[9\]\[18\]
+ sky130_fd_sc_hd__dfxtp_1
XFILLER_69_55 VGND VGND VPWR VPWR sky130_fd_sc_hd__fill_1
X_11182_ clknet_leaf_114_clk _01033_ VGND VGND VPWR VPWR picorv32_core.cpuregs\[6\]\[4\]
+ sky130_fd_sc_hd__dfxtp_1
X_10133_ clknet_leaf_23_clk _00055_ VGND VGND VPWR VPWR picorv32_core.cpuregs\[22\]\[16\]
+ sky130_fd_sc_hd__dfxtp_1
XPHY_EDGE_ROW_66_Left_208 VGND VGND VPWR VPWR sky130_fd_sc_hd__decap_3
XFILLER_0_664 VGND VGND VPWR VPWR sky130_fd_sc_hd__decap_4
X_10064_ net1668 net230 net307 VGND VGND VPWR VPWR _01539_ sky130_fd_sc_hd__mux2_1
XFILLER_88_793 VGND VGND VPWR VPWR sky130_fd_sc_hd__fill_1
XFILLER_75_421 VGND VGND VPWR VPWR sky130_fd_sc_hd__fill_1
XFILLER_47_134 VGND VGND VPWR VPWR sky130_fd_sc_hd__fill_1
XFILLER_47_156 VGND VGND VPWR VPWR sky130_fd_sc_hd__decap_3
XFILLER_71_671 VGND VGND VPWR VPWR sky130_fd_sc_hd__fill_1
X_10966_ clknet_leaf_8_clk _00817_ VGND VGND VPWR VPWR picorv32_core.cpuregs\[13\]\[12\]
+ sky130_fd_sc_hd__dfxtp_1
XPHY_EDGE_ROW_75_Left_217 VGND VGND VPWR VPWR sky130_fd_sc_hd__decap_3
X_10897_ clknet_leaf_105_clk _00748_ VGND VGND VPWR VPWR picorv32_core.mem_rdata_q\[7\]
+ sky130_fd_sc_hd__dfxtp_1
XFILLER_70_192 VGND VGND VPWR VPWR sky130_fd_sc_hd__decap_4
XFILLER_86_7 VGND VGND VPWR VPWR sky130_fd_sc_hd__fill_1
XFILLER_8_720 VPWR VGND VPWR VGND sky130_ef_sc_hd__decap_12
XFILLER_12_793 VPWR VGND VPWR VGND sky130_ef_sc_hd__decap_12
Xhold208 picorv32_core.cpuregs\[31\]\[17\] VGND VGND VPWR VPWR net1317 sky130_fd_sc_hd__dlygate4sd3_1
X_11518_ clknet_leaf_122_clk _00024_ VGND VGND VPWR VPWR _00004_ sky130_fd_sc_hd__dfxtp_2
Xhold219 picorv32_core.cpuregs\[3\]\[31\] VGND VGND VPWR VPWR net1328 sky130_fd_sc_hd__dlygate4sd3_1
X_11449_ clknet_leaf_133_clk _01285_ VGND VGND VPWR VPWR picorv32_core.cpuregs\[24\]\[0\]
+ sky130_fd_sc_hd__dfxtp_1
XFILLER_125_673 VGND VGND VPWR VPWR sky130_fd_sc_hd__decap_3
XTAP_TAPCELL_ROW_113_1949 VGND VPWR sky130_fd_sc_hd__tapvpwrvgnd_1
XTAP_TAPCELL_ROW_113_1938 VGND VPWR sky130_fd_sc_hd__tapvpwrvgnd_1
XFILLER_140_643 VGND VGND VPWR VPWR sky130_fd_sc_hd__fill_1
XFILLER_113_835 VGND VGND VPWR VPWR sky130_fd_sc_hd__fill_2
XPHY_EDGE_ROW_84_Left_226 VGND VGND VPWR VPWR sky130_fd_sc_hd__decap_3
XFILLER_98_568 VGND VGND VPWR VPWR sky130_fd_sc_hd__decap_8
X_06990_ _03200_ _03201_ VGND VGND VPWR VPWR _03202_ sky130_fd_sc_hd__or2_1
XFILLER_79_760 VGND VGND VPWR VPWR sky130_fd_sc_hd__fill_1
X_05941_ net791 net179 net569 VGND VGND VPWR VPWR _02410_ sky130_fd_sc_hd__and3_1
XFILLER_66_421 VGND VGND VPWR VPWR sky130_fd_sc_hd__decap_4
X_05872_ _02345_ _02346_ VGND VGND VPWR VPWR _02347_ sky130_fd_sc_hd__or2_1
X_08660_ net448 net2197 net386 VGND VGND VPWR VPWR _00810_ sky130_fd_sc_hd__mux2_1
XFILLER_81_413 VPWR VGND VPWR VGND sky130_ef_sc_hd__decap_12
X_07611_ _03700_ _03701_ _03706_ _03707_ net628 net623 VGND VGND VPWR VPWR _03711_
+ sky130_fd_sc_hd__mux4_1
XFILLER_26_307 VGND VGND VPWR VPWR sky130_fd_sc_hd__fill_1
XTAP_TAPCELL_ROW_37_836 VGND VPWR sky130_fd_sc_hd__tapvpwrvgnd_1
XTAP_TAPCELL_ROW_37_847 VGND VPWR sky130_fd_sc_hd__tapvpwrvgnd_1
X_08591_ net430 net1983 net394 VGND VGND VPWR VPWR _00714_ sky130_fd_sc_hd__mux2_1
XPHY_EDGE_ROW_93_Left_235 VGND VGND VPWR VPWR sky130_fd_sc_hd__decap_3
X_07542_ picorv32_core.mem_do_prefetch _01702_ _03390_ VGND VGND VPWR VPWR _03650_
+ sky130_fd_sc_hd__mux2_1
X_07473_ picorv32_core.reg_out\[11\] picorv32_core.reg_next_pc\[11\] net557 VGND VGND
+ VPWR VPWR _03603_ sky130_fd_sc_hd__mux2_1
XFILLER_34_395 VGND VGND VPWR VPWR sky130_fd_sc_hd__fill_1
X_06424_ _02752_ net2172 net424 VGND VGND VPWR VPWR _00092_ sky130_fd_sc_hd__mux2_1
X_09212_ net835 _04406_ net648 VGND VGND VPWR VPWR _04409_ sky130_fd_sc_hd__a21oi_1
X_09143_ net1208 net235 net330 VGND VGND VPWR VPWR _01309_ sky130_fd_sc_hd__mux2_1
X_06355_ picorv32_core.reg_out\[23\] picorv32_core.alu_out_q\[23\] net952 VGND VGND
+ VPWR VPWR _02758_ sky130_fd_sc_hd__mux2_1
X_05306_ picorv32_core.count_instr\[39\] net935 picorv32_core.count_cycle\[7\] net602
+ _01814_ VGND VGND VPWR VPWR _01815_ sky130_fd_sc_hd__a221o_1
X_09074_ net1818 net246 net338 VGND VGND VPWR VPWR _01242_ sky130_fd_sc_hd__mux2_1
X_06286_ _02699_ _02702_ net566 VGND VGND VPWR VPWR _02703_ sky130_fd_sc_hd__mux2_2
XFILLER_30_27 VGND VGND VPWR VPWR sky130_fd_sc_hd__fill_1
X_08025_ _04096_ _04097_ net637 VGND VGND VPWR VPWR _04102_ sky130_fd_sc_hd__mux2_1
Xhold720 picorv32_core.cpuregs\[18\]\[9\] VGND VGND VPWR VPWR net1829 sky130_fd_sc_hd__dlygate4sd3_1
X_05237_ net920 _01745_ _01747_ net914 net818 VGND VGND VPWR VPWR _01751_ sky130_fd_sc_hd__a32o_1
XFILLER_116_662 VGND VGND VPWR VPWR sky130_fd_sc_hd__decap_3
Xhold753 picorv32_core.cpuregs\[2\]\[24\] VGND VGND VPWR VPWR net1862 sky130_fd_sc_hd__dlygate4sd3_1
Xhold742 picorv32_core.cpuregs\[28\]\[13\] VGND VGND VPWR VPWR net1851 sky130_fd_sc_hd__dlygate4sd3_1
XFILLER_1_417 VPWR VGND VPWR VGND sky130_ef_sc_hd__decap_12
Xhold731 picorv32_core.cpuregs\[16\]\[3\] VGND VGND VPWR VPWR net1840 sky130_fd_sc_hd__dlygate4sd3_1
X_05168_ _01689_ _01692_ net913 VGND VGND VPWR VPWR _01693_ sky130_fd_sc_hd__o21ai_4
Xhold764 picorv32_core.cpuregs\[13\]\[10\] VGND VGND VPWR VPWR net1873 sky130_fd_sc_hd__dlygate4sd3_1
Xhold797 net51 VGND VGND VPWR VPWR net1906 sky130_fd_sc_hd__dlygate4sd3_1
Xhold786 picorv32_core.cpuregs\[22\]\[26\] VGND VGND VPWR VPWR net1895 sky130_fd_sc_hd__dlygate4sd3_1
XFILLER_103_334 VGND VGND VPWR VPWR sky130_fd_sc_hd__fill_2
Xhold775 picorv32_core.cpuregs\[11\]\[20\] VGND VGND VPWR VPWR net1884 sky130_fd_sc_hd__dlygate4sd3_1
XFILLER_103_367 VGND VGND VPWR VPWR sky130_fd_sc_hd__fill_1
XFILLER_103_356 VGND VGND VPWR VPWR sky130_fd_sc_hd__fill_1
X_09976_ net1217 net494 net313 VGND VGND VPWR VPWR _01453_ sky130_fd_sc_hd__mux2_1
X_05099_ net972 _01630_ picorv32_core.mem_do_prefetch VGND VGND VPWR VPWR _01631_
+ sky130_fd_sc_hd__o21a_1
X_08927_ net429 net2118 net354 VGND VGND VPWR VPWR _01100_ sky130_fd_sc_hd__mux2_1
XFILLER_97_590 VGND VGND VPWR VPWR sky130_fd_sc_hd__fill_1
XFILLER_69_281 VGND VGND VPWR VPWR sky130_fd_sc_hd__decap_4
X_08858_ net467 net2191 net365 VGND VGND VPWR VPWR _01033_ sky130_fd_sc_hd__mux2_1
X_07809_ _03887_ _03896_ _03897_ net620 net689 VGND VGND VPWR VPWR _03898_ sky130_fd_sc_hd__a221o_1
XFILLER_57_465 VGND VGND VPWR VPWR sky130_fd_sc_hd__fill_2
X_08789_ net495 net1940 net370 VGND VGND VPWR VPWR _00967_ sky130_fd_sc_hd__mux2_1
X_10820_ clknet_leaf_69_clk _00671_ VGND VGND VPWR VPWR picorv32_core.cpuregs\[15\]\[29\]
+ sky130_fd_sc_hd__dfxtp_1
X_10751_ clknet_leaf_93_clk _00602_ VGND VGND VPWR VPWR picorv32_core.decoded_imm\[8\]
+ sky130_fd_sc_hd__dfxtp_2
XTAP_TAPCELL_ROW_15_519 VGND VPWR sky130_fd_sc_hd__tapvpwrvgnd_1
XTAP_TAPCELL_ROW_117_2005 VGND VPWR sky130_fd_sc_hd__tapvpwrvgnd_1
X_10682_ clknet_leaf_97_clk _00535_ VGND VGND VPWR VPWR picorv32_core.is_jalr_addi_slti_sltiu_xori_ori_andi
+ sky130_fd_sc_hd__dfxtp_1
XFILLER_40_354 VGND VGND VPWR VPWR sky130_fd_sc_hd__decap_3
XFILLER_40_365 VPWR VGND VPWR VGND sky130_ef_sc_hd__decap_12
XFILLER_139_765 VPWR VGND VPWR VGND sky130_ef_sc_hd__decap_12
X_11303_ clknet_leaf_64_clk _01151_ VGND VGND VPWR VPWR picorv32_core.cpuregs\[3\]\[26\]
+ sky130_fd_sc_hd__dfxtp_1
XFILLER_126_437 VGND VGND VPWR VPWR sky130_fd_sc_hd__fill_1
XFILLER_4_233 VGND VGND VPWR VPWR sky130_fd_sc_hd__fill_2
X_11234_ clknet_leaf_35_clk _01085_ VGND VGND VPWR VPWR picorv32_core.cpuregs\[5\]\[24\]
+ sky130_fd_sc_hd__dfxtp_1
XFILLER_107_662 VGND VGND VPWR VPWR sky130_fd_sc_hd__fill_2
XFILLER_122_643 VGND VGND VPWR VPWR sky130_fd_sc_hd__fill_1
XFILLER_110_805 VGND VGND VPWR VPWR sky130_fd_sc_hd__decap_6
XFILLER_95_505 VPWR VGND VPWR VGND sky130_ef_sc_hd__decap_12
X_11165_ clknet_leaf_28_clk _01016_ VGND VGND VPWR VPWR picorv32_core.cpuregs\[7\]\[19\]
+ sky130_fd_sc_hd__dfxtp_1
X_11096_ clknet_leaf_7_clk _00947_ VGND VGND VPWR VPWR picorv32_core.cpuregs\[0\]\[14\]
+ sky130_fd_sc_hd__dfxtp_1
XFILLER_67_218 VGND VGND VPWR VPWR sky130_fd_sc_hd__decap_6
X_10116_ clknet_leaf_106_clk _00038_ VGND VGND VPWR VPWR net205 sky130_fd_sc_hd__dfxtp_4
XTAP_TAPCELL_ROW_128_2167 VGND VPWR sky130_fd_sc_hd__tapvpwrvgnd_1
XTAP_TAPCELL_ROW_128_2156 VGND VPWR sky130_fd_sc_hd__tapvpwrvgnd_1
X_10047_ net1462 _02698_ net305 VGND VGND VPWR VPWR _01522_ sky130_fd_sc_hd__mux2_1
Xhold91 picorv32_core.cpuregs\[31\]\[16\] VGND VGND VPWR VPWR net1200 sky130_fd_sc_hd__dlygate4sd3_1
XFILLER_76_796 VPWR VGND VPWR VGND sky130_ef_sc_hd__decap_12
Xhold80 net110 VGND VGND VPWR VPWR net1189 sky130_fd_sc_hd__dlygate4sd3_1
XTAP_TAPCELL_ROW_141_2345 VGND VPWR sky130_fd_sc_hd__tapvpwrvgnd_1
XFILLER_63_446 VGND VGND VPWR VPWR sky130_fd_sc_hd__fill_2
XTAP_TAPCELL_ROW_141_2367 VGND VPWR sky130_fd_sc_hd__tapvpwrvgnd_1
XTAP_TAPCELL_ROW_141_2356 VGND VPWR sky130_fd_sc_hd__tapvpwrvgnd_1
XFILLER_16_340 VGND VGND VPWR VPWR sky130_fd_sc_hd__decap_3
X_10949_ clknet_leaf_42_clk _00800_ VGND VGND VPWR VPWR picorv32_core.cpuregs\[19\]\[27\]
+ sky130_fd_sc_hd__dfxtp_1
XFILLER_32_811 VGND VGND VPWR VPWR sky130_fd_sc_hd__fill_1
XFILLER_44_682 VGND VGND VPWR VPWR sky130_fd_sc_hd__fill_1
Xclkbuf_leaf_70_clk clknet_4_15_0_clk VGND VGND VPWR VPWR clknet_leaf_70_clk sky130_fd_sc_hd__clkbuf_8
XFILLER_31_376 VGND VGND VPWR VPWR sky130_fd_sc_hd__fill_1
X_06140_ net971 net197 net570 VGND VGND VPWR VPWR _02593_ sky130_fd_sc_hd__and3_1
XFILLER_129_297 VGND VGND VPWR VPWR sky130_fd_sc_hd__fill_2
X_06071_ net771 _02528_ VGND VGND VPWR VPWR _02530_ sky130_fd_sc_hd__nor2_1
XTAP_TAPCELL_ROW_57_1129 VGND VPWR sky130_fd_sc_hd__tapvpwrvgnd_1
XFILLER_132_429 VGND VGND VPWR VPWR sky130_fd_sc_hd__fill_2
XFILLER_113_610 VGND VGND VPWR VPWR sky130_fd_sc_hd__decap_6
X_09830_ picorv32_core.cpuregs\[12\]\[29\] picorv32_core.cpuregs\[13\]\[29\] picorv32_core.cpuregs\[14\]\[29\]
+ picorv32_core.cpuregs\[15\]\[29\] net903 net871 VGND VGND VPWR VPWR _05000_ sky130_fd_sc_hd__mux4_1
XFILLER_86_505 VGND VGND VPWR VPWR sky130_fd_sc_hd__fill_1
Xfanout529 net530 VGND VGND VPWR VPWR net529 sky130_fd_sc_hd__dlymetal6s2s_1
Xfanout507 net509 VGND VGND VPWR VPWR net507 sky130_fd_sc_hd__buf_2
XTAP_TAPCELL_ROW_70_1318 VGND VPWR sky130_fd_sc_hd__tapvpwrvgnd_1
Xfanout518 _01626_ VGND VGND VPWR VPWR net518 sky130_fd_sc_hd__clkbuf_4
X_09761_ picorv32_core.cpuregs\[20\]\[26\] picorv32_core.cpuregs\[21\]\[26\] picorv32_core.cpuregs\[22\]\[26\]
+ picorv32_core.cpuregs\[23\]\[26\] net901 net867 VGND VGND VPWR VPWR _04934_ sky130_fd_sc_hd__mux4_1
X_06973_ _03184_ _03186_ VGND VGND VPWR VPWR _03187_ sky130_fd_sc_hd__nand2_1
X_08712_ net1742 net234 net384 VGND VGND VPWR VPWR _00861_ sky130_fd_sc_hd__mux2_1
X_05924_ _02393_ _02394_ VGND VGND VPWR VPWR _02395_ sky130_fd_sc_hd__or2_1
XFILLER_132_29 VPWR VGND VPWR VGND sky130_ef_sc_hd__decap_12
X_09692_ net784 net542 _04867_ net472 VGND VGND VPWR VPWR _04868_ sky130_fd_sc_hd__o211a_1
XFILLER_67_785 VGND VGND VPWR VPWR sky130_fd_sc_hd__decap_3
X_08643_ net1887 net245 net392 VGND VGND VPWR VPWR _00794_ sky130_fd_sc_hd__mux2_1
X_05855_ net963 picorv32_core.mem_la_wdata\[7\] _02285_ _02308_ VGND VGND VPWR VPWR
+ _02331_ sky130_fd_sc_hd__or4_4
X_08574_ net228 net1762 net401 VGND VGND VPWR VPWR _00699_ sky130_fd_sc_hd__mux2_1
XFILLER_25_27 VPWR VGND VPWR VGND sky130_ef_sc_hd__decap_12
X_05786_ net817 _02266_ VGND VGND VPWR VPWR _02268_ sky130_fd_sc_hd__or2_1
X_07525_ net767 _03637_ net534 VGND VGND VPWR VPWR _03638_ sky130_fd_sc_hd__mux2_1
Xclkbuf_leaf_61_clk clknet_4_13_0_clk VGND VGND VPWR VPWR clknet_leaf_61_clk sky130_fd_sc_hd__clkbuf_8
X_07456_ net168 _03591_ net532 VGND VGND VPWR VPWR _03592_ sky130_fd_sc_hd__mux2_1
X_07387_ _03410_ _03526_ VGND VGND VPWR VPWR _03527_ sky130_fd_sc_hd__nand2_1
X_06407_ net466 net2079 net423 VGND VGND VPWR VPWR _00075_ sky130_fd_sc_hd__mux2_1
XFILLER_41_15 VGND VGND VPWR VPWR sky130_fd_sc_hd__decap_4
XFILLER_136_713 VPWR VGND VPWR VGND sky130_ef_sc_hd__decap_12
X_06338_ net1285 net252 net435 VGND VGND VPWR VPWR _00058_ sky130_fd_sc_hd__mux2_1
X_09126_ net1671 net431 net328 VGND VGND VPWR VPWR _01292_ sky130_fd_sc_hd__mux2_1
XFILLER_136_757 VPWR VGND VPWR VGND sky130_ef_sc_hd__decap_12
XFILLER_108_459 VGND VGND VPWR VPWR sky130_fd_sc_hd__decap_6
XFILLER_108_437 VGND VGND VPWR VPWR sky130_fd_sc_hd__decap_6
XTAP_TAPCELL_ROW_20_588 VGND VPWR sky130_fd_sc_hd__tapvpwrvgnd_1
XTAP_TAPCELL_ROW_20_599 VGND VPWR sky130_fd_sc_hd__tapvpwrvgnd_1
X_09057_ net1264 net468 net337 VGND VGND VPWR VPWR _01225_ sky130_fd_sc_hd__mux2_1
X_06269_ picorv32_core.reg_pc\[6\] _02685_ VGND VGND VPWR VPWR _02689_ sky130_fd_sc_hd__xor2_1
X_08008_ _04083_ _04084_ net636 VGND VGND VPWR VPWR _04086_ sky130_fd_sc_hd__mux2_1
XFILLER_135_267 VGND VGND VPWR VPWR sky130_fd_sc_hd__decap_4
XTAP_TAPCELL_ROW_96_1690 VGND VPWR sky130_fd_sc_hd__tapvpwrvgnd_1
Xhold561 picorv32_core.cpuregs\[15\]\[26\] VGND VGND VPWR VPWR net1670 sky130_fd_sc_hd__dlygate4sd3_1
Xhold572 picorv32_core.cpuregs\[25\]\[22\] VGND VGND VPWR VPWR net1681 sky130_fd_sc_hd__dlygate4sd3_1
Xhold550 picorv32_core.cpuregs\[29\]\[20\] VGND VGND VPWR VPWR net1659 sky130_fd_sc_hd__dlygate4sd3_1
XFILLER_104_610 VGND VGND VPWR VPWR sky130_fd_sc_hd__decap_3
XFILLER_9_6 VPWR VGND VPWR VGND sky130_ef_sc_hd__decap_12
XFILLER_2_737 VPWR VGND VPWR VGND sky130_ef_sc_hd__decap_12
XFILLER_1_225 VPWR VGND VPWR VGND sky130_ef_sc_hd__decap_12
Xhold583 picorv32_core.cpuregs\[1\]\[26\] VGND VGND VPWR VPWR net1692 sky130_fd_sc_hd__dlygate4sd3_1
XFILLER_77_505 VGND VGND VPWR VPWR sky130_fd_sc_hd__fill_1
Xhold594 picorv32_core.cpuregs\[17\]\[3\] VGND VGND VPWR VPWR net1703 sky130_fd_sc_hd__dlygate4sd3_1
X_09959_ net1281 net252 net318 VGND VGND VPWR VPWR _01437_ sky130_fd_sc_hd__mux2_1
XFILLER_77_527 VGND VGND VPWR VPWR sky130_fd_sc_hd__decap_8
XFILLER_131_495 VGND VGND VPWR VPWR sky130_fd_sc_hd__fill_1
Xhold1250 picorv32_core.decoded_imm\[13\] VGND VGND VPWR VPWR net2359 sky130_fd_sc_hd__dlygate4sd3_1
XFILLER_18_616 VGND VGND VPWR VPWR sky130_fd_sc_hd__decap_3
XFILLER_45_413 VGND VGND VPWR VPWR sky130_fd_sc_hd__fill_1
X_11852_ net55 VGND VGND VPWR VPWR net87 sky130_fd_sc_hd__clkbuf_1
XFILLER_45_479 VGND VGND VPWR VPWR sky130_fd_sc_hd__fill_2
XTAP_TAPCELL_ROW_123_2086 VGND VPWR sky130_fd_sc_hd__tapvpwrvgnd_1
X_10803_ clknet_leaf_7_clk _00654_ VGND VGND VPWR VPWR picorv32_core.cpuregs\[15\]\[12\]
+ sky130_fd_sc_hd__dfxtp_1
XFILLER_14_811 VGND VGND VPWR VPWR sky130_fd_sc_hd__fill_1
XFILLER_32_118 VGND VGND VPWR VPWR sky130_fd_sc_hd__fill_1
Xclkbuf_leaf_52_clk clknet_4_6_0_clk VGND VGND VPWR VPWR clknet_leaf_52_clk sky130_fd_sc_hd__clkbuf_8
XTAP_TAPCELL_ROW_0_291 VGND VPWR sky130_fd_sc_hd__tapvpwrvgnd_1
X_10734_ clknet_leaf_89_clk _00585_ VGND VGND VPWR VPWR picorv32_core.decoded_imm\[25\]
+ sky130_fd_sc_hd__dfxtp_1
X_10665_ clknet_leaf_106_clk _00519_ VGND VGND VPWR VPWR picorv32_core.decoded_rd\[1\]
+ sky130_fd_sc_hd__dfxtp_1
XFILLER_127_757 VPWR VGND VPWR VGND sky130_ef_sc_hd__decap_12
X_10596_ clknet_leaf_96_clk _00450_ VGND VGND VPWR VPWR picorv32_core.instr_sw sky130_fd_sc_hd__dfxtp_1
XFILLER_107_492 VGND VGND VPWR VPWR sky130_fd_sc_hd__fill_1
Xoutput70 net70 VGND VGND VPWR VPWR mem_axi_arvalid sky130_fd_sc_hd__buf_2
X_11217_ clknet_leaf_140_clk _01068_ VGND VGND VPWR VPWR picorv32_core.cpuregs\[5\]\[7\]
+ sky130_fd_sc_hd__dfxtp_1
Xoutput92 net92 VGND VGND VPWR VPWR mem_axi_awaddr[30] sky130_fd_sc_hd__buf_2
Xoutput81 net81 VGND VGND VPWR VPWR mem_axi_awaddr[20] sky130_fd_sc_hd__buf_2
X_11148_ clknet_leaf_135_clk _00999_ VGND VGND VPWR VPWR picorv32_core.cpuregs\[7\]\[2\]
+ sky130_fd_sc_hd__dfxtp_1
XTAP_TAPCELL_ROW_52_1059 VGND VPWR sky130_fd_sc_hd__tapvpwrvgnd_1
XFILLER_49_752 VGND VGND VPWR VPWR sky130_fd_sc_hd__decap_8
X_11079_ clknet_leaf_68_clk _00930_ VGND VGND VPWR VPWR picorv32_core.cpuregs\[10\]\[29\]
+ sky130_fd_sc_hd__dfxtp_1
XFILLER_49_785 VGND VGND VPWR VPWR sky130_fd_sc_hd__decap_3
XFILLER_64_755 VGND VGND VPWR VPWR sky130_fd_sc_hd__fill_1
X_05640_ net809 net963 VGND VGND VPWR VPWR _02124_ sky130_fd_sc_hd__nand2_1
X_05571_ picorv32_core.count_cycle\[26\] net600 VGND VGND VPWR VPWR _02061_ sky130_fd_sc_hd__or2_1
XFILLER_17_682 VGND VGND VPWR VPWR sky130_fd_sc_hd__fill_2
XTAP_TAPCELL_ROW_47_986 VGND VPWR sky130_fd_sc_hd__tapvpwrvgnd_1
Xclkbuf_leaf_43_clk clknet_4_7_0_clk VGND VGND VPWR VPWR clknet_leaf_43_clk sky130_fd_sc_hd__clkbuf_8
XTAP_TAPCELL_ROW_67_1280 VGND VPWR sky130_fd_sc_hd__tapvpwrvgnd_1
XFILLER_51_449 VGND VGND VPWR VPWR sky130_fd_sc_hd__decap_8
X_07310_ net809 picorv32_core.decoded_imm\[6\] VGND VGND VPWR VPWR _03450_ sky130_fd_sc_hd__nand2_1
X_08290_ net1525 net218 net412 VGND VGND VPWR VPWR _00514_ sky130_fd_sc_hd__mux2_1
X_07241_ picorv32_core.count_cycle\[61\] _03380_ net2319 VGND VGND VPWR VPWR _03383_
+ sky130_fd_sc_hd__a21oi_1
XFILLER_20_836 VGND VGND VPWR VPWR sky130_fd_sc_hd__fill_1
X_07172_ net2270 _03338_ net985 VGND VGND VPWR VPWR _03340_ sky130_fd_sc_hd__o21ai_1
XFILLER_118_757 VPWR VGND VPWR VGND sky130_ef_sc_hd__decap_12
XFILLER_118_735 VPWR VGND VPWR VGND sky130_ef_sc_hd__decap_12
XFILLER_117_223 VGND VGND VPWR VPWR sky130_fd_sc_hd__fill_1
X_06123_ _01601_ _02577_ VGND VGND VPWR VPWR _02578_ sky130_fd_sc_hd__nor2_1
XFILLER_11_18 VPWR VGND VPWR VGND sky130_ef_sc_hd__decap_12
XFILLER_133_716 VPWR VGND VPWR VGND sky130_ef_sc_hd__decap_12
X_06054_ net775 net188 net570 VGND VGND VPWR VPWR _02515_ sky130_fd_sc_hd__and3_1
Xfanout304 net305 VGND VGND VPWR VPWR net304 sky130_fd_sc_hd__buf_4
X_09813_ _04977_ _04978_ _04979_ _04980_ net658 net828 VGND VGND VPWR VPWR _04984_
+ sky130_fd_sc_hd__mux4_1
Xfanout315 _05040_ VGND VGND VPWR VPWR net315 sky130_fd_sc_hd__buf_4
XFILLER_113_473 VGND VGND VPWR VPWR sky130_fd_sc_hd__fill_2
XFILLER_100_101 VGND VGND VPWR VPWR sky130_fd_sc_hd__fill_2
Xfanout326 net327 VGND VGND VPWR VPWR net326 sky130_fd_sc_hd__buf_4
XFILLER_59_505 VGND VGND VPWR VPWR sky130_fd_sc_hd__fill_1
Xfanout337 _04349_ VGND VGND VPWR VPWR net337 sky130_fd_sc_hd__buf_4
Xfanout348 net353 VGND VGND VPWR VPWR net348 sky130_fd_sc_hd__clkbuf_8
XFILLER_100_112 VGND VGND VPWR VPWR sky130_fd_sc_hd__decap_4
Xfanout359 _04343_ VGND VGND VPWR VPWR net359 sky130_fd_sc_hd__buf_2
X_09744_ picorv32_core.cpuregs\[8\]\[25\] picorv32_core.cpuregs\[9\]\[25\] picorv32_core.cpuregs\[10\]\[25\]
+ picorv32_core.cpuregs\[11\]\[25\] net906 net871 VGND VGND VPWR VPWR _04918_ sky130_fd_sc_hd__mux4_1
X_06956_ _03165_ _03170_ VGND VGND VPWR VPWR _03171_ sky130_fd_sc_hd__nand2_1
XFILLER_74_519 VGND VGND VPWR VPWR sky130_fd_sc_hd__decap_3
X_09675_ picorv32_core.cpuregs\[28\]\[22\] picorv32_core.cpuregs\[29\]\[22\] picorv32_core.cpuregs\[30\]\[22\]
+ picorv32_core.cpuregs\[31\]\[22\] net891 net857 VGND VGND VPWR VPWR _04852_ sky130_fd_sc_hd__mux4_1
XFILLER_82_530 VGND VGND VPWR VPWR sky130_fd_sc_hd__fill_2
X_06887_ picorv32_core.decoded_imm_j\[16\] _02928_ VGND VGND VPWR VPWR _03107_ sky130_fd_sc_hd__nor2_1
X_05907_ _02377_ _02378_ VGND VGND VPWR VPWR _02379_ sky130_fd_sc_hd__nand2_1
XTAP_TAPCELL_ROW_83_1509 VGND VPWR sky130_fd_sc_hd__tapvpwrvgnd_1
XFILLER_55_777 VGND VGND VPWR VPWR sky130_fd_sc_hd__fill_1
X_08626_ net1479 net465 net391 VGND VGND VPWR VPWR _00777_ sky130_fd_sc_hd__mux2_1
X_05838_ _02284_ _02289_ _02298_ _02315_ VGND VGND VPWR VPWR _02316_ sky130_fd_sc_hd__a31o_1
XFILLER_70_736 VGND VGND VPWR VPWR sky130_fd_sc_hd__decap_4
XFILLER_70_725 VGND VGND VPWR VPWR sky130_fd_sc_hd__decap_3
Xclkbuf_leaf_34_clk clknet_4_5_0_clk VGND VGND VPWR VPWR clknet_leaf_34_clk sky130_fd_sc_hd__clkbuf_8
X_05769_ picorv32_core.is_compare net607 net572 net568 VGND VGND VPWR VPWR _02253_
+ sky130_fd_sc_hd__nor4_1
XFILLER_23_641 VGND VGND VPWR VPWR sky130_fd_sc_hd__fill_1
X_08557_ net428 net1473 net399 VGND VGND VPWR VPWR _00682_ sky130_fd_sc_hd__mux2_1
X_07508_ net1906 _03626_ net463 VGND VGND VPWR VPWR _00346_ sky130_fd_sc_hd__mux2_1
XTAP_TAPCELL_ROW_25_669 VGND VPWR sky130_fd_sc_hd__tapvpwrvgnd_1
X_08488_ net1511 net426 net406 VGND VGND VPWR VPWR _00618_ sky130_fd_sc_hd__mux2_1
X_07439_ net971 _03396_ _03544_ _03578_ VGND VGND VPWR VPWR _00325_ sky130_fd_sc_hd__a22o_1
XTAP_TAPCELL_ROW_98_1730 VGND VPWR sky130_fd_sc_hd__tapvpwrvgnd_1
X_10450_ clknet_leaf_100_clk _00337_ VGND VGND VPWR VPWR net42 sky130_fd_sc_hd__dfxtp_1
X_09109_ net238 net1929 net334 VGND VGND VPWR VPWR _01276_ sky130_fd_sc_hd__mux2_1
X_10381_ clknet_leaf_101_clk _00300_ VGND VGND VPWR VPWR picorv32_core.count_cycle\[39\]
+ sky130_fd_sc_hd__dfxtp_1
XFILLER_124_738 VPWR VGND VPWR VGND sky130_ef_sc_hd__decap_12
Xhold380 picorv32_core.cpuregs\[14\]\[1\] VGND VGND VPWR VPWR net1489 sky130_fd_sc_hd__dlygate4sd3_1
XFILLER_132_793 VPWR VGND VPWR VGND sky130_ef_sc_hd__decap_12
XFILLER_77_302 VGND VGND VPWR VPWR sky130_fd_sc_hd__decap_4
X_11002_ clknet_leaf_23_clk _00853_ VGND VGND VPWR VPWR picorv32_core.cpuregs\[12\]\[16\]
+ sky130_fd_sc_hd__dfxtp_1
Xhold391 picorv32_core.cpuregs\[15\]\[3\] VGND VGND VPWR VPWR net1500 sky130_fd_sc_hd__dlygate4sd3_1
XFILLER_2_589 VGND VGND VPWR VPWR sky130_fd_sc_hd__decap_6
Xfanout860 net862 VGND VGND VPWR VPWR net860 sky130_fd_sc_hd__clkbuf_4
XTAP_TAPCELL_ROW_125_2115 VGND VPWR sky130_fd_sc_hd__tapvpwrvgnd_1
Xfanout871 net872 VGND VGND VPWR VPWR net871 sky130_fd_sc_hd__clkbuf_4
Xfanout893 net900 VGND VGND VPWR VPWR net893 sky130_fd_sc_hd__buf_4
Xfanout882 net883 VGND VGND VPWR VPWR net882 sky130_fd_sc_hd__clkbuf_4
XTAP_TAPCELL_ROW_5_372 VGND VPWR sky130_fd_sc_hd__tapvpwrvgnd_1
XFILLER_58_593 VGND VGND VPWR VPWR sky130_fd_sc_hd__fill_1
XTAP_TAPCELL_ROW_5_383 VGND VPWR sky130_fd_sc_hd__tapvpwrvgnd_1
XFILLER_46_733 VGND VGND VPWR VPWR sky130_fd_sc_hd__fill_1
Xhold1080 picorv32_core.cpuregs\[10\]\[26\] VGND VGND VPWR VPWR net2189 sky130_fd_sc_hd__dlygate4sd3_1
XFILLER_73_541 VGND VGND VPWR VPWR sky130_fd_sc_hd__fill_2
Xhold1091 picorv32_core.cpuregs\[21\]\[1\] VGND VGND VPWR VPWR net2200 sky130_fd_sc_hd__dlygate4sd3_1
Xclkbuf_leaf_25_clk clknet_4_4_0_clk VGND VGND VPWR VPWR clknet_leaf_25_clk sky130_fd_sc_hd__clkbuf_8
X_11835_ net68 VGND VGND VPWR VPWR net100 sky130_fd_sc_hd__clkbuf_1
XFILLER_26_490 VGND VGND VPWR VPWR sky130_fd_sc_hd__fill_1
XTAP_TAPCELL_ROW_44_945 VGND VPWR sky130_fd_sc_hd__tapvpwrvgnd_1
X_10717_ clknet_leaf_26_clk _00568_ VGND VGND VPWR VPWR net123 sky130_fd_sc_hd__dfxtp_1
X_11697_ clknet_leaf_23_clk _01528_ VGND VGND VPWR VPWR picorv32_core.cpuregs\[27\]\[14\]
+ sky130_fd_sc_hd__dfxtp_1
XFILLER_9_166 VGND VGND VPWR VPWR sky130_fd_sc_hd__fill_2
XTAP_TAPCELL_ROW_136_2277 VGND VPWR sky130_fd_sc_hd__tapvpwrvgnd_1
X_10648_ clknet_leaf_19_clk _00502_ VGND VGND VPWR VPWR picorv32_core.cpuregs\[20\]\[16\]
+ sky130_fd_sc_hd__dfxtp_1
XFILLER_9_177 VGND VGND VPWR VPWR sky130_fd_sc_hd__fill_1
XFILLER_127_565 VGND VGND VPWR VPWR sky130_fd_sc_hd__fill_1
X_10579_ clknet_leaf_92_clk _00433_ VGND VGND VPWR VPWR picorv32_core.instr_bne sky130_fd_sc_hd__dfxtp_1
XFILLER_96_600 VGND VGND VPWR VPWR sky130_fd_sc_hd__fill_2
X_07790_ _03874_ _03875_ net630 VGND VGND VPWR VPWR _03880_ sky130_fd_sc_hd__mux2_1
X_06810_ picorv32_core.decoded_imm_j\[10\] _02922_ VGND VGND VPWR VPWR _03036_ sky130_fd_sc_hd__nand2_1
X_06741_ net665 net970 VGND VGND VPWR VPWR _02973_ sky130_fd_sc_hd__nor2_1
X_09460_ _04638_ _04639_ _04642_ _04643_ net654 net643 VGND VGND VPWR VPWR _04647_
+ sky130_fd_sc_hd__mux4_1
XFILLER_37_744 VGND VGND VPWR VPWR sky130_fd_sc_hd__fill_2
X_08411_ picorv32_core.mem_rdata_q\[31\] net615 VGND VGND VPWR VPWR _04286_ sky130_fd_sc_hd__and2_1
X_06672_ picorv32_core.reg_pc\[13\] net552 _02925_ net515 VGND VGND VPWR VPWR _00211_
+ sky130_fd_sc_hd__a22o_1
XFILLER_64_596 VGND VGND VPWR VPWR sky130_fd_sc_hd__fill_2
X_05623_ picorv32_core.count_instr\[62\] net937 net941 picorv32_core.count_instr\[30\]
+ VGND VGND VPWR VPWR _02109_ sky130_fd_sc_hd__a22o_1
Xclkbuf_leaf_16_clk clknet_4_3_0_clk VGND VGND VPWR VPWR clknet_leaf_16_clk sky130_fd_sc_hd__clkbuf_8
XFILLER_24_449 VGND VGND VPWR VPWR sky130_fd_sc_hd__decap_3
X_09391_ picorv32_core.cpuregs\[12\]\[9\] picorv32_core.cpuregs\[13\]\[9\] picorv32_core.cpuregs\[14\]\[9\]
+ picorv32_core.cpuregs\[15\]\[9\] net874 net841 VGND VGND VPWR VPWR _04581_ sky130_fd_sc_hd__mux4_1
X_05554_ _02032_ _02035_ _02044_ VGND VGND VPWR VPWR _02045_ sky130_fd_sc_hd__nand3_1
X_08342_ _01595_ net175 net451 _04243_ VGND VGND VPWR VPWR _04244_ sky130_fd_sc_hd__a211o_1
XTAP_TAPCELL_ROW_22_617 VGND VPWR sky130_fd_sc_hd__tapvpwrvgnd_1
X_05485_ _01957_ _01969_ VGND VGND VPWR VPWR _01981_ sky130_fd_sc_hd__and2_1
XTAP_TAPCELL_ROW_22_628 VGND VPWR sky130_fd_sc_hd__tapvpwrvgnd_1
X_08273_ net1846 net291 net410 VGND VGND VPWR VPWR _00497_ sky130_fd_sc_hd__mux2_1
X_07224_ net2363 _03370_ _03372_ VGND VGND VPWR VPWR _00316_ sky130_fd_sc_hd__o21a_1
XFILLER_20_688 VGND VGND VPWR VPWR sky130_fd_sc_hd__fill_1
X_07155_ picorv32_core.count_cycle\[28\] picorv32_core.count_cycle\[29\] picorv32_core.count_cycle\[30\]
+ _03324_ VGND VGND VPWR VPWR _03329_ sky130_fd_sc_hd__and4_2
X_06106_ _02153_ _02561_ VGND VGND VPWR VPWR _02562_ sky130_fd_sc_hd__and2_1
X_07086_ picorv32_core.count_cycle\[4\] _03284_ net972 VGND VGND VPWR VPWR _03286_
+ sky130_fd_sc_hd__a21oi_1
XTAP_TAPCELL_ROW_93_1660 VGND VPWR sky130_fd_sc_hd__tapvpwrvgnd_1
X_06037_ _02497_ _02498_ VGND VGND VPWR VPWR _02499_ sky130_fd_sc_hd__nand2_1
XFILLER_114_793 VPWR VGND VPWR VGND sky130_ef_sc_hd__decap_12
XFILLER_113_281 VGND VGND VPWR VPWR sky130_fd_sc_hd__decap_6
X_07988_ picorv32_core.cpuregs\[8\]\[26\] picorv32_core.cpuregs\[9\]\[26\] picorv32_core.cpuregs\[10\]\[26\]
+ picorv32_core.cpuregs\[11\]\[26\] net759 net726 VGND VGND VPWR VPWR _04067_ sky130_fd_sc_hd__mux4_1
X_09727_ net832 _04901_ VGND VGND VPWR VPWR _04902_ sky130_fd_sc_hd__or2_1
XPHY_EDGE_ROW_114_Right_114 VGND VGND VPWR VPWR sky130_fd_sc_hd__decap_3
X_06939_ _03141_ _03146_ _03154_ VGND VGND VPWR VPWR _03155_ sky130_fd_sc_hd__o21ai_1
XFILLER_87_699 VGND VGND VPWR VPWR sky130_fd_sc_hd__fill_1
XTAP_TAPCELL_ROW_2_331 VGND VPWR sky130_fd_sc_hd__tapvpwrvgnd_1
X_09658_ picorv32_core.cpuregs\[8\]\[21\] picorv32_core.cpuregs\[9\]\[21\] picorv32_core.cpuregs\[10\]\[21\]
+ picorv32_core.cpuregs\[11\]\[21\] net892 net858 VGND VGND VPWR VPWR _04836_ sky130_fd_sc_hd__mux4_1
XFILLER_15_427 VGND VGND VPWR VPWR sky130_fd_sc_hd__fill_1
X_08609_ net229 net1931 net397 VGND VGND VPWR VPWR _00732_ sky130_fd_sc_hd__mux2_1
XTAP_TAPCELL_ROW_120_2045 VGND VPWR sky130_fd_sc_hd__tapvpwrvgnd_1
X_09589_ picorv32_core.cpuregs\[4\]\[18\] picorv32_core.cpuregs\[5\]\[18\] picorv32_core.cpuregs\[6\]\[18\]
+ picorv32_core.cpuregs\[7\]\[18\] net892 net858 VGND VGND VPWR VPWR _04770_ sky130_fd_sc_hd__mux4_1
XFILLER_70_533 VGND VGND VPWR VPWR sky130_fd_sc_hd__fill_2
XFILLER_15_449 VGND VGND VPWR VPWR sky130_fd_sc_hd__fill_2
X_11620_ clknet_leaf_111_clk _01451_ VGND VGND VPWR VPWR picorv32_core.cpuregs\[28\]\[1\]
+ sky130_fd_sc_hd__dfxtp_1
XFILLER_30_419 VGND VGND VPWR VPWR sky130_fd_sc_hd__fill_1
XTAP_TAPCELL_ROW_41_904 VGND VPWR sky130_fd_sc_hd__tapvpwrvgnd_1
X_11551_ clknet_leaf_107_clk _01382_ VGND VGND VPWR VPWR picorv32_core.mem_state\[0\]
+ sky130_fd_sc_hd__dfxtp_1
XFILLER_128_318 VGND VGND VPWR VPWR sky130_fd_sc_hd__decap_4
X_10502_ clknet_leaf_47_clk _00388_ VGND VGND VPWR VPWR net193 sky130_fd_sc_hd__dfxtp_4
X_11482_ clknet_leaf_96_clk _01318_ VGND VGND VPWR VPWR picorv32_core.instr_sh sky130_fd_sc_hd__dfxtp_1
XFILLER_10_176 VGND VGND VPWR VPWR sky130_fd_sc_hd__decap_3
XFILLER_109_543 VGND VGND VPWR VPWR sky130_fd_sc_hd__fill_1
X_10433_ clknet_leaf_59_clk _01565_ VGND VGND VPWR VPWR picorv32_core.reg_out\[26\]
+ sky130_fd_sc_hd__dfxtp_1
X_10364_ clknet_leaf_85_clk _00283_ VGND VGND VPWR VPWR picorv32_core.count_cycle\[22\]
+ sky130_fd_sc_hd__dfxtp_1
XFILLER_12_83 VGND VGND VPWR VPWR sky130_fd_sc_hd__fill_1
XFILLER_3_821 VPWR VGND VPWR VGND sky130_ef_sc_hd__decap_12
XFILLER_128_83 VGND VGND VPWR VPWR sky130_fd_sc_hd__fill_1
X_10295_ clknet_leaf_88_clk _00214_ VGND VGND VPWR VPWR picorv32_core.reg_pc\[16\]
+ sky130_fd_sc_hd__dfxtp_2
Xfanout690 net691 VGND VGND VPWR VPWR net690 sky130_fd_sc_hd__buf_2
XTAP_TAPCELL_ROW_105_1829 VGND VPWR sky130_fd_sc_hd__tapvpwrvgnd_1
XFILLER_19_777 VGND VGND VPWR VPWR sky130_fd_sc_hd__decap_6
XTAP_TAPCELL_ROW_138_2306 VGND VPWR sky130_fd_sc_hd__tapvpwrvgnd_1
XFILLER_61_555 VGND VGND VPWR VPWR sky130_fd_sc_hd__decap_4
XFILLER_119_318 VGND VGND VPWR VPWR sky130_fd_sc_hd__decap_4
XFILLER_14_493 VGND VGND VPWR VPWR sky130_fd_sc_hd__fill_1
XTAP_TAPCELL_ROW_60_1169 VGND VPWR sky130_fd_sc_hd__tapvpwrvgnd_1
X_05270_ _01777_ _01780_ VGND VGND VPWR VPWR _01781_ sky130_fd_sc_hd__nand2_1
XFILLER_115_557 VGND VGND VPWR VPWR sky130_fd_sc_hd__decap_3
XTAP_TAPCELL_ROW_75_1390 VGND VPWR sky130_fd_sc_hd__tapvpwrvgnd_1
Xclkbuf_leaf_5_clk clknet_4_1_0_clk VGND VGND VPWR VPWR clknet_leaf_5_clk sky130_fd_sc_hd__clkbuf_8
X_08960_ net1613 net429 net348 VGND VGND VPWR VPWR _01132_ sky130_fd_sc_hd__mux2_1
XFILLER_111_741 VPWR VGND VPWR VGND sky130_ef_sc_hd__decap_12
X_07911_ picorv32_core.cpuregs\[24\]\[22\] picorv32_core.cpuregs\[25\]\[22\] picorv32_core.cpuregs\[26\]\[22\]
+ picorv32_core.cpuregs\[27\]\[22\] net753 net720 VGND VGND VPWR VPWR _03994_ sky130_fd_sc_hd__mux4_1
XFILLER_69_622 VGND VGND VPWR VPWR sky130_fd_sc_hd__fill_1
X_08891_ net467 net1623 net359 VGND VGND VPWR VPWR _01065_ sky130_fd_sc_hd__mux2_1
X_07842_ picorv32_core.cpuregs\[12\]\[18\] picorv32_core.cpuregs\[13\]\[18\] picorv32_core.cpuregs\[14\]\[18\]
+ picorv32_core.cpuregs\[15\]\[18\] net751 net718 VGND VGND VPWR VPWR _03929_ sky130_fd_sc_hd__mux4_1
XFILLER_111_785 VPWR VGND VPWR VGND sky130_ef_sc_hd__decap_12
XFILLER_96_496 VGND VGND VPWR VPWR sky130_fd_sc_hd__fill_2
XFILLER_84_669 VGND VGND VPWR VPWR sky130_fd_sc_hd__decap_4
XFILLER_83_146 VGND VGND VPWR VPWR sky130_fd_sc_hd__decap_3
X_09512_ net800 net546 _04695_ net473 VGND VGND VPWR VPWR _04696_ sky130_fd_sc_hd__o211a_1
X_07773_ net692 _03856_ net682 VGND VGND VPWR VPWR _03864_ sky130_fd_sc_hd__o21a_1
XFILLER_140_29 VPWR VGND VPWR VGND sky130_ef_sc_hd__decap_12
X_06724_ picorv32_core.decoded_imm_j\[1\] _02911_ _02949_ _02948_ VGND VGND VPWR VPWR
+ _02957_ sky130_fd_sc_hd__a31o_1
X_09443_ picorv32_core.reg_pc\[11\] net539 _04630_ net482 VGND VGND VPWR VPWR _04631_
+ sky130_fd_sc_hd__a211o_1
XFILLER_24_235 VGND VGND VPWR VPWR sky130_fd_sc_hd__fill_1
X_06655_ _02683_ picorv32_core.reg_next_pc\[5\] net555 VGND VGND VPWR VPWR _02917_
+ sky130_fd_sc_hd__mux2_2
X_05606_ _02081_ _02084_ VGND VGND VPWR VPWR _02093_ sky130_fd_sc_hd__nand2_1
X_09374_ picorv32_core.reg_pc\[8\] net536 _04564_ net482 VGND VGND VPWR VPWR _04565_
+ sky130_fd_sc_hd__a211o_1
XFILLER_24_257 VGND VGND VPWR VPWR sky130_fd_sc_hd__fill_1
X_06586_ picorv32_core.count_instr\[43\] picorv32_core.count_instr\[42\] _02869_ VGND
+ VGND VPWR VPWR _02873_ sky130_fd_sc_hd__and3_1
X_08325_ net968 net1172 net453 VGND VGND VPWR VPWR _00542_ sky130_fd_sc_hd__mux2_1
XFILLER_33_27 VGND VGND VPWR VPWR sky130_fd_sc_hd__decap_4
X_05537_ _02006_ _02017_ _02028_ _02008_ _02018_ VGND VGND VPWR VPWR _02029_ sky130_fd_sc_hd__o221a_1
X_05468_ net923 _01959_ _01965_ VGND VGND VPWR VPWR _01556_ sky130_fd_sc_hd__a21o_1
X_08256_ net2332 _00754_ net439 VGND VGND VPWR VPWR _00482_ sky130_fd_sc_hd__mux2_1
XPHY_EDGE_ROW_104_Left_246 VGND VGND VPWR VPWR sky130_fd_sc_hd__decap_3
X_07207_ picorv32_core.count_cycle\[49\] _03359_ VGND VGND VPWR VPWR _03362_ sky130_fd_sc_hd__and2_1
X_08187_ net981 picorv32_core.is_alu_reg_imm net527 VGND VGND VPWR VPWR _04199_ sky130_fd_sc_hd__and3_2
XFILLER_134_833 VGND VGND VPWR VPWR sky130_fd_sc_hd__fill_1
XFILLER_134_811 VGND VGND VPWR VPWR sky130_fd_sc_hd__fill_1
X_07138_ _03318_ net994 _03317_ VGND VGND VPWR VPWR _00284_ sky130_fd_sc_hd__and3b_1
X_05399_ net923 _01893_ _01894_ _01901_ VGND VGND VPWR VPWR _01551_ sky130_fd_sc_hd__a31o_1
XTAP_TAPCELL_ROW_91_1619 VGND VPWR sky130_fd_sc_hd__tapvpwrvgnd_1
X_07069_ _02941_ _02942_ net933 VGND VGND VPWR VPWR _03274_ sky130_fd_sc_hd__o21a_1
XFILLER_79_408 VGND VGND VPWR VPWR sky130_fd_sc_hd__decap_8
XTAP_TAPCELL_ROW_7_412 VGND VPWR sky130_fd_sc_hd__tapvpwrvgnd_1
XTAP_TAPCELL_ROW_7_401 VGND VPWR sky130_fd_sc_hd__tapvpwrvgnd_1
XFILLER_0_813 VPWR VGND VPWR VGND sky130_ef_sc_hd__decap_12
XFILLER_59_110 VGND VGND VPWR VPWR sky130_fd_sc_hd__fill_2
X_10080_ picorv32_core.decoded_imm_j\[1\] _00762_ net437 VGND VGND VPWR VPWR _00528_
+ sky130_fd_sc_hd__mux2_1
XFILLER_48_806 VGND VGND VPWR VPWR sky130_fd_sc_hd__decap_6
XPHY_EDGE_ROW_113_Left_255 VGND VGND VPWR VPWR sky130_fd_sc_hd__decap_3
XFILLER_101_262 VGND VGND VPWR VPWR sky130_fd_sc_hd__decap_4
XFILLER_114_85 VGND VGND VPWR VPWR sky130_fd_sc_hd__fill_2
XFILLER_74_23 VGND VGND VPWR VPWR sky130_fd_sc_hd__decap_4
X_10982_ clknet_leaf_36_clk _00833_ VGND VGND VPWR VPWR picorv32_core.cpuregs\[13\]\[28\]
+ sky130_fd_sc_hd__dfxtp_1
XFILLER_43_500 VGND VGND VPWR VPWR sky130_fd_sc_hd__decap_4
XFILLER_70_363 VGND VGND VPWR VPWR sky130_fd_sc_hd__fill_1
XFILLER_16_769 VPWR VGND VPWR VGND sky130_ef_sc_hd__decap_12
X_11603_ clknet_leaf_22_clk _01434_ VGND VGND VPWR VPWR picorv32_core.cpuregs\[23\]\[16\]
+ sky130_fd_sc_hd__dfxtp_1
XTAP_TAPCELL_ROW_100_1759 VGND VPWR sky130_fd_sc_hd__tapvpwrvgnd_1
XTAP_TAPCELL_ROW_100_1748 VGND VPWR sky130_fd_sc_hd__tapvpwrvgnd_1
XFILLER_128_104 VGND VGND VPWR VPWR sky130_fd_sc_hd__decap_4
XPHY_EDGE_ROW_122_Left_264 VGND VGND VPWR VPWR sky130_fd_sc_hd__decap_3
X_11534_ clknet_leaf_14_clk _01365_ VGND VGND VPWR VPWR picorv32_core.cpuregs\[30\]\[15\]
+ sky130_fd_sc_hd__dfxtp_1
XTAP_TAPCELL_ROW_133_2236 VGND VPWR sky130_fd_sc_hd__tapvpwrvgnd_1
XFILLER_99_31 VGND VGND VPWR VPWR sky130_fd_sc_hd__fill_1
X_11465_ clknet_leaf_20_clk _01301_ VGND VGND VPWR VPWR picorv32_core.cpuregs\[24\]\[16\]
+ sky130_fd_sc_hd__dfxtp_1
XFILLER_139_93 VPWR VGND VPWR VGND sky130_ef_sc_hd__decap_12
XFILLER_137_671 VGND VGND VPWR VPWR sky130_fd_sc_hd__fill_1
XFILLER_109_373 VGND VGND VPWR VPWR sky130_fd_sc_hd__fill_2
X_10416_ clknet_leaf_125_clk _01578_ VGND VGND VPWR VPWR picorv32_core.reg_out\[9\]
+ sky130_fd_sc_hd__dfxtp_1
XFILLER_136_192 VGND VGND VPWR VPWR sky130_fd_sc_hd__decap_4
X_11396_ clknet_leaf_11_clk _01232_ VGND VGND VPWR VPWR picorv32_core.cpuregs\[31\]\[11\]
+ sky130_fd_sc_hd__dfxtp_1
XFILLER_3_651 VGND VGND VPWR VPWR sky130_fd_sc_hd__decap_3
X_10347_ clknet_leaf_104_clk _00266_ VGND VGND VPWR VPWR picorv32_core.count_cycle\[5\]
+ sky130_fd_sc_hd__dfxtp_1
X_10278_ clknet_leaf_74_clk _00197_ VGND VGND VPWR VPWR picorv32_core.count_instr\[62\]
+ sky130_fd_sc_hd__dfxtp_1
XPHY_EDGE_ROW_131_Left_273 VGND VGND VPWR VPWR sky130_fd_sc_hd__decap_3
XFILLER_78_474 VGND VGND VPWR VPWR sky130_fd_sc_hd__fill_2
XFILLER_65_113 VGND VGND VPWR VPWR sky130_fd_sc_hd__fill_2
XFILLER_38_305 VGND VGND VPWR VPWR sky130_fd_sc_hd__decap_3
XTAP_TAPCELL_ROW_49_1009 VGND VPWR sky130_fd_sc_hd__tapvpwrvgnd_1
XFILLER_0_53 VGND VGND VPWR VPWR sky130_fd_sc_hd__decap_3
XFILLER_34_533 VGND VGND VPWR VPWR sky130_fd_sc_hd__fill_1
XFILLER_34_522 VGND VGND VPWR VPWR sky130_fd_sc_hd__fill_1
XFILLER_46_382 VPWR VGND VPWR VGND sky130_ef_sc_hd__decap_12
XTAP_TAPCELL_ROW_62_1209 VGND VPWR sky130_fd_sc_hd__tapvpwrvgnd_1
XFILLER_0_97 VPWR VGND VPWR VGND sky130_ef_sc_hd__decap_12
X_06440_ net492 net1557 net421 VGND VGND VPWR VPWR _00106_ sky130_fd_sc_hd__mux2_1
XFILLER_34_599 VGND VGND VPWR VPWR sky130_fd_sc_hd__fill_1
XPHY_EDGE_ROW_140_Left_282 VGND VGND VPWR VPWR sky130_fd_sc_hd__decap_3
X_06371_ picorv32_core.reg_out\[26\] picorv32_core.alu_out_q\[26\] net953 VGND VGND
+ VPWR VPWR _02771_ sky130_fd_sc_hd__mux2_1
X_05322_ picorv32_core.reg_pc\[8\] picorv32_core.decoded_imm\[8\] VGND VGND VPWR VPWR
+ _01830_ sky130_fd_sc_hd__nand2_1
X_09090_ net467 net1596 net333 VGND VGND VPWR VPWR _01257_ sky130_fd_sc_hd__mux2_1
X_08110_ net449 net2093 net414 VGND VGND VPWR VPWR _00403_ sky130_fd_sc_hd__mux2_1
XTAP_TAPCELL_ROW_32_767 VGND VPWR sky130_fd_sc_hd__tapvpwrvgnd_1
X_08041_ net639 _04116_ VGND VGND VPWR VPWR _04117_ sky130_fd_sc_hd__or2_1
XTAP_TAPCELL_ROW_12_480 VGND VPWR sky130_fd_sc_hd__tapvpwrvgnd_1
X_05253_ _01764_ VGND VGND VPWR VPWR _01765_ sky130_fd_sc_hd__inv_2
XFILLER_134_129 VGND VGND VPWR VPWR sky130_fd_sc_hd__decap_3
XFILLER_116_811 VGND VGND VPWR VPWR sky130_fd_sc_hd__fill_1
Xhold902 picorv32_core.cpuregs\[12\]\[17\] VGND VGND VPWR VPWR net2011 sky130_fd_sc_hd__dlygate4sd3_1
Xhold913 picorv32_core.reg_sh\[1\] VGND VGND VPWR VPWR net2022 sky130_fd_sc_hd__dlygate4sd3_1
Xhold946 picorv32_core.cpuregs\[25\]\[26\] VGND VGND VPWR VPWR net2055 sky130_fd_sc_hd__dlygate4sd3_1
X_05184_ net919 _01688_ VGND VGND VPWR VPWR _01706_ sky130_fd_sc_hd__nand2_2
Xhold935 picorv32_core.instr_bltu VGND VGND VPWR VPWR net2044 sky130_fd_sc_hd__dlygate4sd3_1
Xhold924 picorv32_core.cpuregs\[31\]\[10\] VGND VGND VPWR VPWR net2033 sky130_fd_sc_hd__dlygate4sd3_1
Xhold979 picorv32_core.cpuregs\[27\]\[27\] VGND VGND VPWR VPWR net2088 sky130_fd_sc_hd__dlygate4sd3_1
Xhold957 picorv32_core.cpuregs\[8\]\[28\] VGND VGND VPWR VPWR net2066 sky130_fd_sc_hd__dlygate4sd3_1
X_09992_ net1970 net254 net314 VGND VGND VPWR VPWR _01469_ sky130_fd_sc_hd__mux2_1
XFILLER_0_109 VGND VGND VPWR VPWR sky130_fd_sc_hd__decap_3
Xhold968 picorv32_core.cpuregs\[22\]\[8\] VGND VGND VPWR VPWR net2077 sky130_fd_sc_hd__dlygate4sd3_1
X_08943_ net238 net2230 net355 VGND VGND VPWR VPWR _01116_ sky130_fd_sc_hd__mux2_1
Xclkbuf_4_15_0_clk clknet_0_clk VGND VGND VPWR VPWR clknet_4_15_0_clk sky130_fd_sc_hd__clkbuf_8
XFILLER_97_772 VGND VGND VPWR VPWR sky130_fd_sc_hd__decap_6
X_08874_ net248 net1910 net363 VGND VGND VPWR VPWR _01049_ sky130_fd_sc_hd__mux2_1
XFILLER_97_794 VGND VGND VPWR VPWR sky130_fd_sc_hd__fill_1
XFILLER_28_27 VGND VGND VPWR VPWR sky130_fd_sc_hd__fill_1
X_07825_ picorv32_core.cpuregs\[8\]\[17\] picorv32_core.cpuregs\[9\]\[17\] picorv32_core.cpuregs\[10\]\[17\]
+ picorv32_core.cpuregs\[11\]\[17\] net747 net714 VGND VGND VPWR VPWR _03913_ sky130_fd_sc_hd__mux4_1
XFILLER_84_477 VGND VGND VPWR VPWR sky130_fd_sc_hd__fill_2
XFILLER_84_466 VGND VGND VPWR VPWR sky130_fd_sc_hd__fill_1
XFILLER_72_639 VGND VGND VPWR VPWR sky130_fd_sc_hd__decap_4
XFILLER_72_606 VGND VGND VPWR VPWR sky130_fd_sc_hd__fill_1
X_07756_ _03844_ _03845_ net630 VGND VGND VPWR VPWR _03848_ sky130_fd_sc_hd__mux2_1
X_06707_ _02792_ picorv32_core.reg_next_pc\[31\] net560 VGND VGND VPWR VPWR _02943_
+ sky130_fd_sc_hd__mux2_2
XTAP_TAPCELL_ROW_88_1581 VGND VPWR sky130_fd_sc_hd__tapvpwrvgnd_1
X_09426_ net797 net548 _04613_ net469 VGND VGND VPWR VPWR _04614_ sky130_fd_sc_hd__o211a_1
XFILLER_13_717 VGND VGND VPWR VPWR sky130_fd_sc_hd__decap_8
X_07687_ net681 _03782_ net623 VGND VGND VPWR VPWR _03783_ sky130_fd_sc_hd__a21o_1
X_06638_ _02905_ _02906_ VGND VGND VPWR VPWR _00196_ sky130_fd_sc_hd__nor2_1
XFILLER_40_503 VGND VGND VPWR VPWR sky130_fd_sc_hd__fill_1
X_09357_ net808 net541 VGND VGND VPWR VPWR _04548_ sky130_fd_sc_hd__or2_1
X_06569_ picorv32_core.count_instr\[36\] _02859_ picorv32_core.count_instr\[37\] VGND
+ VGND VPWR VPWR _02862_ sky130_fd_sc_hd__a21o_1
X_08308_ _00744_ _00743_ _00741_ _00742_ VGND VGND VPWR VPWR _04230_ sky130_fd_sc_hd__and4bb_1
X_09288_ _01598_ net541 VGND VGND VPWR VPWR _04482_ sky130_fd_sc_hd__nand2_1
XFILLER_21_783 VGND VGND VPWR VPWR sky130_fd_sc_hd__fill_1
XFILLER_126_619 VGND VGND VPWR VPWR sky130_fd_sc_hd__decap_3
X_08239_ picorv32_core.mem_rdata_q\[4\] picorv32_core.mem_rdata_q\[5\] picorv32_core.mem_rdata_q\[6\]
+ _04222_ VGND VGND VPWR VPWR _04223_ sky130_fd_sc_hd__or4b_1
XFILLER_60_69 VGND VGND VPWR VPWR sky130_fd_sc_hd__fill_1
XFILLER_119_671 VGND VGND VPWR VPWR sky130_fd_sc_hd__fill_1
XFILLER_107_3 VPWR VGND VPWR VGND sky130_ef_sc_hd__decap_12
X_11250_ clknet_leaf_136_clk _01098_ VGND VGND VPWR VPWR picorv32_core.cpuregs\[4\]\[5\]
+ sky130_fd_sc_hd__dfxtp_1
XFILLER_106_365 VPWR VGND VPWR VGND sky130_ef_sc_hd__decap_12
X_10201_ clknet_leaf_22_clk _00120_ VGND VGND VPWR VPWR picorv32_core.cpuregs\[9\]\[17\]
+ sky130_fd_sc_hd__dfxtp_1
X_11181_ clknet_leaf_116_clk _01032_ VGND VGND VPWR VPWR picorv32_core.cpuregs\[6\]\[3\]
+ sky130_fd_sc_hd__dfxtp_1
XFILLER_121_302 VGND VGND VPWR VPWR sky130_fd_sc_hd__fill_1
X_10132_ clknet_leaf_19_clk _00054_ VGND VGND VPWR VPWR picorv32_core.cpuregs\[22\]\[15\]
+ sky130_fd_sc_hd__dfxtp_1
XFILLER_125_51 VGND VGND VPWR VPWR sky130_fd_sc_hd__decap_4
XFILLER_95_709 VGND VGND VPWR VPWR sky130_fd_sc_hd__decap_3
XFILLER_0_643 VGND VGND VPWR VPWR sky130_fd_sc_hd__fill_1
X_10063_ net1221 net234 net306 VGND VGND VPWR VPWR _01538_ sky130_fd_sc_hd__mux2_1
XFILLER_47_113 VGND VGND VPWR VPWR sky130_fd_sc_hd__decap_4
XFILLER_63_617 VGND VGND VPWR VPWR sky130_fd_sc_hd__fill_2
X_10965_ clknet_leaf_11_clk _00816_ VGND VGND VPWR VPWR picorv32_core.cpuregs\[13\]\[11\]
+ sky130_fd_sc_hd__dfxtp_1
X_10896_ clknet_leaf_99_clk _00747_ VGND VGND VPWR VPWR picorv32_core.mem_rdata_q\[6\]
+ sky130_fd_sc_hd__dfxtp_1
XFILLER_31_503 VGND VGND VPWR VPWR sky130_fd_sc_hd__fill_1
XFILLER_31_536 VPWR VGND VPWR VGND sky130_ef_sc_hd__decap_12
XFILLER_31_558 VGND VGND VPWR VPWR sky130_fd_sc_hd__fill_2
XFILLER_8_732 VPWR VGND VPWR VGND sky130_ef_sc_hd__decap_12
X_11517_ clknet_leaf_122_clk _00023_ VGND VGND VPWR VPWR _00003_ sky130_fd_sc_hd__dfxtp_1
X_11448_ clknet_leaf_68_clk _01284_ VGND VGND VPWR VPWR picorv32_core.cpuregs\[1\]\[31\]
+ sky130_fd_sc_hd__dfxtp_1
XTAP_TAPCELL_ROW_59_1160 VGND VPWR sky130_fd_sc_hd__tapvpwrvgnd_1
Xhold209 picorv32_core.cpuregs\[11\]\[12\] VGND VGND VPWR VPWR net1318 sky130_fd_sc_hd__dlygate4sd3_1
X_11379_ clknet_leaf_65_clk _01220_ VGND VGND VPWR VPWR picorv32_core.cpuregs\[18\]\[31\]
+ sky130_fd_sc_hd__dfxtp_1
XTAP_TAPCELL_ROW_113_1939 VGND VPWR sky130_fd_sc_hd__tapvpwrvgnd_1
XFILLER_140_699 VGND VGND VPWR VPWR sky130_fd_sc_hd__fill_1
X_05940_ net507 _02406_ _02409_ VGND VGND VPWR VPWR picorv32_core.alu_out\[14\] sky130_fd_sc_hd__a21o_1
XFILLER_22_3 VPWR VGND VPWR VGND sky130_ef_sc_hd__decap_12
XFILLER_66_455 VGND VGND VPWR VPWR sky130_fd_sc_hd__fill_2
X_05871_ _02329_ _02336_ _02334_ VGND VGND VPWR VPWR _02346_ sky130_fd_sc_hd__o21a_1
XFILLER_27_809 VPWR VGND VPWR VGND sky130_ef_sc_hd__decap_12
X_07610_ _03699_ _03708_ _03709_ _03704_ net681 VGND VGND VPWR VPWR _03710_ sky130_fd_sc_hd__a221o_1
X_08590_ net444 net1993 net394 VGND VGND VPWR VPWR _00713_ sky130_fd_sc_hd__mux2_1
XFILLER_38_157 VGND VGND VPWR VPWR sky130_fd_sc_hd__fill_1
XFILLER_81_425 VGND VGND VPWR VPWR sky130_fd_sc_hd__decap_8
XTAP_TAPCELL_ROW_37_837 VGND VPWR sky130_fd_sc_hd__tapvpwrvgnd_1
XTAP_TAPCELL_ROW_37_848 VGND VPWR sky130_fd_sc_hd__tapvpwrvgnd_1
X_07541_ net924 picorv32_core.cpu_state\[2\] net915 _01693_ _03648_ VGND VGND VPWR
+ VPWR _03649_ sky130_fd_sc_hd__o311a_1
X_07472_ net1744 _03602_ net460 VGND VGND VPWR VPWR _00334_ sky130_fd_sc_hd__mux2_1
XFILLER_14_18 VGND VGND VPWR VPWR sky130_fd_sc_hd__decap_8
XTAP_TAPCELL_ROW_17_550 VGND VPWR sky130_fd_sc_hd__tapvpwrvgnd_1
XFILLER_34_363 VGND VGND VPWR VPWR sky130_fd_sc_hd__fill_1
X_06423_ net248 net2122 net424 VGND VGND VPWR VPWR _00091_ sky130_fd_sc_hd__mux2_1
X_09211_ net652 _04407_ VGND VGND VPWR VPWR _04408_ sky130_fd_sc_hd__nand2_1
XFILLER_14_29 VPWR VGND VPWR VGND sky130_ef_sc_hd__decap_12
X_09142_ net1979 net237 net330 VGND VGND VPWR VPWR _01308_ sky130_fd_sc_hd__mux2_1
X_06354_ net1207 net241 net435 VGND VGND VPWR VPWR _00061_ sky130_fd_sc_hd__mux2_1
X_05305_ picorv32_core.count_instr\[7\] net939 net943 picorv32_core.count_cycle\[39\]
+ VGND VGND VPWR VPWR _01814_ sky130_fd_sc_hd__a22o_1
XFILLER_108_619 VGND VGND VPWR VPWR sky130_fd_sc_hd__fill_1
X_09073_ net1713 net247 net339 VGND VGND VPWR VPWR _01241_ sky130_fd_sc_hd__mux2_1
X_06285_ _02700_ _02701_ VGND VGND VPWR VPWR _02702_ sky130_fd_sc_hd__nor2_1
X_08024_ net695 _04093_ net684 VGND VGND VPWR VPWR _04101_ sky130_fd_sc_hd__o21a_1
XFILLER_107_129 VGND VGND VPWR VPWR sky130_fd_sc_hd__decap_3
Xhold710 net42 VGND VGND VPWR VPWR net1819 sky130_fd_sc_hd__dlygate4sd3_1
Xhold721 picorv32_core.cpuregs\[26\]\[15\] VGND VGND VPWR VPWR net1830 sky130_fd_sc_hd__dlygate4sd3_1
X_05236_ picorv32_core.count_cycle\[2\] net599 net576 _01749_ VGND VGND VPWR VPWR
+ _01750_ sky130_fd_sc_hd__o211a_1
Xhold732 picorv32_core.cpuregs\[21\]\[30\] VGND VGND VPWR VPWR net1841 sky130_fd_sc_hd__dlygate4sd3_1
XFILLER_116_674 VGND VGND VPWR VPWR sky130_fd_sc_hd__fill_2
Xhold743 picorv32_core.cpuregs\[8\]\[21\] VGND VGND VPWR VPWR net1852 sky130_fd_sc_hd__dlygate4sd3_1
Xhold754 picorv32_core.cpuregs\[18\]\[3\] VGND VGND VPWR VPWR net1863 sky130_fd_sc_hd__dlygate4sd3_1
X_05167_ picorv32_core.reg_sh\[1\] picorv32_core.reg_sh\[0\] VGND VGND VPWR VPWR _01692_
+ sky130_fd_sc_hd__or2_1
Xhold765 picorv32_core.cpuregs\[21\]\[23\] VGND VGND VPWR VPWR net1874 sky130_fd_sc_hd__dlygate4sd3_1
XFILLER_89_525 VGND VGND VPWR VPWR sky130_fd_sc_hd__fill_1
Xhold787 picorv32_core.cpuregs\[2\]\[1\] VGND VGND VPWR VPWR net1896 sky130_fd_sc_hd__dlygate4sd3_1
XFILLER_1_429 VGND VGND VPWR VPWR sky130_fd_sc_hd__decap_3
Xhold776 picorv32_core.cpuregs\[9\]\[9\] VGND VGND VPWR VPWR net1885 sky130_fd_sc_hd__dlygate4sd3_1
XFILLER_39_15 VGND VGND VPWR VPWR sky130_fd_sc_hd__decap_3
Xhold798 picorv32_core.cpuregs\[10\]\[22\] VGND VGND VPWR VPWR net1907 sky130_fd_sc_hd__dlygate4sd3_1
XFILLER_89_558 VGND VGND VPWR VPWR sky130_fd_sc_hd__fill_2
X_09975_ net1727 net497 net312 VGND VGND VPWR VPWR _01452_ sky130_fd_sc_hd__mux2_1
X_05098_ _01582_ _01624_ _01629_ VGND VGND VPWR VPWR _01630_ sky130_fd_sc_hd__o21ba_1
X_08926_ net443 net2102 net354 VGND VGND VPWR VPWR _01099_ sky130_fd_sc_hd__mux2_1
XFILLER_111_390 VGND VGND VPWR VPWR sky130_fd_sc_hd__fill_2
X_08857_ net493 net1644 net362 VGND VGND VPWR VPWR _01032_ sky130_fd_sc_hd__mux2_1
XFILLER_29_113 VGND VGND VPWR VPWR sky130_fd_sc_hd__fill_1
X_07808_ _03891_ _03892_ net634 VGND VGND VPWR VPWR _03897_ sky130_fd_sc_hd__mux2_1
XFILLER_57_455 VGND VGND VPWR VPWR sky130_fd_sc_hd__fill_1
XFILLER_29_146 VGND VGND VPWR VPWR sky130_fd_sc_hd__decap_3
XFILLER_72_425 VGND VGND VPWR VPWR sky130_fd_sc_hd__fill_1
X_08788_ net498 net1626 net371 VGND VGND VPWR VPWR _00966_ sky130_fd_sc_hd__mux2_1
XFILLER_45_639 VGND VGND VPWR VPWR sky130_fd_sc_hd__fill_2
X_07739_ net692 _03828_ net618 VGND VGND VPWR VPWR _03832_ sky130_fd_sc_hd__o21a_1
X_10750_ clknet_leaf_93_clk _00601_ VGND VGND VPWR VPWR picorv32_core.decoded_imm\[9\]
+ sky130_fd_sc_hd__dfxtp_2
XFILLER_41_823 VGND VGND VPWR VPWR sky130_fd_sc_hd__fill_2
X_10681_ clknet_leaf_98_clk _00534_ VGND VGND VPWR VPWR picorv32_core.is_alu_reg_reg
+ sky130_fd_sc_hd__dfxtp_1
X_09409_ picorv32_core.cpuregs\[4\]\[10\] picorv32_core.cpuregs\[5\]\[10\] picorv32_core.cpuregs\[6\]\[10\]
+ picorv32_core.cpuregs\[7\]\[10\] net873 net840 VGND VGND VPWR VPWR _04598_ sky130_fd_sc_hd__mux4_1
XTAP_TAPCELL_ROW_117_2006 VGND VPWR sky130_fd_sc_hd__tapvpwrvgnd_1
XFILLER_71_57 VGND VGND VPWR VPWR sky130_fd_sc_hd__decap_6
XFILLER_9_529 VGND VGND VPWR VPWR sky130_fd_sc_hd__decap_4
XFILLER_40_377 VGND VGND VPWR VPWR sky130_fd_sc_hd__fill_1
XFILLER_139_777 VGND VGND VPWR VPWR sky130_fd_sc_hd__decap_6
XFILLER_40_399 VGND VGND VPWR VPWR sky130_fd_sc_hd__decap_4
X_11302_ clknet_leaf_71_clk _01150_ VGND VGND VPWR VPWR picorv32_core.cpuregs\[3\]\[25\]
+ sky130_fd_sc_hd__dfxtp_1
X_11233_ clknet_leaf_43_clk _01084_ VGND VGND VPWR VPWR picorv32_core.cpuregs\[5\]\[23\]
+ sky130_fd_sc_hd__dfxtp_1
XFILLER_20_83 VGND VGND VPWR VPWR sky130_fd_sc_hd__fill_1
XFILLER_136_83 VGND VGND VPWR VPWR sky130_fd_sc_hd__fill_1
X_11164_ clknet_leaf_21_clk _01015_ VGND VGND VPWR VPWR picorv32_core.cpuregs\[7\]\[18\]
+ sky130_fd_sc_hd__dfxtp_1
XFILLER_122_699 VGND VGND VPWR VPWR sky130_fd_sc_hd__fill_1
XFILLER_110_817 VGND VGND VPWR VPWR sky130_fd_sc_hd__fill_1
XFILLER_95_517 VGND VGND VPWR VPWR sky130_fd_sc_hd__decap_4
X_11095_ clknet_leaf_14_clk _00946_ VGND VGND VPWR VPWR picorv32_core.cpuregs\[0\]\[13\]
+ sky130_fd_sc_hd__dfxtp_1
XTAP_TAPCELL_ROW_54_1090 VGND VPWR sky130_fd_sc_hd__tapvpwrvgnd_1
X_10115_ clknet_leaf_108_clk _00037_ VGND VGND VPWR VPWR axi_adapter.xfer_done sky130_fd_sc_hd__dfxtp_1
XTAP_TAPCELL_ROW_128_2168 VGND VPWR sky130_fd_sc_hd__tapvpwrvgnd_1
XTAP_TAPCELL_ROW_128_2157 VGND VPWR sky130_fd_sc_hd__tapvpwrvgnd_1
XFILLER_76_753 VGND VGND VPWR VPWR sky130_fd_sc_hd__decap_3
X_10046_ net1304 net431 net304 VGND VGND VPWR VPWR _01521_ sky130_fd_sc_hd__mux2_1
Xhold92 picorv32_core.cpuregs\[14\]\[28\] VGND VGND VPWR VPWR net1201 sky130_fd_sc_hd__dlygate4sd3_1
Xhold81 net131 VGND VGND VPWR VPWR net1190 sky130_fd_sc_hd__dlygate4sd3_1
Xhold70 picorv32_core.decoded_rd\[3\] VGND VGND VPWR VPWR net1179 sky130_fd_sc_hd__dlygate4sd3_1
XTAP_TAPCELL_ROW_141_2346 VGND VPWR sky130_fd_sc_hd__tapvpwrvgnd_1
XTAP_TAPCELL_ROW_141_2368 VGND VPWR sky130_fd_sc_hd__tapvpwrvgnd_1
XTAP_TAPCELL_ROW_141_2357 VGND VPWR sky130_fd_sc_hd__tapvpwrvgnd_1
XFILLER_91_767 VGND VGND VPWR VPWR sky130_fd_sc_hd__decap_4
X_10948_ clknet_leaf_45_clk _00799_ VGND VGND VPWR VPWR picorv32_core.cpuregs\[19\]\[26\]
+ sky130_fd_sc_hd__dfxtp_1
XFILLER_31_333 VGND VGND VPWR VPWR sky130_fd_sc_hd__decap_3
X_10879_ clknet_leaf_45_clk _00730_ VGND VGND VPWR VPWR picorv32_core.cpuregs\[16\]\[23\]
+ sky130_fd_sc_hd__dfxtp_1
XFILLER_129_265 VGND VGND VPWR VPWR sky130_fd_sc_hd__decap_6
XFILLER_8_562 VGND VGND VPWR VPWR sky130_fd_sc_hd__fill_2
X_06070_ net771 _02528_ VGND VGND VPWR VPWR _02529_ sky130_fd_sc_hd__nand2_1
XFILLER_6_41 VPWR VGND VPWR VGND sky130_ef_sc_hd__decap_12
XANTENNA_1 _00006_ VGND VGND VPWR VPWR sky130_fd_sc_hd__diode_2
XFILLER_6_85 VPWR VGND VPWR VGND sky130_ef_sc_hd__decap_12
Xfanout508 net509 VGND VGND VPWR VPWR net508 sky130_fd_sc_hd__dlymetal6s2s_1
XTAP_TAPCELL_ROW_70_1319 VGND VPWR sky130_fd_sc_hd__tapvpwrvgnd_1
Xfanout519 _01626_ VGND VGND VPWR VPWR net519 sky130_fd_sc_hd__buf_2
XFILLER_140_474 VGND VGND VPWR VPWR sky130_fd_sc_hd__fill_2
X_09760_ picorv32_core.cpuregs\[8\]\[26\] picorv32_core.cpuregs\[9\]\[26\] picorv32_core.cpuregs\[10\]\[26\]
+ picorv32_core.cpuregs\[11\]\[26\] net901 net867 VGND VGND VPWR VPWR _04933_ sky130_fd_sc_hd__mux4_1
X_06972_ net678 _03185_ VGND VGND VPWR VPWR _03186_ sky130_fd_sc_hd__nor2_1
X_08711_ net2036 net237 net384 VGND VGND VPWR VPWR _00860_ sky130_fd_sc_hd__mux2_1
X_09691_ _01599_ net542 VGND VGND VPWR VPWR _04867_ sky130_fd_sc_hd__nand2_1
X_05923_ _02379_ _02384_ _02377_ VGND VGND VPWR VPWR _02394_ sky130_fd_sc_hd__o21a_1
X_08642_ net1277 net249 net392 VGND VGND VPWR VPWR _00793_ sky130_fd_sc_hd__mux2_1
XFILLER_27_617 VGND VGND VPWR VPWR sky130_fd_sc_hd__decap_4
XFILLER_81_222 VGND VGND VPWR VPWR sky130_fd_sc_hd__fill_2
X_05854_ _02322_ _02324_ _02321_ VGND VGND VPWR VPWR _02330_ sky130_fd_sc_hd__a21o_1
X_08573_ net233 net2056 net400 VGND VGND VPWR VPWR _00698_ sky130_fd_sc_hd__mux2_1
XTAP_TAPCELL_ROW_85_1540 VGND VPWR sky130_fd_sc_hd__tapvpwrvgnd_1
X_05785_ net817 _02266_ VGND VGND VPWR VPWR _02267_ sky130_fd_sc_hd__nand2_1
X_07524_ picorv32_core.reg_out\[28\] picorv32_core.reg_next_pc\[28\] net559 VGND VGND
+ VPWR VPWR _03637_ sky130_fd_sc_hd__mux2_1
XFILLER_25_39 VGND VGND VPWR VPWR sky130_fd_sc_hd__fill_1
XFILLER_50_642 VGND VGND VPWR VPWR sky130_fd_sc_hd__fill_2
XFILLER_34_193 VGND VGND VPWR VPWR sky130_fd_sc_hd__decap_3
X_07455_ picorv32_core.reg_out\[5\] picorv32_core.reg_next_pc\[5\] net555 VGND VGND
+ VPWR VPWR _03591_ sky130_fd_sc_hd__mux2_1
XFILLER_50_653 VGND VGND VPWR VPWR sky130_fd_sc_hd__decap_6
X_06406_ net494 net1954 net423 VGND VGND VPWR VPWR _00074_ sky130_fd_sc_hd__mux2_1
X_07386_ net773 picorv32_core.decoded_imm\[24\] VGND VGND VPWR VPWR _03526_ sky130_fd_sc_hd__or2_1
XFILLER_136_725 VPWR VGND VPWR VGND sky130_ef_sc_hd__decap_12
X_06337_ _02740_ _02743_ net565 VGND VGND VPWR VPWR _02744_ sky130_fd_sc_hd__mux2_1
X_09125_ net1428 net446 net328 VGND VGND VPWR VPWR _01291_ sky130_fd_sc_hd__mux2_1
XFILLER_136_769 VPWR VGND VPWR VGND sky130_ef_sc_hd__decap_12
XFILLER_108_427 VGND VGND VPWR VPWR sky130_fd_sc_hd__decap_6
X_09056_ net1235 net493 net337 VGND VGND VPWR VPWR _01224_ sky130_fd_sc_hd__mux2_1
XTAP_TAPCELL_ROW_20_589 VGND VPWR sky130_fd_sc_hd__tapvpwrvgnd_1
X_06268_ picorv32_core.reg_out\[6\] picorv32_core.alu_out_q\[6\] net950 VGND VGND
+ VPWR VPWR _02688_ sky130_fd_sc_hd__mux2_1
X_08007_ net636 _04078_ net689 VGND VGND VPWR VPWR _04085_ sky130_fd_sc_hd__o21a_1
X_05219_ picorv32_core.count_instr\[1\] net939 net602 _01733_ VGND VGND VPWR VPWR
+ _01734_ sky130_fd_sc_hd__a211o_1
XFILLER_116_471 VGND VGND VPWR VPWR sky130_fd_sc_hd__decap_4
Xhold551 picorv32_core.cpuregs\[13\]\[21\] VGND VGND VPWR VPWR net1660 sky130_fd_sc_hd__dlygate4sd3_1
XTAP_TAPCELL_ROW_96_1691 VGND VPWR sky130_fd_sc_hd__tapvpwrvgnd_1
X_06199_ picorv32_core.cpuregs\[8\]\[3\] picorv32_core.cpuregs\[9\]\[3\] picorv32_core.cpuregs\[10\]\[3\]
+ picorv32_core.cpuregs\[11\]\[3\] net742 net709 VGND VGND VPWR VPWR _02630_ sky130_fd_sc_hd__mux4_1
XFILLER_2_749 VGND VGND VPWR VPWR sky130_fd_sc_hd__decap_6
Xhold562 picorv32_core.cpuregs\[24\]\[7\] VGND VGND VPWR VPWR net1671 sky130_fd_sc_hd__dlygate4sd3_1
Xhold540 picorv32_core.cpuregs\[12\]\[7\] VGND VGND VPWR VPWR net1649 sky130_fd_sc_hd__dlygate4sd3_1
Xhold584 picorv32_core.cpuregs\[21\]\[13\] VGND VGND VPWR VPWR net1693 sky130_fd_sc_hd__dlygate4sd3_1
Xhold573 picorv32_core.cpuregs\[20\]\[13\] VGND VGND VPWR VPWR net1682 sky130_fd_sc_hd__dlygate4sd3_1
XFILLER_1_237 VPWR VGND VPWR VGND sky130_ef_sc_hd__decap_12
Xhold595 picorv32_core.cpuregs\[12\]\[9\] VGND VGND VPWR VPWR net1704 sky130_fd_sc_hd__dlygate4sd3_1
XFILLER_104_699 VGND VGND VPWR VPWR sky130_fd_sc_hd__fill_1
X_09958_ net1779 net258 net318 VGND VGND VPWR VPWR _01436_ sky130_fd_sc_hd__mux2_1
X_08909_ net240 net1938 net360 VGND VGND VPWR VPWR _01083_ sky130_fd_sc_hd__mux2_1
X_09889_ net1947 net221 net326 VGND VGND VPWR VPWR _01377_ sky130_fd_sc_hd__mux2_1
Xhold1251 picorv32_core.count_instr\[30\] VGND VGND VPWR VPWR net2360 sky130_fd_sc_hd__dlygate4sd3_1
Xhold1240 picorv32_core.decoded_imm_j\[16\] VGND VGND VPWR VPWR net2349 sky130_fd_sc_hd__dlygate4sd3_1
XFILLER_122_41 VGND VGND VPWR VPWR sky130_fd_sc_hd__decap_8
X_11851_ net54 VGND VGND VPWR VPWR net86 sky130_fd_sc_hd__clkbuf_1
XTAP_TAPCELL_ROW_123_2087 VGND VPWR sky130_fd_sc_hd__tapvpwrvgnd_1
X_10802_ clknet_leaf_2_clk _00653_ VGND VGND VPWR VPWR picorv32_core.cpuregs\[15\]\[11\]
+ sky130_fd_sc_hd__dfxtp_1
X_10733_ clknet_leaf_89_clk _00584_ VGND VGND VPWR VPWR picorv32_core.decoded_imm\[26\]
+ sky130_fd_sc_hd__dfxtp_2
XFILLER_60_439 VPWR VGND VPWR VGND sky130_ef_sc_hd__decap_12
XTAP_TAPCELL_ROW_0_292 VGND VPWR sky130_fd_sc_hd__tapvpwrvgnd_1
XFILLER_13_388 VGND VGND VPWR VPWR sky130_fd_sc_hd__decap_4
X_10664_ clknet_leaf_107_clk _00518_ VGND VGND VPWR VPWR picorv32_core.decoded_rd\[0\]
+ sky130_fd_sc_hd__dfxtp_1
X_10595_ clknet_leaf_93_clk _00449_ VGND VGND VPWR VPWR picorv32_core.instr_andi sky130_fd_sc_hd__dfxtp_1
XFILLER_5_521 VGND VGND VPWR VPWR sky130_fd_sc_hd__fill_1
XFILLER_127_769 VPWR VGND VPWR VGND sky130_ef_sc_hd__decap_12
XFILLER_5_554 VGND VGND VPWR VPWR sky130_fd_sc_hd__decap_6
XPHY_EDGE_ROW_128_Right_128 VGND VGND VPWR VPWR sky130_fd_sc_hd__decap_3
XFILLER_107_460 VGND VGND VPWR VPWR sky130_fd_sc_hd__decap_8
Xoutput60 net60 VGND VGND VPWR VPWR mem_axi_araddr[30] sky130_fd_sc_hd__buf_2
X_11216_ clknet_leaf_143_clk _01067_ VGND VGND VPWR VPWR picorv32_core.cpuregs\[5\]\[6\]
+ sky130_fd_sc_hd__dfxtp_1
XFILLER_122_474 VGND VGND VPWR VPWR sky130_fd_sc_hd__fill_2
Xoutput93 net93 VGND VGND VPWR VPWR mem_axi_awaddr[31] sky130_fd_sc_hd__buf_2
Xoutput82 net82 VGND VGND VPWR VPWR mem_axi_awaddr[21] sky130_fd_sc_hd__buf_2
X_11147_ clknet_leaf_110_clk _00998_ VGND VGND VPWR VPWR picorv32_core.cpuregs\[7\]\[1\]
+ sky130_fd_sc_hd__dfxtp_1
Xoutput71 net71 VGND VGND VPWR VPWR mem_axi_awaddr[10] sky130_fd_sc_hd__buf_2
XFILLER_0_281 VGND VGND VPWR VPWR sky130_fd_sc_hd__fill_1
X_11078_ clknet_leaf_39_clk _00929_ VGND VGND VPWR VPWR picorv32_core.cpuregs\[10\]\[28\]
+ sky130_fd_sc_hd__dfxtp_1
X_10029_ net1924 net236 net310 VGND VGND VPWR VPWR _01505_ sky130_fd_sc_hd__mux2_1
XFILLER_64_712 VGND VGND VPWR VPWR sky130_fd_sc_hd__fill_1
XFILLER_36_414 VGND VGND VPWR VPWR sky130_fd_sc_hd__decap_6
XFILLER_48_263 VGND VGND VPWR VPWR sky130_fd_sc_hd__fill_2
XFILLER_91_553 VGND VGND VPWR VPWR sky130_fd_sc_hd__decap_6
X_05570_ net945 picorv32_core.count_cycle\[58\] net603 _02059_ VGND VGND VPWR VPWR
+ _02060_ sky130_fd_sc_hd__a211o_1
XTAP_TAPCELL_ROW_67_1270 VGND VPWR sky130_fd_sc_hd__tapvpwrvgnd_1
XTAP_TAPCELL_ROW_47_987 VGND VPWR sky130_fd_sc_hd__tapvpwrvgnd_1
XTAP_TAPCELL_ROW_67_1281 VGND VPWR sky130_fd_sc_hd__tapvpwrvgnd_1
XFILLER_16_193 VGND VGND VPWR VPWR sky130_fd_sc_hd__decap_3
X_07240_ picorv32_core.count_cycle\[61\] _03380_ _03382_ VGND VGND VPWR VPWR _00322_
+ sky130_fd_sc_hd__o21a_1
XTAP_TAPCELL_ROW_80_1470 VGND VPWR sky130_fd_sc_hd__tapvpwrvgnd_1
X_07171_ picorv32_core.count_cycle\[34\] picorv32_core.count_cycle\[35\] picorv32_core.count_cycle\[36\]
+ _03334_ VGND VGND VPWR VPWR _03339_ sky130_fd_sc_hd__and4_1
XFILLER_118_747 VGND VGND VPWR VPWR sky130_fd_sc_hd__decap_8
X_06122_ net954 _02576_ VGND VGND VPWR VPWR _02577_ sky130_fd_sc_hd__xor2_1
XFILLER_118_769 VPWR VGND VPWR VGND sky130_ef_sc_hd__decap_12
XFILLER_8_392 VGND VGND VPWR VPWR sky130_fd_sc_hd__decap_3
XFILLER_132_227 VGND VGND VPWR VPWR sky130_fd_sc_hd__fill_1
XFILLER_117_279 VGND VGND VPWR VPWR sky130_fd_sc_hd__fill_1
XFILLER_105_419 VPWR VGND VPWR VGND sky130_ef_sc_hd__decap_12
X_06053_ _02497_ _02502_ _02512_ VGND VGND VPWR VPWR _02514_ sky130_fd_sc_hd__a21o_1
XFILLER_113_430 VGND VGND VPWR VPWR sky130_fd_sc_hd__fill_2
Xfanout305 _05042_ VGND VGND VPWR VPWR net305 sky130_fd_sc_hd__clkbuf_4
XFILLER_141_783 VGND VGND VPWR VPWR sky130_fd_sc_hd__fill_1
X_09812_ _04975_ _04976_ _04982_ _04981_ net838 net828 VGND VGND VPWR VPWR _04983_
+ sky130_fd_sc_hd__mux4_1
Xfanout327 _05029_ VGND VGND VPWR VPWR net327 sky130_fd_sc_hd__buf_4
XFILLER_101_614 VGND VGND VPWR VPWR sky130_fd_sc_hd__fill_2
Xfanout338 net339 VGND VGND VPWR VPWR net338 sky130_fd_sc_hd__clkbuf_8
Xfanout316 net317 VGND VGND VPWR VPWR net316 sky130_fd_sc_hd__buf_4
Xfanout349 _04345_ VGND VGND VPWR VPWR net349 sky130_fd_sc_hd__buf_2
X_09743_ picorv32_core.cpuregs\[12\]\[25\] picorv32_core.cpuregs\[13\]\[25\] picorv32_core.cpuregs\[14\]\[25\]
+ picorv32_core.cpuregs\[15\]\[25\] net905 net870 VGND VGND VPWR VPWR _04917_ sky130_fd_sc_hd__mux4_1
XFILLER_100_168 VGND VGND VPWR VPWR sky130_fd_sc_hd__decap_3
X_06955_ _03124_ _03132_ _03166_ _03169_ VGND VGND VPWR VPWR _03170_ sky130_fd_sc_hd__o31ai_2
X_09674_ picorv32_core.cpuregs\[16\]\[22\] picorv32_core.cpuregs\[17\]\[22\] picorv32_core.cpuregs\[18\]\[22\]
+ picorv32_core.cpuregs\[19\]\[22\] net894 net860 VGND VGND VPWR VPWR _04851_ sky130_fd_sc_hd__mux4_1
X_06886_ picorv32_core.decoded_imm_j\[16\] _02928_ VGND VGND VPWR VPWR _03106_ sky130_fd_sc_hd__and2_1
X_05906_ net797 _02376_ VGND VGND VPWR VPWR _02378_ sky130_fd_sc_hd__or2_1
XFILLER_27_403 VGND VGND VPWR VPWR sky130_fd_sc_hd__fill_1
XFILLER_36_27 VGND VGND VPWR VPWR sky130_fd_sc_hd__fill_1
X_08625_ net1270 net492 net391 VGND VGND VPWR VPWR _00776_ sky130_fd_sc_hd__mux2_1
XFILLER_15_609 VGND VGND VPWR VPWR sky130_fd_sc_hd__fill_1
XFILLER_36_49 VGND VGND VPWR VPWR sky130_fd_sc_hd__fill_1
X_05837_ _02296_ _02314_ VGND VGND VPWR VPWR _02315_ sky130_fd_sc_hd__or2_1
X_08556_ net430 net1858 net398 VGND VGND VPWR VPWR _00681_ sky130_fd_sc_hd__mux2_1
X_07507_ net778 _03625_ net535 VGND VGND VPWR VPWR _03626_ sky130_fd_sc_hd__mux2_1
X_05768_ picorv32_core.instr_and picorv32_core.instr_andi VGND VGND VPWR VPWR _02252_
+ sky130_fd_sc_hd__or2_2
X_05699_ net791 net179 VGND VGND VPWR VPWR _02183_ sky130_fd_sc_hd__or2_1
X_08487_ net1290 net431 net407 VGND VGND VPWR VPWR _00617_ sky130_fd_sc_hd__mux2_1
X_07438_ _03396_ _03577_ VGND VGND VPWR VPWR _03578_ sky130_fd_sc_hd__nor2_1
XFILLER_50_494 VPWR VGND VPWR VGND sky130_ef_sc_hd__decap_12
XFILLER_50_472 VGND VGND VPWR VPWR sky130_fd_sc_hd__decap_4
XTAP_TAPCELL_ROW_98_1731 VGND VPWR sky130_fd_sc_hd__tapvpwrvgnd_1
XTAP_TAPCELL_ROW_98_1720 VGND VPWR sky130_fd_sc_hd__tapvpwrvgnd_1
X_07369_ net785 picorv32_core.decoded_imm\[18\] VGND VGND VPWR VPWR _03509_ sky130_fd_sc_hd__or2_1
XFILLER_6_307 VGND VGND VPWR VPWR sky130_fd_sc_hd__fill_1
XFILLER_136_533 VGND VGND VPWR VPWR sky130_fd_sc_hd__fill_1
X_09108_ net240 net1612 net334 VGND VGND VPWR VPWR _01275_ sky130_fd_sc_hd__mux2_1
X_10380_ clknet_leaf_102_clk _00299_ VGND VGND VPWR VPWR picorv32_core.count_cycle\[38\]
+ sky130_fd_sc_hd__dfxtp_1
X_09039_ net251 net1753 net342 VGND VGND VPWR VPWR _01208_ sky130_fd_sc_hd__mux2_1
XFILLER_117_52 VGND VGND VPWR VPWR sky130_fd_sc_hd__decap_4
Xhold381 picorv32_core.cpuregs\[15\]\[14\] VGND VGND VPWR VPWR net1490 sky130_fd_sc_hd__dlygate4sd3_1
Xhold370 picorv32_core.cpuregs\[19\]\[4\] VGND VGND VPWR VPWR net1479 sky130_fd_sc_hd__dlygate4sd3_1
X_11001_ clknet_leaf_14_clk _00852_ VGND VGND VPWR VPWR picorv32_core.cpuregs\[12\]\[15\]
+ sky130_fd_sc_hd__dfxtp_1
Xhold392 picorv32_core.cpuregs\[11\]\[3\] VGND VGND VPWR VPWR net1501 sky130_fd_sc_hd__dlygate4sd3_1
Xfanout861 net862 VGND VGND VPWR VPWR net861 sky130_fd_sc_hd__clkbuf_2
XFILLER_77_78 VGND VGND VPWR VPWR sky130_fd_sc_hd__fill_1
Xfanout850 _00006_ VGND VGND VPWR VPWR net850 sky130_fd_sc_hd__clkbuf_4
XTAP_TAPCELL_ROW_125_2116 VGND VPWR sky130_fd_sc_hd__tapvpwrvgnd_1
Xfanout872 _00006_ VGND VGND VPWR VPWR net872 sky130_fd_sc_hd__clkbuf_4
Xfanout894 net896 VGND VGND VPWR VPWR net894 sky130_fd_sc_hd__buf_4
Xfanout883 net907 VGND VGND VPWR VPWR net883 sky130_fd_sc_hd__clkbuf_4
XFILLER_58_550 VGND VGND VPWR VPWR sky130_fd_sc_hd__decap_8
XTAP_TAPCELL_ROW_5_373 VGND VPWR sky130_fd_sc_hd__tapvpwrvgnd_1
XFILLER_133_51 VGND VGND VPWR VPWR sky130_fd_sc_hd__decap_4
XTAP_TAPCELL_ROW_5_384 VGND VPWR sky130_fd_sc_hd__tapvpwrvgnd_1
Xhold1081 picorv32_core.cpuregs\[4\]\[27\] VGND VGND VPWR VPWR net2190 sky130_fd_sc_hd__dlygate4sd3_1
Xhold1070 picorv32_core.cpuregs\[2\]\[21\] VGND VGND VPWR VPWR net2179 sky130_fd_sc_hd__dlygate4sd3_1
XFILLER_93_55 VGND VGND VPWR VPWR sky130_fd_sc_hd__fill_1
XFILLER_73_531 VGND VGND VPWR VPWR sky130_fd_sc_hd__decap_6
Xhold1092 picorv32_core.cpuregs\[16\]\[13\] VGND VGND VPWR VPWR net2201 sky130_fd_sc_hd__dlygate4sd3_1
XFILLER_45_222 VGND VGND VPWR VPWR sky130_fd_sc_hd__fill_2
XTAP_TAPCELL_ROW_107_1860 VGND VPWR sky130_fd_sc_hd__tapvpwrvgnd_1
XFILLER_33_406 VPWR VGND VPWR VGND sky130_ef_sc_hd__decap_12
X_11834_ net67 VGND VGND VPWR VPWR net99 sky130_fd_sc_hd__clkbuf_1
XTAP_TAPCELL_ROW_44_946 VGND VPWR sky130_fd_sc_hd__tapvpwrvgnd_1
X_10716_ clknet_leaf_26_clk _00567_ VGND VGND VPWR VPWR net122 sky130_fd_sc_hd__dfxtp_1
X_11696_ clknet_leaf_10_clk _01527_ VGND VGND VPWR VPWR picorv32_core.cpuregs\[27\]\[13\]
+ sky130_fd_sc_hd__dfxtp_1
XFILLER_13_152 VGND VGND VPWR VPWR sky130_fd_sc_hd__decap_3
X_10647_ clknet_leaf_18_clk _00501_ VGND VGND VPWR VPWR picorv32_core.cpuregs\[20\]\[15\]
+ sky130_fd_sc_hd__dfxtp_1
XFILLER_139_393 VGND VGND VPWR VPWR sky130_fd_sc_hd__fill_1
XTAP_TAPCELL_ROW_136_2278 VGND VPWR sky130_fd_sc_hd__tapvpwrvgnd_1
X_10578_ clknet_leaf_97_clk _00432_ VGND VGND VPWR VPWR picorv32_core.instr_beq sky130_fd_sc_hd__dfxtp_1
XFILLER_127_599 VGND VGND VPWR VPWR sky130_fd_sc_hd__fill_1
XFILLER_123_783 VGND VGND VPWR VPWR sky130_fd_sc_hd__fill_1
XFILLER_96_645 VGND VGND VPWR VPWR sky130_fd_sc_hd__decap_4
XFILLER_95_111 VGND VGND VPWR VPWR sky130_fd_sc_hd__fill_1
XFILLER_96_689 VGND VGND VPWR VPWR sky130_fd_sc_hd__decap_6
XFILLER_49_561 VGND VGND VPWR VPWR sky130_fd_sc_hd__fill_2
XFILLER_49_550 VGND VGND VPWR VPWR sky130_fd_sc_hd__decap_8
XTAP_TAPCELL_ROW_69_1310 VGND VPWR sky130_fd_sc_hd__tapvpwrvgnd_1
XFILLER_36_211 VGND VGND VPWR VPWR sky130_fd_sc_hd__decap_3
X_06740_ net587 _02971_ VGND VGND VPWR VPWR _02972_ sky130_fd_sc_hd__nor2_1
X_06671_ _02716_ picorv32_core.reg_next_pc\[13\] net557 VGND VGND VPWR VPWR _02925_
+ sky130_fd_sc_hd__mux2_2
X_05622_ net27 net583 net574 VGND VGND VPWR VPWR _02108_ sky130_fd_sc_hd__a21o_1
X_08410_ net676 net934 _04284_ VGND VGND VPWR VPWR _04285_ sky130_fd_sc_hd__a21o_1
XFILLER_64_586 VGND VGND VPWR VPWR sky130_fd_sc_hd__fill_2
XFILLER_64_575 VGND VGND VPWR VPWR sky130_fd_sc_hd__fill_2
XFILLER_37_789 VGND VGND VPWR VPWR sky130_fd_sc_hd__fill_1
XFILLER_51_225 VGND VGND VPWR VPWR sky130_fd_sc_hd__decap_3
X_09390_ picorv32_core.cpuregs\[0\]\[9\] picorv32_core.cpuregs\[1\]\[9\] picorv32_core.cpuregs\[2\]\[9\]
+ picorv32_core.cpuregs\[3\]\[9\] net873 net840 VGND VGND VPWR VPWR _04580_ sky130_fd_sc_hd__mux4_1
X_05553_ _02042_ _02043_ VGND VGND VPWR VPWR _02044_ sky130_fd_sc_hd__nand2_1
X_08341_ net928 picorv32_core.mem_la_wdata\[3\] net175 net927 VGND VGND VPWR VPWR
+ _04243_ sky130_fd_sc_hd__a22o_1
X_05484_ _01978_ _01979_ VGND VGND VPWR VPWR _01980_ sky130_fd_sc_hd__nand2_1
XTAP_TAPCELL_ROW_22_618 VGND VPWR sky130_fd_sc_hd__tapvpwrvgnd_1
XTAP_TAPCELL_ROW_22_629 VGND VPWR sky130_fd_sc_hd__tapvpwrvgnd_1
X_08272_ net1755 net295 net410 VGND VGND VPWR VPWR _00496_ sky130_fd_sc_hd__mux2_1
X_07223_ picorv32_core.count_cycle\[55\] _03370_ net977 VGND VGND VPWR VPWR _03372_
+ sky130_fd_sc_hd__a21oi_1
XFILLER_22_29 VPWR VGND VPWR VGND sky130_ef_sc_hd__decap_12
XFILLER_138_29 VPWR VGND VPWR VGND sky130_ef_sc_hd__decap_12
X_07154_ _03328_ net995 _03327_ VGND VGND VPWR VPWR _00290_ sky130_fd_sc_hd__and3b_1
X_06105_ _02154_ _02249_ net608 VGND VGND VPWR VPWR _02561_ sky130_fd_sc_hd__a21o_1
X_07085_ _03284_ _03285_ VGND VGND VPWR VPWR _00264_ sky130_fd_sc_hd__nor2_1
XFILLER_133_558 VGND VGND VPWR VPWR sky130_fd_sc_hd__fill_2
X_06036_ net777 _02496_ VGND VGND VPWR VPWR _02498_ sky130_fd_sc_hd__or2_1
XTAP_TAPCELL_ROW_93_1650 VGND VPWR sky130_fd_sc_hd__tapvpwrvgnd_1
XFILLER_101_400 VGND VGND VPWR VPWR sky130_fd_sc_hd__decap_8
X_07987_ net640 _04065_ VGND VGND VPWR VPWR _04066_ sky130_fd_sc_hd__or2_1
XFILLER_87_656 VPWR VGND VPWR VGND sky130_ef_sc_hd__decap_12
X_09726_ _04892_ _04893_ _04898_ _04899_ net658 net646 VGND VGND VPWR VPWR _04901_
+ sky130_fd_sc_hd__mux4_1
XFILLER_101_477 VGND VGND VPWR VPWR sky130_fd_sc_hd__fill_2
X_06938_ _03152_ _03153_ VGND VGND VPWR VPWR _03154_ sky130_fd_sc_hd__and2_1
XTAP_TAPCELL_ROW_2_332 VGND VPWR sky130_fd_sc_hd__tapvpwrvgnd_1
X_09657_ net659 _04834_ VGND VGND VPWR VPWR _04835_ sky130_fd_sc_hd__or2_1
X_06869_ net667 picorv32_core.reg_next_pc\[14\] _02926_ net490 VGND VGND VPWR VPWR
+ _03091_ sky130_fd_sc_hd__a22o_1
XTAP_TAPCELL_ROW_120_2046 VGND VPWR sky130_fd_sc_hd__tapvpwrvgnd_1
X_08608_ net233 net2105 net396 VGND VGND VPWR VPWR _00731_ sky130_fd_sc_hd__mux2_1
X_09588_ picorv32_core.cpuregs\[16\]\[18\] picorv32_core.cpuregs\[17\]\[18\] picorv32_core.cpuregs\[18\]\[18\]
+ picorv32_core.cpuregs\[19\]\[18\] net900 net866 VGND VGND VPWR VPWR _04769_ sky130_fd_sc_hd__mux4_1
XFILLER_82_383 VGND VGND VPWR VPWR sky130_fd_sc_hd__fill_2
X_08539_ net1507 net233 net404 VGND VGND VPWR VPWR _00666_ sky130_fd_sc_hd__mux2_1
XTAP_TAPCELL_ROW_41_905 VGND VPWR sky130_fd_sc_hd__tapvpwrvgnd_1
XFILLER_129_809 VPWR VGND VPWR VGND sky130_ef_sc_hd__decap_12
X_11550_ clknet_leaf_62_clk _01381_ VGND VGND VPWR VPWR picorv32_core.cpuregs\[30\]\[31\]
+ sky130_fd_sc_hd__dfxtp_1
XFILLER_70_589 VGND VGND VPWR VPWR sky130_fd_sc_hd__decap_3
XFILLER_137_3 VPWR VGND VPWR VGND sky130_ef_sc_hd__decap_12
X_10501_ clknet_leaf_47_clk _00387_ VGND VGND VPWR VPWR net192 sky130_fd_sc_hd__dfxtp_4
XTAP_TAPCELL_ROW_102_1790 VGND VPWR sky130_fd_sc_hd__tapvpwrvgnd_1
X_11481_ clknet_leaf_96_clk _01317_ VGND VGND VPWR VPWR picorv32_core.instr_sb sky130_fd_sc_hd__dfxtp_1
XFILLER_10_144 VGND VGND VPWR VPWR sky130_fd_sc_hd__fill_2
X_10432_ clknet_leaf_59_clk _01564_ VGND VGND VPWR VPWR picorv32_core.reg_out\[25\]
+ sky130_fd_sc_hd__dfxtp_1
XFILLER_124_514 VGND VGND VPWR VPWR sky130_fd_sc_hd__decap_4
X_10363_ clknet_leaf_85_clk _00282_ VGND VGND VPWR VPWR picorv32_core.count_cycle\[21\]
+ sky130_fd_sc_hd__dfxtp_1
XFILLER_124_547 VGND VGND VPWR VPWR sky130_fd_sc_hd__decap_3
XFILLER_88_44 VGND VGND VPWR VPWR sky130_fd_sc_hd__fill_1
XFILLER_3_833 VGND VGND VPWR VPWR sky130_fd_sc_hd__decap_4
X_10294_ clknet_leaf_89_clk _00213_ VGND VGND VPWR VPWR picorv32_core.reg_pc\[15\]
+ sky130_fd_sc_hd__dfxtp_1
XFILLER_78_645 VGND VGND VPWR VPWR sky130_fd_sc_hd__decap_4
XFILLER_120_753 VGND VGND VPWR VPWR sky130_fd_sc_hd__decap_3
Xfanout680 picorv32_core.instr_jal VGND VGND VPWR VPWR net680 sky130_fd_sc_hd__clkbuf_2
Xfanout691 _00003_ VGND VGND VPWR VPWR net691 sky130_fd_sc_hd__buf_4
XFILLER_58_380 VGND VGND VPWR VPWR sky130_fd_sc_hd__decap_8
XFILLER_61_512 VGND VGND VPWR VPWR sky130_fd_sc_hd__decap_6
XFILLER_46_586 VGND VGND VPWR VPWR sky130_fd_sc_hd__fill_2
XTAP_TAPCELL_ROW_64_1240 VGND VPWR sky130_fd_sc_hd__tapvpwrvgnd_1
XTAP_TAPCELL_ROW_138_2307 VGND VPWR sky130_fd_sc_hd__tapvpwrvgnd_1
X_11679_ clknet_leaf_39_clk _01510_ VGND VGND VPWR VPWR picorv32_core.cpuregs\[26\]\[28\]
+ sky130_fd_sc_hd__dfxtp_1
XFILLER_115_547 VGND VGND VPWR VPWR sky130_fd_sc_hd__decap_3
XFILLER_5_181 VPWR VGND VPWR VGND sky130_ef_sc_hd__decap_12
XFILLER_130_506 VGND VGND VPWR VPWR sky130_fd_sc_hd__decap_4
X_07910_ net186 net511 _03992_ _03993_ VGND VGND VPWR VPWR _00381_ sky130_fd_sc_hd__o22a_1
XTAP_TAPCELL_ROW_75_1391 VGND VPWR sky130_fd_sc_hd__tapvpwrvgnd_1
XFILLER_68_122 VGND VGND VPWR VPWR sky130_fd_sc_hd__fill_2
X_08890_ net493 net1825 net359 VGND VGND VPWR VPWR _01064_ sky130_fd_sc_hd__mux2_1
XFILLER_111_753 VPWR VGND VPWR VGND sky130_ef_sc_hd__decap_12
X_07841_ picorv32_core.cpuregs\[0\]\[18\] picorv32_core.cpuregs\[1\]\[18\] picorv32_core.cpuregs\[2\]\[18\]
+ picorv32_core.cpuregs\[3\]\[18\] net750 net717 VGND VGND VPWR VPWR _03928_ sky130_fd_sc_hd__mux4_1
XFILLER_111_797 VPWR VGND VPWR VGND sky130_ef_sc_hd__decap_12
XFILLER_96_486 VGND VGND VPWR VPWR sky130_fd_sc_hd__fill_2
X_07772_ picorv32_core.cpuregs\[8\]\[14\] picorv32_core.cpuregs\[9\]\[14\] picorv32_core.cpuregs\[10\]\[14\]
+ picorv32_core.cpuregs\[11\]\[14\] net747 net714 VGND VGND VPWR VPWR _03863_ sky130_fd_sc_hd__mux4_1
X_09511_ net783 net547 VGND VGND VPWR VPWR _04695_ sky130_fd_sc_hd__or2_1
XFILLER_17_18 VPWR VGND VPWR VGND sky130_ef_sc_hd__decap_12
X_06723_ _02954_ _02955_ VGND VGND VPWR VPWR _02956_ sky130_fd_sc_hd__nor2_1
XFILLER_25_704 VGND VGND VPWR VPWR sky130_fd_sc_hd__fill_2
X_06654_ picorv32_core.reg_pc\[4\] net551 _02916_ net514 VGND VGND VPWR VPWR _00202_
+ sky130_fd_sc_hd__a22o_1
X_09442_ net831 _04626_ _04629_ net478 VGND VGND VPWR VPWR _04630_ sky130_fd_sc_hd__o211a_1
X_05605_ picorv32_core.reg_pc\[29\] picorv32_core.decoded_imm\[29\] VGND VGND VPWR
+ VPWR _02092_ sky130_fd_sc_hd__and2_1
X_06585_ picorv32_core.count_instr\[42\] _02869_ picorv32_core.count_instr\[43\] VGND
+ VGND VPWR VPWR _02872_ sky130_fd_sc_hd__a21o_1
X_09373_ net830 _04560_ _04563_ net478 VGND VGND VPWR VPWR _04564_ sky130_fd_sc_hd__o211a_1
X_05536_ _02007_ _02019_ VGND VGND VPWR VPWR _02028_ sky130_fd_sc_hd__or2_1
XFILLER_52_589 VGND VGND VPWR VPWR sky130_fd_sc_hd__fill_1
X_08324_ net969 net1188 net453 VGND VGND VPWR VPWR _00541_ sky130_fd_sc_hd__mux2_1
XFILLER_33_781 VGND VGND VPWR VPWR sky130_fd_sc_hd__decap_3
XFILLER_137_105 VGND VGND VPWR VPWR sky130_fd_sc_hd__decap_6
X_05467_ net911 net303 _01960_ _01964_ VGND VGND VPWR VPWR _01965_ sky130_fd_sc_hd__a31o_1
X_08255_ net2342 _00753_ net441 VGND VGND VPWR VPWR _00481_ sky130_fd_sc_hd__mux2_1
X_07206_ picorv32_core.count_cycle\[49\] _03359_ VGND VGND VPWR VPWR _03361_ sky130_fd_sc_hd__or2_1
X_05398_ net918 net796 _01897_ net910 _01900_ VGND VGND VPWR VPWR _01901_ sky130_fd_sc_hd__a221o_1
X_08186_ picorv32_core.is_alu_reg_imm net526 VGND VGND VPWR VPWR _04198_ sky130_fd_sc_hd__and2_1
X_07137_ picorv32_core.count_cycle\[22\] picorv32_core.count_cycle\[23\] _03314_ VGND
+ VGND VPWR VPWR _03318_ sky130_fd_sc_hd__and3_1
X_07068_ _02943_ _03263_ net679 VGND VGND VPWR VPWR _03273_ sky130_fd_sc_hd__a21oi_1
XTAP_TAPCELL_ROW_7_413 VGND VPWR sky130_fd_sc_hd__tapvpwrvgnd_1
XTAP_TAPCELL_ROW_7_402 VGND VPWR sky130_fd_sc_hd__tapvpwrvgnd_1
X_06019_ _02177_ net571 net609 VGND VGND VPWR VPWR _02483_ sky130_fd_sc_hd__a21o_1
XFILLER_0_825 VGND VGND VPWR VPWR sky130_fd_sc_hd__decap_3
XFILLER_102_753 VGND VGND VPWR VPWR sky130_fd_sc_hd__decap_3
XFILLER_75_659 VGND VGND VPWR VPWR sky130_fd_sc_hd__fill_1
X_10981_ clknet_leaf_43_clk _00832_ VGND VGND VPWR VPWR picorv32_core.cpuregs\[13\]\[27\]
+ sky130_fd_sc_hd__dfxtp_1
X_09709_ net284 _04871_ _04884_ _04865_ VGND VGND VPWR VPWR _01342_ sky130_fd_sc_hd__a31o_1
XFILLER_62_309 VGND VGND VPWR VPWR sky130_fd_sc_hd__decap_6
XFILLER_55_350 VGND VGND VPWR VPWR sky130_fd_sc_hd__fill_1
XFILLER_55_372 VGND VGND VPWR VPWR sky130_fd_sc_hd__decap_6
XFILLER_130_41 VPWR VGND VPWR VGND sky130_ef_sc_hd__decap_12
XFILLER_15_247 VGND VGND VPWR VPWR sky130_fd_sc_hd__decap_6
XFILLER_130_85 VPWR VGND VPWR VGND sky130_ef_sc_hd__decap_12
X_11602_ clknet_leaf_19_clk _01433_ VGND VGND VPWR VPWR picorv32_core.cpuregs\[23\]\[15\]
+ sky130_fd_sc_hd__dfxtp_1
XFILLER_70_386 VGND VGND VPWR VPWR sky130_fd_sc_hd__decap_6
XFILLER_24_781 VPWR VGND VPWR VGND sky130_ef_sc_hd__decap_12
XFILLER_129_617 VGND VGND VPWR VPWR sky130_fd_sc_hd__decap_3
XTAP_TAPCELL_ROW_100_1749 VGND VPWR sky130_fd_sc_hd__tapvpwrvgnd_1
X_11533_ clknet_leaf_9_clk _01364_ VGND VGND VPWR VPWR picorv32_core.cpuregs\[30\]\[14\]
+ sky130_fd_sc_hd__dfxtp_1
XFILLER_137_650 VGND VGND VPWR VPWR sky130_fd_sc_hd__fill_1
X_11464_ clknet_leaf_16_clk _01300_ VGND VGND VPWR VPWR picorv32_core.cpuregs\[24\]\[15\]
+ sky130_fd_sc_hd__dfxtp_1
XTAP_TAPCELL_ROW_133_2237 VGND VPWR sky130_fd_sc_hd__tapvpwrvgnd_1
X_10415_ clknet_leaf_125_clk _01577_ VGND VGND VPWR VPWR picorv32_core.reg_out\[8\]
+ sky130_fd_sc_hd__dfxtp_1
X_11395_ clknet_leaf_2_clk _01231_ VGND VGND VPWR VPWR picorv32_core.cpuregs\[31\]\[10\]
+ sky130_fd_sc_hd__dfxtp_1
XTAP_TAPCELL_ROW_115_1970 VGND VPWR sky130_fd_sc_hd__tapvpwrvgnd_1
X_10346_ clknet_leaf_104_clk _00265_ VGND VGND VPWR VPWR picorv32_core.count_cycle\[4\]
+ sky130_fd_sc_hd__dfxtp_1
X_10277_ clknet_leaf_74_clk _00196_ VGND VGND VPWR VPWR picorv32_core.count_instr\[61\]
+ sky130_fd_sc_hd__dfxtp_1
XFILLER_2_195 VGND VGND VPWR VPWR sky130_fd_sc_hd__fill_1
XFILLER_17_6 VPWR VGND VPWR VGND sky130_ef_sc_hd__decap_12
XFILLER_73_180 VGND VGND VPWR VPWR sky130_fd_sc_hd__decap_3
XFILLER_46_394 VGND VGND VPWR VPWR sky130_fd_sc_hd__decap_8
XFILLER_64_90 VGND VGND VPWR VPWR sky130_fd_sc_hd__fill_1
XFILLER_22_718 VPWR VGND VPWR VGND sky130_ef_sc_hd__decap_12
XFILLER_9_30 VPWR VGND VPWR VGND sky130_ef_sc_hd__decap_12
XFILLER_34_589 VGND VGND VPWR VPWR sky130_fd_sc_hd__fill_1
X_06370_ net1765 net229 net436 VGND VGND VPWR VPWR _00064_ sky130_fd_sc_hd__mux2_1
X_05321_ picorv32_core.reg_pc\[8\] picorv32_core.decoded_imm\[8\] VGND VGND VPWR VPWR
+ _01829_ sky130_fd_sc_hd__or2_1
XTAP_TAPCELL_ROW_32_768 VGND VPWR sky130_fd_sc_hd__tapvpwrvgnd_1
X_08040_ picorv32_core.cpuregs\[12\]\[29\] picorv32_core.cpuregs\[13\]\[29\] picorv32_core.cpuregs\[14\]\[29\]
+ picorv32_core.cpuregs\[15\]\[29\] net762 net729 VGND VGND VPWR VPWR _04116_ sky130_fd_sc_hd__mux4_1
XTAP_TAPCELL_ROW_12_481 VGND VPWR sky130_fd_sc_hd__tapvpwrvgnd_1
X_05252_ picorv32_core.reg_pc\[4\] picorv32_core.decoded_imm\[4\] VGND VGND VPWR VPWR
+ _01764_ sky130_fd_sc_hd__nand2_1
XTAP_TAPCELL_ROW_77_1420 VGND VPWR sky130_fd_sc_hd__tapvpwrvgnd_1
Xhold903 picorv32_core.cpuregs\[11\]\[4\] VGND VGND VPWR VPWR net2012 sky130_fd_sc_hd__dlygate4sd3_1
Xhold925 picorv32_core.cpuregs\[30\]\[23\] VGND VGND VPWR VPWR net2034 sky130_fd_sc_hd__dlygate4sd3_1
X_05183_ _01591_ _01689_ VGND VGND VPWR VPWR _01705_ sky130_fd_sc_hd__nor2_2
Xhold936 picorv32_core.cpuregs\[8\]\[9\] VGND VGND VPWR VPWR net2045 sky130_fd_sc_hd__dlygate4sd3_1
Xhold914 picorv32_core.cpuregs\[12\]\[10\] VGND VGND VPWR VPWR net2023 sky130_fd_sc_hd__dlygate4sd3_1
Xhold958 picorv32_core.cpuregs\[17\]\[27\] VGND VGND VPWR VPWR net2067 sky130_fd_sc_hd__dlygate4sd3_1
Xhold947 picorv32_core.cpuregs\[17\]\[24\] VGND VGND VPWR VPWR net2056 sky130_fd_sc_hd__dlygate4sd3_1
Xhold969 picorv32_core.cpuregs\[1\]\[16\] VGND VGND VPWR VPWR net2078 sky130_fd_sc_hd__dlygate4sd3_1
X_09991_ net1368 net258 net314 VGND VGND VPWR VPWR _01468_ sky130_fd_sc_hd__mux2_1
XFILLER_89_707 VGND VGND VPWR VPWR sky130_fd_sc_hd__fill_2
X_08942_ net241 net2174 net355 VGND VGND VPWR VPWR _01115_ sky130_fd_sc_hd__mux2_1
XFILLER_97_740 VPWR VGND VPWR VGND sky130_ef_sc_hd__decap_12
X_08873_ net251 net1942 net363 VGND VGND VPWR VPWR _01048_ sky130_fd_sc_hd__mux2_1
X_07824_ net634 _03911_ VGND VGND VPWR VPWR _03912_ sky130_fd_sc_hd__or2_1
XFILLER_71_106 VGND VGND VPWR VPWR sky130_fd_sc_hd__decap_6
X_07755_ picorv32_core.cpuregs\[16\]\[13\] picorv32_core.cpuregs\[17\]\[13\] picorv32_core.cpuregs\[18\]\[13\]
+ picorv32_core.cpuregs\[19\]\[13\] net740 net707 VGND VGND VPWR VPWR _03847_ sky130_fd_sc_hd__mux4_1
XFILLER_37_350 VGND VGND VPWR VPWR sky130_fd_sc_hd__fill_1
X_06706_ picorv32_core.reg_pc\[30\] net553 _02942_ net517 VGND VGND VPWR VPWR _00228_
+ sky130_fd_sc_hd__a22o_1
XTAP_TAPCELL_ROW_88_1582 VGND VPWR sky130_fd_sc_hd__tapvpwrvgnd_1
X_07686_ _03771_ _03772_ net627 VGND VGND VPWR VPWR _03782_ sky130_fd_sc_hd__mux2_1
X_06637_ net2305 _02904_ net997 VGND VGND VPWR VPWR _02906_ sky130_fd_sc_hd__o21ai_1
X_09425_ net802 _03388_ VGND VGND VPWR VPWR _04613_ sky130_fd_sc_hd__or2_1
XFILLER_52_353 VGND VGND VPWR VPWR sky130_fd_sc_hd__decap_8
XFILLER_13_707 VGND VGND VPWR VPWR sky130_fd_sc_hd__fill_2
XFILLER_44_27 VGND VGND VPWR VPWR sky130_fd_sc_hd__fill_1
XFILLER_12_206 VGND VGND VPWR VPWR sky130_fd_sc_hd__decap_3
XFILLER_13_729 VPWR VGND VPWR VGND sky130_ef_sc_hd__decap_12
XFILLER_25_589 VGND VGND VPWR VPWR sky130_fd_sc_hd__decap_6
XFILLER_100_33 VGND VGND VPWR VPWR sky130_fd_sc_hd__fill_1
XFILLER_52_397 VGND VGND VPWR VPWR sky130_fd_sc_hd__decap_4
X_06568_ net2345 _02859_ _02861_ VGND VGND VPWR VPWR _00171_ sky130_fd_sc_hd__o21a_1
X_09356_ net814 net797 _03388_ VGND VGND VPWR VPWR _04547_ sky130_fd_sc_hd__mux2_1
X_05519_ net945 picorv32_core.count_cycle\[54\] net603 _02012_ VGND VGND VPWR VPWR
+ _02013_ sky130_fd_sc_hd__a211o_1
X_06499_ picorv32_core.count_instr\[11\] _02815_ _02817_ VGND VGND VPWR VPWR _00146_
+ sky130_fd_sc_hd__o21a_1
X_08307_ _00745_ _00746_ VGND VGND VPWR VPWR _04229_ sky130_fd_sc_hd__nor2_1
X_09287_ _03470_ _03472_ VGND VGND VPWR VPWR _04481_ sky130_fd_sc_hd__or2_1
X_08238_ picorv32_core.mem_rdata_q\[0\] picorv32_core.mem_rdata_q\[1\] picorv32_core.mem_rdata_q\[2\]
+ picorv32_core.mem_rdata_q\[3\] VGND VGND VPWR VPWR _04222_ sky130_fd_sc_hd__and4_1
XFILLER_109_31 VGND VGND VPWR VPWR sky130_fd_sc_hd__fill_1
XFILLER_107_801 VPWR VGND VPWR VGND sky130_ef_sc_hd__decap_12
X_10200_ clknet_leaf_19_clk _00119_ VGND VGND VPWR VPWR picorv32_core.cpuregs\[9\]\[16\]
+ sky130_fd_sc_hd__dfxtp_1
X_08169_ _00745_ _00746_ VGND VGND VPWR VPWR _04190_ sky130_fd_sc_hd__and2b_1
XFILLER_109_86 VGND VGND VPWR VPWR sky130_fd_sc_hd__fill_1
XFILLER_69_57 VGND VGND VPWR VPWR sky130_fd_sc_hd__decap_4
X_11180_ clknet_leaf_135_clk _01031_ VGND VGND VPWR VPWR picorv32_core.cpuregs\[6\]\[2\]
+ sky130_fd_sc_hd__dfxtp_1
XFILLER_106_377 VGND VGND VPWR VPWR sky130_fd_sc_hd__fill_2
X_10131_ clknet_leaf_7_clk _00053_ VGND VGND VPWR VPWR picorv32_core.cpuregs\[22\]\[14\]
+ sky130_fd_sc_hd__dfxtp_1
XFILLER_0_611 VGND VGND VPWR VPWR sky130_fd_sc_hd__fill_1
X_10062_ net1561 net236 net306 VGND VGND VPWR VPWR _01537_ sky130_fd_sc_hd__mux2_1
XFILLER_0_699 VGND VGND VPWR VPWR sky130_fd_sc_hd__fill_1
XFILLER_102_583 VGND VGND VPWR VPWR sky130_fd_sc_hd__decap_4
XFILLER_28_350 VGND VGND VPWR VPWR sky130_fd_sc_hd__decap_4
XFILLER_18_83 VGND VGND VPWR VPWR sky130_fd_sc_hd__fill_1
XFILLER_28_394 VGND VGND VPWR VPWR sky130_fd_sc_hd__fill_1
X_10964_ clknet_leaf_1_clk _00815_ VGND VGND VPWR VPWR picorv32_core.cpuregs\[13\]\[10\]
+ sky130_fd_sc_hd__dfxtp_1
X_10895_ clknet_leaf_99_clk _00746_ VGND VGND VPWR VPWR picorv32_core.mem_rdata_q\[5\]
+ sky130_fd_sc_hd__dfxtp_1
XFILLER_16_589 VGND VGND VPWR VPWR sky130_fd_sc_hd__decap_4
XFILLER_31_548 VGND VGND VPWR VPWR sky130_fd_sc_hd__decap_4
XFILLER_129_458 VGND VGND VPWR VPWR sky130_fd_sc_hd__fill_1
XFILLER_8_744 VPWR VGND VPWR VGND sky130_ef_sc_hd__decap_12
X_11516_ clknet_leaf_112_clk _00022_ VGND VGND VPWR VPWR _00002_ sky130_fd_sc_hd__dfxtp_2
XFILLER_7_254 VGND VGND VPWR VPWR sky130_fd_sc_hd__decap_4
X_11447_ clknet_leaf_64_clk _01283_ VGND VGND VPWR VPWR picorv32_core.cpuregs\[1\]\[30\]
+ sky130_fd_sc_hd__dfxtp_1
X_11378_ clknet_leaf_65_clk _01219_ VGND VGND VPWR VPWR picorv32_core.cpuregs\[18\]\[30\]
+ sky130_fd_sc_hd__dfxtp_1
XFILLER_125_653 VGND VGND VPWR VPWR sky130_fd_sc_hd__decap_3
XFILLER_98_515 VGND VGND VPWR VPWR sky130_fd_sc_hd__fill_2
XTAP_TAPCELL_ROW_59_1161 VGND VPWR sky130_fd_sc_hd__tapvpwrvgnd_1
X_10329_ clknet_leaf_85_clk _00248_ VGND VGND VPWR VPWR picorv32_core.reg_next_pc\[19\]
+ sky130_fd_sc_hd__dfxtp_1
XTAP_TAPCELL_ROW_72_1350 VGND VPWR sky130_fd_sc_hd__tapvpwrvgnd_1
XFILLER_94_721 VGND VGND VPWR VPWR sky130_fd_sc_hd__fill_1
XFILLER_78_250 VGND VGND VPWR VPWR sky130_fd_sc_hd__fill_2
XFILLER_39_615 VGND VGND VPWR VPWR sky130_fd_sc_hd__fill_1
XFILLER_39_626 VGND VGND VPWR VPWR sky130_fd_sc_hd__fill_2
X_05870_ _02343_ _02344_ VGND VGND VPWR VPWR _02345_ sky130_fd_sc_hd__nand2b_1
XFILLER_81_404 VGND VGND VPWR VPWR sky130_fd_sc_hd__fill_1
XFILLER_26_309 VGND VGND VPWR VPWR sky130_fd_sc_hd__fill_2
XFILLER_35_821 VGND VGND VPWR VPWR sky130_fd_sc_hd__decap_6
XTAP_TAPCELL_ROW_37_838 VGND VPWR sky130_fd_sc_hd__tapvpwrvgnd_1
X_07540_ _01680_ _01694_ picorv32_core.cpu_state\[2\] VGND VGND VPWR VPWR _03648_
+ sky130_fd_sc_hd__o21ai_1
XFILLER_50_813 VGND VGND VPWR VPWR sky130_fd_sc_hd__fill_1
X_07471_ net802 _03601_ net532 VGND VGND VPWR VPWR _03602_ sky130_fd_sc_hd__mux2_1
XTAP_TAPCELL_ROW_17_551 VGND VPWR sky130_fd_sc_hd__tapvpwrvgnd_1
X_06422_ net252 net2115 net424 VGND VGND VPWR VPWR _00090_ sky130_fd_sc_hd__mux2_1
X_09210_ picorv32_core.cpuregs\[8\]\[2\] picorv32_core.cpuregs\[9\]\[2\] picorv32_core.cpuregs\[10\]\[2\]
+ picorv32_core.cpuregs\[11\]\[2\] net876 net843 VGND VGND VPWR VPWR _04407_ sky130_fd_sc_hd__mux4_1
X_09141_ net1316 net242 net330 VGND VGND VPWR VPWR _01307_ sky130_fd_sc_hd__mux2_1
X_06353_ _02753_ _02756_ net564 VGND VGND VPWR VPWR _02757_ sky130_fd_sc_hd__mux2_2
X_09072_ net1300 net253 net338 VGND VGND VPWR VPWR _01240_ sky130_fd_sc_hd__mux2_1
X_05304_ net19 _01717_ _01722_ net33 _01812_ VGND VGND VPWR VPWR _01813_ sky130_fd_sc_hd__a221o_1
X_08023_ picorv32_core.cpuregs\[8\]\[28\] picorv32_core.cpuregs\[9\]\[28\] picorv32_core.cpuregs\[10\]\[28\]
+ picorv32_core.cpuregs\[11\]\[28\] net754 net721 VGND VGND VPWR VPWR _04100_ sky130_fd_sc_hd__mux4_1
X_06284_ picorv32_core.reg_pc\[9\] picorv32_core.reg_pc\[8\] _02693_ VGND VGND VPWR
+ VPWR _02701_ sky130_fd_sc_hd__and3_1
XFILLER_30_29 VGND VGND VPWR VPWR sky130_fd_sc_hd__decap_8
Xhold700 picorv32_core.cpuregs\[26\]\[26\] VGND VGND VPWR VPWR net1809 sky130_fd_sc_hd__dlygate4sd3_1
Xhold711 picorv32_core.cpuregs\[17\]\[5\] VGND VGND VPWR VPWR net1820 sky130_fd_sc_hd__dlygate4sd3_1
X_05235_ picorv32_core.count_instr\[34\] net935 net602 _01748_ VGND VGND VPWR VPWR
+ _01749_ sky130_fd_sc_hd__a211o_1
Xhold755 picorv32_core.cpuregs\[18\]\[2\] VGND VGND VPWR VPWR net1864 sky130_fd_sc_hd__dlygate4sd3_1
X_05166_ net914 _01689_ VGND VGND VPWR VPWR _01691_ sky130_fd_sc_hd__nand2_1
Xhold744 picorv32_core.cpuregs\[17\]\[9\] VGND VGND VPWR VPWR net1853 sky130_fd_sc_hd__dlygate4sd3_1
Xhold722 picorv32_core.cpuregs\[7\]\[8\] VGND VGND VPWR VPWR net1831 sky130_fd_sc_hd__dlygate4sd3_1
Xhold733 picorv32_core.cpuregs\[11\]\[10\] VGND VGND VPWR VPWR net1842 sky130_fd_sc_hd__dlygate4sd3_1
Xhold777 picorv32_core.cpuregs\[3\]\[30\] VGND VGND VPWR VPWR net1886 sky130_fd_sc_hd__dlygate4sd3_1
XFILLER_116_697 VGND VGND VPWR VPWR sky130_fd_sc_hd__decap_3
XFILLER_89_548 VGND VGND VPWR VPWR sky130_fd_sc_hd__fill_1
Xhold766 picorv32_core.cpuregs\[10\]\[16\] VGND VGND VPWR VPWR net1875 sky130_fd_sc_hd__dlygate4sd3_1
Xhold788 picorv32_core.cpuregs\[10\]\[0\] VGND VGND VPWR VPWR net1897 sky130_fd_sc_hd__dlygate4sd3_1
Xhold799 picorv32_core.cpuregs\[3\]\[24\] VGND VGND VPWR VPWR net1908 sky130_fd_sc_hd__dlygate4sd3_1
X_09974_ net1465 net500 net313 VGND VGND VPWR VPWR _01451_ sky130_fd_sc_hd__mux2_1
X_05097_ picorv32_core.mem_do_wdata picorv32_core.mem_do_rdata picorv32_core.mem_do_rinst
+ net518 _01628_ VGND VGND VPWR VPWR _01629_ sky130_fd_sc_hd__o311a_1
XFILLER_57_401 VGND VGND VPWR VPWR sky130_fd_sc_hd__decap_8
X_08925_ net448 net2042 net354 VGND VGND VPWR VPWR _01098_ sky130_fd_sc_hd__mux2_1
XFILLER_85_743 VGND VGND VPWR VPWR sky130_fd_sc_hd__decap_6
X_08856_ net496 net1988 net365 VGND VGND VPWR VPWR _01031_ sky130_fd_sc_hd__mux2_1
XFILLER_84_253 VGND VGND VPWR VPWR sky130_fd_sc_hd__fill_1
X_07807_ net696 _03888_ net685 VGND VGND VPWR VPWR _03896_ sky130_fd_sc_hd__o21a_1
XFILLER_29_158 VGND VGND VPWR VPWR sky130_fd_sc_hd__fill_2
XFILLER_29_169 VGND VGND VPWR VPWR sky130_fd_sc_hd__fill_2
X_05999_ _02452_ _02453_ _02450_ VGND VGND VPWR VPWR _02464_ sky130_fd_sc_hd__o21a_1
XFILLER_72_415 VGND VGND VPWR VPWR sky130_fd_sc_hd__decap_4
XFILLER_57_489 VGND VGND VPWR VPWR sky130_fd_sc_hd__fill_2
X_08787_ net503 net1959 net370 VGND VGND VPWR VPWR _00965_ sky130_fd_sc_hd__mux2_1
X_07738_ picorv32_core.cpuregs\[8\]\[12\] picorv32_core.cpuregs\[9\]\[12\] picorv32_core.cpuregs\[10\]\[12\]
+ picorv32_core.cpuregs\[11\]\[12\] net737 net704 VGND VGND VPWR VPWR _03831_ sky130_fd_sc_hd__mux4_1
XFILLER_53_673 VGND VGND VPWR VPWR sky130_fd_sc_hd__decap_4
X_07669_ _03764_ _03765_ net457 _03762_ VGND VGND VPWR VPWR _03766_ sky130_fd_sc_hd__o211a_1
XPHY_EDGE_ROW_9_Left_151 VGND VGND VPWR VPWR sky130_fd_sc_hd__decap_3
XFILLER_13_526 VGND VGND VPWR VPWR sky130_fd_sc_hd__fill_2
X_10680_ clknet_leaf_94_clk _00533_ VGND VGND VPWR VPWR picorv32_core.is_slli_srli_srai
+ sky130_fd_sc_hd__dfxtp_2
X_09408_ picorv32_core.cpuregs\[24\]\[10\] picorv32_core.cpuregs\[25\]\[10\] picorv32_core.cpuregs\[26\]\[10\]
+ picorv32_core.cpuregs\[27\]\[10\] net883 net850 VGND VGND VPWR VPWR _04597_ sky130_fd_sc_hd__mux4_1
X_09339_ picorv32_core.cpuregs\[28\]\[7\] picorv32_core.cpuregs\[29\]\[7\] picorv32_core.cpuregs\[30\]\[7\]
+ picorv32_core.cpuregs\[31\]\[7\] net876 net843 VGND VGND VPWR VPWR _04531_ sky130_fd_sc_hd__mux4_1
XTAP_TAPCELL_ROW_117_2007 VGND VPWR sky130_fd_sc_hd__tapvpwrvgnd_1
XPHY_EDGE_ROW_109_Right_109 VGND VGND VPWR VPWR sky130_fd_sc_hd__decap_3
X_11301_ clknet_leaf_35_clk _01149_ VGND VGND VPWR VPWR picorv32_core.cpuregs\[3\]\[24\]
+ sky130_fd_sc_hd__dfxtp_1
XFILLER_106_141 VGND VGND VPWR VPWR sky130_fd_sc_hd__decap_3
X_11232_ clknet_leaf_30_clk _01083_ VGND VGND VPWR VPWR picorv32_core.cpuregs\[5\]\[22\]
+ sky130_fd_sc_hd__dfxtp_1
X_11163_ clknet_leaf_27_clk _01014_ VGND VGND VPWR VPWR picorv32_core.cpuregs\[7\]\[17\]
+ sky130_fd_sc_hd__dfxtp_1
X_10114_ net1137 VGND VGND VPWR VPWR _00964_ sky130_fd_sc_hd__clkbuf_1
XFILLER_88_570 VGND VGND VPWR VPWR sky130_fd_sc_hd__fill_1
X_11094_ clknet_leaf_7_clk _00945_ VGND VGND VPWR VPWR picorv32_core.cpuregs\[0\]\[12\]
+ sky130_fd_sc_hd__dfxtp_1
XTAP_TAPCELL_ROW_128_2158 VGND VPWR sky130_fd_sc_hd__tapvpwrvgnd_1
XTAP_TAPCELL_ROW_54_1091 VGND VPWR sky130_fd_sc_hd__tapvpwrvgnd_1
X_10045_ net1294 net445 net304 VGND VGND VPWR VPWR _01520_ sky130_fd_sc_hd__mux2_1
Xhold82 net118 VGND VGND VPWR VPWR net1191 sky130_fd_sc_hd__dlygate4sd3_1
XFILLER_76_787 VGND VGND VPWR VPWR sky130_fd_sc_hd__fill_2
Xhold71 net108 VGND VGND VPWR VPWR net1180 sky130_fd_sc_hd__dlygate4sd3_1
Xhold60 net126 VGND VGND VPWR VPWR net1169 sky130_fd_sc_hd__dlygate4sd3_1
XFILLER_36_618 VGND VGND VPWR VPWR sky130_fd_sc_hd__fill_1
XFILLER_91_735 VGND VGND VPWR VPWR sky130_fd_sc_hd__decap_4
Xhold93 picorv32_core.cpuregs\[7\]\[3\] VGND VGND VPWR VPWR net1202 sky130_fd_sc_hd__dlygate4sd3_1
XFILLER_29_670 VGND VGND VPWR VPWR sky130_fd_sc_hd__fill_2
XTAP_TAPCELL_ROW_141_2369 VGND VPWR sky130_fd_sc_hd__tapvpwrvgnd_1
XTAP_TAPCELL_ROW_141_2358 VGND VPWR sky130_fd_sc_hd__tapvpwrvgnd_1
XTAP_TAPCELL_ROW_141_2347 VGND VPWR sky130_fd_sc_hd__tapvpwrvgnd_1
XFILLER_90_234 VGND VGND VPWR VPWR sky130_fd_sc_hd__fill_2
X_10947_ clknet_leaf_66_clk _00798_ VGND VGND VPWR VPWR picorv32_core.cpuregs\[19\]\[25\]
+ sky130_fd_sc_hd__dfxtp_1
XFILLER_71_492 VGND VGND VPWR VPWR sky130_fd_sc_hd__fill_2
XTAP_TAPCELL_ROW_14_510 VGND VPWR sky130_fd_sc_hd__tapvpwrvgnd_1
X_10878_ clknet_leaf_34_clk _00729_ VGND VGND VPWR VPWR picorv32_core.cpuregs\[16\]\[22\]
+ sky130_fd_sc_hd__dfxtp_1
XFILLER_129_222 VGND VGND VPWR VPWR sky130_fd_sc_hd__fill_2
Xclkbuf_4_14_0_clk clknet_0_clk VGND VGND VPWR VPWR clknet_4_14_0_clk sky130_fd_sc_hd__clkbuf_8
XANTENNA_2 _00009_ VGND VGND VPWR VPWR sky130_fd_sc_hd__diode_2
XFILLER_6_53 VPWR VGND VPWR VGND sky130_ef_sc_hd__decap_12
XFILLER_6_97 VPWR VGND VPWR VGND sky130_ef_sc_hd__decap_12
Xfanout509 _02253_ VGND VGND VPWR VPWR net509 sky130_fd_sc_hd__buf_2
XFILLER_112_177 VGND VGND VPWR VPWR sky130_fd_sc_hd__decap_3
XFILLER_98_389 VGND VGND VPWR VPWR sky130_fd_sc_hd__decap_6
X_06971_ _02933_ _02934_ _03157_ VGND VGND VPWR VPWR _03185_ sky130_fd_sc_hd__and3_1
X_08710_ net1338 net242 net384 VGND VGND VPWR VPWR _00859_ sky130_fd_sc_hd__mux2_1
X_09690_ _03518_ _03519_ VGND VGND VPWR VPWR _04866_ sky130_fd_sc_hd__xnor2_1
X_05922_ _02391_ _02392_ VGND VGND VPWR VPWR _02393_ sky130_fd_sc_hd__nand2b_1
X_08641_ net1573 net251 net392 VGND VGND VPWR VPWR _00792_ sky130_fd_sc_hd__mux2_1
X_05853_ _02322_ _02324_ _02321_ VGND VGND VPWR VPWR _02329_ sky130_fd_sc_hd__a21oi_1
XFILLER_94_573 VPWR VGND VPWR VGND sky130_ef_sc_hd__decap_12
XFILLER_54_437 VGND VGND VPWR VPWR sky130_fd_sc_hd__fill_1
X_08572_ net239 net1916 net401 VGND VGND VPWR VPWR _00697_ sky130_fd_sc_hd__mux2_1
XTAP_TAPCELL_ROW_85_1541 VGND VPWR sky130_fd_sc_hd__tapvpwrvgnd_1
X_05784_ net967 _02265_ VGND VGND VPWR VPWR _02266_ sky130_fd_sc_hd__xnor2_1
X_07523_ net2326 _03636_ net463 VGND VGND VPWR VPWR _00351_ sky130_fd_sc_hd__mux2_1
XFILLER_34_150 VGND VGND VPWR VPWR sky130_fd_sc_hd__fill_1
X_07454_ net1945 _03590_ net460 VGND VGND VPWR VPWR _00328_ sky130_fd_sc_hd__mux2_1
X_06405_ net497 net1827 net422 VGND VGND VPWR VPWR _00073_ sky130_fd_sc_hd__mux2_1
X_07385_ _03412_ _03413_ _03521_ _03524_ VGND VGND VPWR VPWR _03525_ sky130_fd_sc_hd__o211a_1
X_06336_ _02741_ _02742_ VGND VGND VPWR VPWR _02743_ sky130_fd_sc_hd__nor2_1
X_09124_ net1531 net450 net328 VGND VGND VPWR VPWR _01290_ sky130_fd_sc_hd__mux2_1
XFILLER_136_737 VPWR VGND VPWR VGND sky130_ef_sc_hd__decap_12
XFILLER_135_225 VGND VGND VPWR VPWR sky130_fd_sc_hd__fill_2
X_06267_ net1498 net449 net433 VGND VGND VPWR VPWR _00044_ sky130_fd_sc_hd__mux2_1
X_09055_ net1383 net497 net336 VGND VGND VPWR VPWR _01223_ sky130_fd_sc_hd__mux2_1
X_08006_ picorv32_core.cpuregs\[16\]\[27\] picorv32_core.cpuregs\[17\]\[27\] picorv32_core.cpuregs\[18\]\[27\]
+ picorv32_core.cpuregs\[19\]\[27\] net756 net723 VGND VGND VPWR VPWR _04084_ sky130_fd_sc_hd__mux4_1
Xhold530 picorv32_core.cpuregs\[17\]\[14\] VGND VGND VPWR VPWR net1639 sky130_fd_sc_hd__dlygate4sd3_1
X_05218_ picorv32_core.count_instr\[33\] net935 net943 picorv32_core.count_cycle\[33\]
+ VGND VGND VPWR VPWR _01733_ sky130_fd_sc_hd__a22o_1
Xhold552 picorv32_core.cpuregs\[24\]\[26\] VGND VGND VPWR VPWR net1661 sky130_fd_sc_hd__dlygate4sd3_1
Xhold563 picorv32_core.cpuregs\[17\]\[16\] VGND VGND VPWR VPWR net1672 sky130_fd_sc_hd__dlygate4sd3_1
XTAP_TAPCELL_ROW_96_1692 VGND VPWR sky130_fd_sc_hd__tapvpwrvgnd_1
Xhold541 picorv32_core.cpuregs\[22\]\[15\] VGND VGND VPWR VPWR net1650 sky130_fd_sc_hd__dlygate4sd3_1
X_06198_ picorv32_core.cpuregs\[12\]\[3\] picorv32_core.cpuregs\[13\]\[3\] picorv32_core.cpuregs\[14\]\[3\]
+ picorv32_core.cpuregs\[15\]\[3\] net742 net709 VGND VGND VPWR VPWR _02629_ sky130_fd_sc_hd__mux4_1
XFILLER_1_205 VPWR VGND VPWR VGND sky130_ef_sc_hd__decap_12
Xhold574 picorv32_core.cpuregs\[5\]\[29\] VGND VGND VPWR VPWR net1683 sky130_fd_sc_hd__dlygate4sd3_1
Xhold596 picorv32_core.cpuregs\[29\]\[24\] VGND VGND VPWR VPWR net1705 sky130_fd_sc_hd__dlygate4sd3_1
Xhold585 picorv32_core.cpuregs\[12\]\[19\] VGND VGND VPWR VPWR net1694 sky130_fd_sc_hd__dlygate4sd3_1
XFILLER_1_249 VPWR VGND VPWR VGND sky130_ef_sc_hd__decap_12
X_05149_ picorv32_core.is_lb_lh_lw_lbu_lhu _01663_ VGND VGND VPWR VPWR _01677_ sky130_fd_sc_hd__and2_1
X_09957_ net1738 net260 net316 VGND VGND VPWR VPWR _01435_ sky130_fd_sc_hd__mux2_1
X_08908_ net244 net1699 net360 VGND VGND VPWR VPWR _01082_ sky130_fd_sc_hd__mux2_1
X_09888_ net1783 net225 net327 VGND VGND VPWR VPWR _01376_ sky130_fd_sc_hd__mux2_1
Xhold1241 picorv32_core.count_instr\[62\] VGND VGND VPWR VPWR net2350 sky130_fd_sc_hd__dlygate4sd3_1
Xhold1230 picorv32_core.reg_pc\[26\] VGND VGND VPWR VPWR net2339 sky130_fd_sc_hd__dlygate4sd3_1
XFILLER_58_754 VGND VGND VPWR VPWR sky130_fd_sc_hd__fill_2
Xhold1252 picorv32_core.decoded_imm\[7\] VGND VGND VPWR VPWR net2361 sky130_fd_sc_hd__dlygate4sd3_1
X_08839_ net2005 net257 net367 VGND VGND VPWR VPWR _01015_ sky130_fd_sc_hd__mux2_1
X_11850_ net53 VGND VGND VPWR VPWR net85 sky130_fd_sc_hd__clkbuf_1
XFILLER_57_297 VGND VGND VPWR VPWR sky130_fd_sc_hd__fill_1
XTAP_TAPCELL_ROW_123_2088 VGND VPWR sky130_fd_sc_hd__tapvpwrvgnd_1
XFILLER_14_813 VPWR VGND VPWR VGND sky130_ef_sc_hd__decap_12
X_10801_ clknet_leaf_1_clk _00652_ VGND VGND VPWR VPWR picorv32_core.cpuregs\[15\]\[10\]
+ sky130_fd_sc_hd__dfxtp_1
X_10732_ clknet_leaf_89_clk _00583_ VGND VGND VPWR VPWR picorv32_core.decoded_imm\[27\]
+ sky130_fd_sc_hd__dfxtp_2
XTAP_TAPCELL_ROW_0_293 VGND VPWR sky130_fd_sc_hd__tapvpwrvgnd_1
XFILLER_13_312 VGND VGND VPWR VPWR sky130_fd_sc_hd__fill_2
XFILLER_9_316 VGND VGND VPWR VPWR sky130_fd_sc_hd__decap_3
X_10663_ clknet_leaf_67_clk _00517_ VGND VGND VPWR VPWR picorv32_core.cpuregs\[20\]\[31\]
+ sky130_fd_sc_hd__dfxtp_1
X_10594_ clknet_leaf_92_clk _00448_ VGND VGND VPWR VPWR picorv32_core.instr_ori sky130_fd_sc_hd__dfxtp_1
XFILLER_126_269 VGND VGND VPWR VPWR sky130_fd_sc_hd__fill_1
XTAP_TAPCELL_ROW_56_1120 VGND VPWR sky130_fd_sc_hd__tapvpwrvgnd_1
XFILLER_5_577 VGND VGND VPWR VPWR sky130_fd_sc_hd__fill_1
Xoutput50 net50 VGND VGND VPWR VPWR mem_axi_araddr[21] sky130_fd_sc_hd__buf_2
Xoutput61 net61 VGND VGND VPWR VPWR mem_axi_araddr[31] sky130_fd_sc_hd__buf_2
X_11215_ clknet_leaf_137_clk _01066_ VGND VGND VPWR VPWR picorv32_core.cpuregs\[5\]\[5\]
+ sky130_fd_sc_hd__dfxtp_1
Xoutput83 net83 VGND VGND VPWR VPWR mem_axi_awaddr[22] sky130_fd_sc_hd__buf_2
XFILLER_68_518 VPWR VGND VPWR VGND sky130_ef_sc_hd__decap_12
XFILLER_68_507 VGND VGND VPWR VPWR sky130_fd_sc_hd__decap_8
Xoutput72 net72 VGND VGND VPWR VPWR mem_axi_awaddr[11] sky130_fd_sc_hd__buf_2
Xoutput94 net94 VGND VGND VPWR VPWR mem_axi_awaddr[3] sky130_fd_sc_hd__buf_2
X_11146_ clknet_leaf_119_clk _00997_ VGND VGND VPWR VPWR picorv32_core.cpuregs\[7\]\[0\]
+ sky130_fd_sc_hd__dfxtp_1
X_11077_ clknet_leaf_42_clk _00928_ VGND VGND VPWR VPWR picorv32_core.cpuregs\[10\]\[27\]
+ sky130_fd_sc_hd__dfxtp_1
XFILLER_1_783 VGND VGND VPWR VPWR sky130_fd_sc_hd__fill_1
X_10028_ net1367 net243 net310 VGND VGND VPWR VPWR _01504_ sky130_fd_sc_hd__mux2_1
XFILLER_48_253 VGND VGND VPWR VPWR sky130_fd_sc_hd__fill_1
XFILLER_64_735 VPWR VGND VPWR VGND sky130_ef_sc_hd__decap_12
XFILLER_51_418 VGND VGND VPWR VPWR sky130_fd_sc_hd__decap_3
XTAP_TAPCELL_ROW_47_988 VGND VPWR sky130_fd_sc_hd__tapvpwrvgnd_1
XTAP_TAPCELL_ROW_67_1282 VGND VPWR sky130_fd_sc_hd__tapvpwrvgnd_1
XTAP_TAPCELL_ROW_67_1271 VGND VPWR sky130_fd_sc_hd__tapvpwrvgnd_1
XFILLER_44_470 VGND VGND VPWR VPWR sky130_fd_sc_hd__decap_6
XTAP_TAPCELL_ROW_27_690 VGND VPWR sky130_fd_sc_hd__tapvpwrvgnd_1
XTAP_TAPCELL_ROW_80_1471 VGND VPWR sky130_fd_sc_hd__tapvpwrvgnd_1
XTAP_TAPCELL_ROW_80_1460 VGND VPWR sky130_fd_sc_hd__tapvpwrvgnd_1
XFILLER_32_698 VGND VGND VPWR VPWR sky130_fd_sc_hd__fill_2
X_07170_ _03338_ net985 _03337_ VGND VGND VPWR VPWR _00296_ sky130_fd_sc_hd__and3b_1
X_06121_ net670 net193 _02567_ VGND VGND VPWR VPWR _02576_ sky130_fd_sc_hd__a21o_1
X_06052_ _02497_ _02502_ _02512_ VGND VGND VPWR VPWR _02513_ sky130_fd_sc_hd__nand3_1
Xclkbuf_leaf_120_clk clknet_4_8_0_clk VGND VGND VPWR VPWR clknet_leaf_120_clk sky130_fd_sc_hd__clkbuf_8
XFILLER_133_729 VPWR VGND VPWR VGND sky130_ef_sc_hd__decap_12
XFILLER_126_781 VPWR VGND VPWR VGND sky130_ef_sc_hd__decap_12
XFILLER_141_762 VGND VGND VPWR VPWR sky130_fd_sc_hd__decap_4
X_09811_ picorv32_core.cpuregs\[24\]\[28\] picorv32_core.cpuregs\[25\]\[28\] picorv32_core.cpuregs\[26\]\[28\]
+ picorv32_core.cpuregs\[27\]\[28\] net894 net860 VGND VGND VPWR VPWR _04982_ sky130_fd_sc_hd__mux4_1
Xfanout339 _04349_ VGND VGND VPWR VPWR net339 sky130_fd_sc_hd__buf_4
XFILLER_98_164 VGND VGND VPWR VPWR sky130_fd_sc_hd__decap_6
Xfanout306 net307 VGND VGND VPWR VPWR net306 sky130_fd_sc_hd__buf_4
Xfanout317 _05039_ VGND VGND VPWR VPWR net317 sky130_fd_sc_hd__buf_4
Xfanout328 net329 VGND VGND VPWR VPWR net328 sky130_fd_sc_hd__buf_4
X_09742_ picorv32_core.cpuregs\[0\]\[25\] picorv32_core.cpuregs\[1\]\[25\] picorv32_core.cpuregs\[2\]\[25\]
+ picorv32_core.cpuregs\[3\]\[25\] net905 net870 VGND VGND VPWR VPWR _04916_ sky130_fd_sc_hd__mux4_1
XFILLER_113_486 VGND VGND VPWR VPWR sky130_fd_sc_hd__decap_8
XFILLER_101_637 VGND VGND VPWR VPWR sky130_fd_sc_hd__fill_1
X_06954_ _03166_ _03167_ _03168_ _03153_ VGND VGND VPWR VPWR _03169_ sky130_fd_sc_hd__o211a_1
XFILLER_39_220 VGND VGND VPWR VPWR sky130_fd_sc_hd__decap_4
X_09673_ picorv32_core.cpuregs\[20\]\[22\] picorv32_core.cpuregs\[21\]\[22\] picorv32_core.cpuregs\[22\]\[22\]
+ picorv32_core.cpuregs\[23\]\[22\] net894 net860 VGND VGND VPWR VPWR _04850_ sky130_fd_sc_hd__mux4_1
X_06885_ _03101_ _03104_ _03105_ net989 VGND VGND VPWR VPWR _00244_ sky130_fd_sc_hd__o31a_1
X_05905_ net797 _02376_ VGND VGND VPWR VPWR _02377_ sky130_fd_sc_hd__nand2_1
X_08624_ net1306 net495 net390 VGND VGND VPWR VPWR _00775_ sky130_fd_sc_hd__mux2_1
XFILLER_27_459 VGND VGND VPWR VPWR sky130_fd_sc_hd__fill_1
X_05836_ _02288_ _02297_ VGND VGND VPWR VPWR _02314_ sky130_fd_sc_hd__nor2_1
X_08555_ net444 net1610 net398 VGND VGND VPWR VPWR _00680_ sky130_fd_sc_hd__mux2_1
XFILLER_42_418 VGND VGND VPWR VPWR sky130_fd_sc_hd__fill_2
X_05767_ net823 picorv32_core.mem_la_wdata\[0\] net607 _02250_ VGND VGND VPWR VPWR
+ _02251_ sky130_fd_sc_hd__o22a_1
X_07506_ picorv32_core.reg_out\[22\] picorv32_core.reg_next_pc\[22\] net561 VGND VGND
+ VPWR VPWR _03625_ sky130_fd_sc_hd__mux2_1
X_05698_ net791 net179 VGND VGND VPWR VPWR _02182_ sky130_fd_sc_hd__nand2_1
XFILLER_52_27 VGND VGND VPWR VPWR sky130_fd_sc_hd__fill_1
X_08486_ net1766 net444 net406 VGND VGND VPWR VPWR _00616_ sky130_fd_sc_hd__mux2_1
XFILLER_23_654 VGND VGND VPWR VPWR sky130_fd_sc_hd__fill_2
X_07437_ picorv32_core.reg_pc\[31\] net538 _03576_ VGND VGND VPWR VPWR _03577_ sky130_fd_sc_hd__a21oi_1
XPHY_EDGE_ROW_99_Left_241 VGND VGND VPWR VPWR sky130_fd_sc_hd__decap_3
XFILLER_50_462 VGND VGND VPWR VPWR sky130_fd_sc_hd__fill_1
XFILLER_10_326 VGND VGND VPWR VPWR sky130_fd_sc_hd__fill_1
XTAP_TAPCELL_ROW_98_1732 VGND VPWR sky130_fd_sc_hd__tapvpwrvgnd_1
XTAP_TAPCELL_ROW_98_1721 VGND VPWR sky130_fd_sc_hd__tapvpwrvgnd_1
X_07368_ net785 picorv32_core.decoded_imm\[18\] VGND VGND VPWR VPWR _03508_ sky130_fd_sc_hd__nor2_1
XFILLER_7_809 VPWR VGND VPWR VGND sky130_ef_sc_hd__decap_12
X_09107_ net245 net1888 net334 VGND VGND VPWR VPWR _01274_ sky130_fd_sc_hd__mux2_1
X_06319_ picorv32_core.reg_out\[16\] picorv32_core.alu_out_q\[16\] net952 VGND VGND
+ VPWR VPWR _02729_ sky130_fd_sc_hd__mux2_1
X_07299_ _03437_ _03438_ VGND VGND VPWR VPWR _03439_ sky130_fd_sc_hd__nand2_1
Xclkbuf_leaf_111_clk clknet_4_10_0_clk VGND VGND VPWR VPWR clknet_leaf_111_clk sky130_fd_sc_hd__clkbuf_8
XFILLER_123_206 VGND VGND VPWR VPWR sky130_fd_sc_hd__fill_2
X_09038_ net257 net2083 net342 VGND VGND VPWR VPWR _01207_ sky130_fd_sc_hd__mux2_1
XFILLER_123_239 VGND VGND VPWR VPWR sky130_fd_sc_hd__fill_2
Xhold371 picorv32_core.cpuregs\[11\]\[29\] VGND VGND VPWR VPWR net1480 sky130_fd_sc_hd__dlygate4sd3_1
Xhold360 picorv32_core.cpuregs\[6\]\[0\] VGND VGND VPWR VPWR net1469 sky130_fd_sc_hd__dlygate4sd3_1
Xhold382 picorv32_core.cpuregs\[21\]\[29\] VGND VGND VPWR VPWR net1491 sky130_fd_sc_hd__dlygate4sd3_1
Xhold393 picorv32_core.cpuregs\[30\]\[30\] VGND VGND VPWR VPWR net1502 sky130_fd_sc_hd__dlygate4sd3_1
X_11000_ clknet_leaf_9_clk _00851_ VGND VGND VPWR VPWR picorv32_core.cpuregs\[12\]\[14\]
+ sky130_fd_sc_hd__dfxtp_1
Xfanout851 net854 VGND VGND VPWR VPWR net851 sky130_fd_sc_hd__clkbuf_4
Xfanout840 net841 VGND VGND VPWR VPWR net840 sky130_fd_sc_hd__clkbuf_4
Xfanout862 net866 VGND VGND VPWR VPWR net862 sky130_fd_sc_hd__clkbuf_4
XFILLER_92_307 VGND VGND VPWR VPWR sky130_fd_sc_hd__fill_1
XTAP_TAPCELL_ROW_51_1050 VGND VPWR sky130_fd_sc_hd__tapvpwrvgnd_1
Xfanout884 net885 VGND VGND VPWR VPWR net884 sky130_fd_sc_hd__buf_4
Xfanout873 net874 VGND VGND VPWR VPWR net873 sky130_fd_sc_hd__buf_4
XTAP_TAPCELL_ROW_125_2117 VGND VPWR sky130_fd_sc_hd__tapvpwrvgnd_1
Xhold1060 picorv32_core.cpuregs\[25\]\[21\] VGND VGND VPWR VPWR net2169 sky130_fd_sc_hd__dlygate4sd3_1
Xfanout895 net896 VGND VGND VPWR VPWR net895 sky130_fd_sc_hd__clkbuf_2
XTAP_TAPCELL_ROW_5_374 VGND VPWR sky130_fd_sc_hd__tapvpwrvgnd_1
Xhold1071 picorv32_core.cpuregs\[21\]\[26\] VGND VGND VPWR VPWR net2180 sky130_fd_sc_hd__dlygate4sd3_1
Xhold1093 picorv32_core.cpuregs\[8\]\[26\] VGND VGND VPWR VPWR net2202 sky130_fd_sc_hd__dlygate4sd3_1
XFILLER_85_381 VGND VGND VPWR VPWR sky130_fd_sc_hd__decap_4
Xhold1082 picorv32_core.cpuregs\[6\]\[4\] VGND VGND VPWR VPWR net2191 sky130_fd_sc_hd__dlygate4sd3_1
XTAP_TAPCELL_ROW_107_1861 VGND VPWR sky130_fd_sc_hd__tapvpwrvgnd_1
XTAP_TAPCELL_ROW_107_1850 VGND VPWR sky130_fd_sc_hd__tapvpwrvgnd_1
XFILLER_93_78 VGND VGND VPWR VPWR sky130_fd_sc_hd__fill_2
XFILLER_61_727 VGND VGND VPWR VPWR sky130_fd_sc_hd__fill_1
X_11833_ net66 VGND VGND VPWR VPWR net98 sky130_fd_sc_hd__clkbuf_1
XFILLER_33_418 VGND VGND VPWR VPWR sky130_fd_sc_hd__decap_6
XFILLER_26_83 VGND VGND VPWR VPWR sky130_fd_sc_hd__fill_1
XTAP_TAPCELL_ROW_44_936 VGND VPWR sky130_fd_sc_hd__tapvpwrvgnd_1
XTAP_TAPCELL_ROW_44_947 VGND VPWR sky130_fd_sc_hd__tapvpwrvgnd_1
XFILLER_14_643 VGND VGND VPWR VPWR sky130_fd_sc_hd__fill_1
X_11695_ clknet_leaf_10_clk _01526_ VGND VGND VPWR VPWR picorv32_core.cpuregs\[27\]\[12\]
+ sky130_fd_sc_hd__dfxtp_1
X_10715_ clknet_leaf_4_clk _00566_ VGND VGND VPWR VPWR net121 sky130_fd_sc_hd__dfxtp_1
XTAP_TAPCELL_ROW_24_660 VGND VPWR sky130_fd_sc_hd__tapvpwrvgnd_1
X_10646_ clknet_leaf_8_clk _00500_ VGND VGND VPWR VPWR picorv32_core.cpuregs\[20\]\[14\]
+ sky130_fd_sc_hd__dfxtp_1
XTAP_TAPCELL_ROW_136_2279 VGND VPWR sky130_fd_sc_hd__tapvpwrvgnd_1
X_10577_ clknet_leaf_98_clk _00431_ VGND VGND VPWR VPWR picorv32_core.instr_auipc
+ sky130_fd_sc_hd__dfxtp_1
Xclkbuf_leaf_102_clk clknet_4_11_0_clk VGND VGND VPWR VPWR clknet_leaf_102_clk sky130_fd_sc_hd__clkbuf_8
XFILLER_96_624 VGND VGND VPWR VPWR sky130_fd_sc_hd__fill_1
XFILLER_110_456 VPWR VGND VPWR VGND sky130_ef_sc_hd__decap_12
X_11129_ clknet_leaf_14_clk _00980_ VGND VGND VPWR VPWR picorv32_core.cpuregs\[8\]\[15\]
+ sky130_fd_sc_hd__dfxtp_1
XFILLER_68_359 VGND VGND VPWR VPWR sky130_fd_sc_hd__decap_4
XFILLER_110_489 VGND VGND VPWR VPWR sky130_fd_sc_hd__fill_2
XTAP_TAPCELL_ROW_69_1311 VGND VPWR sky130_fd_sc_hd__tapvpwrvgnd_1
XTAP_TAPCELL_ROW_69_1300 VGND VPWR sky130_fd_sc_hd__tapvpwrvgnd_1
XFILLER_36_201 VGND VGND VPWR VPWR sky130_fd_sc_hd__fill_1
XFILLER_76_392 VGND VGND VPWR VPWR sky130_fd_sc_hd__fill_1
X_06670_ picorv32_core.reg_pc\[12\] net552 _02924_ net515 VGND VGND VPWR VPWR _00210_
+ sky130_fd_sc_hd__a22o_1
XFILLER_49_595 VGND VGND VPWR VPWR sky130_fd_sc_hd__decap_8
X_05621_ _02105_ _02106_ picorv32_core.cpu_state\[3\] VGND VGND VPWR VPWR _02107_
+ sky130_fd_sc_hd__and3b_1
XFILLER_24_418 VGND VGND VPWR VPWR sky130_fd_sc_hd__fill_2
XTAP_TAPCELL_ROW_82_1500 VGND VPWR sky130_fd_sc_hd__tapvpwrvgnd_1
X_05552_ picorv32_core.reg_pc\[25\] picorv32_core.decoded_imm\[25\] VGND VGND VPWR
+ VPWR _02043_ sky130_fd_sc_hd__nand2_1
X_08340_ net1209 net454 _04242_ VGND VGND VPWR VPWR _00551_ sky130_fd_sc_hd__o21a_1
X_05483_ picorv32_core.reg_pc\[20\] picorv32_core.decoded_imm\[20\] VGND VGND VPWR
+ VPWR _01979_ sky130_fd_sc_hd__nand2_1
XTAP_TAPCELL_ROW_22_619 VGND VPWR sky130_fd_sc_hd__tapvpwrvgnd_1
X_08271_ net1530 net299 net410 VGND VGND VPWR VPWR _00495_ sky130_fd_sc_hd__mux2_1
XFILLER_32_473 VGND VGND VPWR VPWR sky130_fd_sc_hd__decap_3
X_07222_ _03370_ _03371_ VGND VGND VPWR VPWR _00315_ sky130_fd_sc_hd__nor2_1
XFILLER_32_495 VGND VGND VPWR VPWR sky130_fd_sc_hd__decap_8
XFILLER_118_501 VGND VGND VPWR VPWR sky130_fd_sc_hd__decap_3
X_07153_ picorv32_core.count_cycle\[28\] picorv32_core.count_cycle\[29\] _03324_ VGND
+ VGND VPWR VPWR _03328_ sky130_fd_sc_hd__and3_1
X_06104_ net766 net193 net570 VGND VGND VPWR VPWR _02560_ sky130_fd_sc_hd__and3_1
X_07084_ net2281 _03283_ net983 VGND VGND VPWR VPWR _03285_ sky130_fd_sc_hd__o21ai_1
X_06035_ net777 _02496_ VGND VGND VPWR VPWR _02497_ sky130_fd_sc_hd__nand2_1
XTAP_TAPCELL_ROW_93_1651 VGND VPWR sky130_fd_sc_hd__tapvpwrvgnd_1
XFILLER_114_751 VGND VGND VPWR VPWR sky130_fd_sc_hd__decap_4
X_07986_ picorv32_core.cpuregs\[12\]\[26\] picorv32_core.cpuregs\[13\]\[26\] picorv32_core.cpuregs\[14\]\[26\]
+ picorv32_core.cpuregs\[15\]\[26\] net759 net726 VGND VGND VPWR VPWR _04065_ sky130_fd_sc_hd__mux4_1
XFILLER_87_668 VGND VGND VPWR VPWR sky130_fd_sc_hd__decap_4
X_09725_ _04894_ _04895_ _04897_ _04896_ net658 net646 VGND VGND VPWR VPWR _04900_
+ sky130_fd_sc_hd__mux4_1
XFILLER_101_489 VGND VGND VPWR VPWR sky130_fd_sc_hd__fill_2
X_06937_ net934 _02932_ VGND VGND VPWR VPWR _03153_ sky130_fd_sc_hd__nand2_1
XFILLER_86_189 VGND VGND VPWR VPWR sky130_fd_sc_hd__fill_1
XFILLER_28_724 VGND VGND VPWR VPWR sky130_fd_sc_hd__fill_1
X_09656_ picorv32_core.cpuregs\[12\]\[21\] picorv32_core.cpuregs\[13\]\[21\] picorv32_core.cpuregs\[14\]\[21\]
+ picorv32_core.cpuregs\[15\]\[21\] net897 net863 VGND VGND VPWR VPWR _04834_ sky130_fd_sc_hd__mux4_1
XTAP_TAPCELL_ROW_2_333 VGND VPWR sky130_fd_sc_hd__tapvpwrvgnd_1
XFILLER_27_223 VGND VGND VPWR VPWR sky130_fd_sc_hd__fill_1
XFILLER_28_757 VPWR VGND VPWR VGND sky130_ef_sc_hd__decap_12
X_08607_ net239 net2234 net397 VGND VGND VPWR VPWR _00730_ sky130_fd_sc_hd__mux2_1
XFILLER_103_55 VGND VGND VPWR VPWR sky130_fd_sc_hd__fill_1
XFILLER_82_362 VGND VGND VPWR VPWR sky130_fd_sc_hd__fill_2
X_06868_ _03086_ _03089_ net587 VGND VGND VPWR VPWR _03090_ sky130_fd_sc_hd__a21oi_1
XFILLER_43_727 VGND VGND VPWR VPWR sky130_fd_sc_hd__fill_1
X_09587_ picorv32_core.cpuregs\[20\]\[18\] picorv32_core.cpuregs\[21\]\[18\] picorv32_core.cpuregs\[22\]\[18\]
+ picorv32_core.cpuregs\[23\]\[18\] net900 net866 VGND VGND VPWR VPWR _04768_ sky130_fd_sc_hd__mux4_1
X_06799_ _03024_ _03025_ VGND VGND VPWR VPWR _03026_ sky130_fd_sc_hd__nand2_1
X_05819_ _02296_ _02297_ VGND VGND VPWR VPWR _02298_ sky130_fd_sc_hd__nor2_1
XFILLER_36_790 VGND VGND VPWR VPWR sky130_fd_sc_hd__decap_3
XFILLER_43_749 VGND VGND VPWR VPWR sky130_fd_sc_hd__fill_1
X_08538_ net2162 net236 net404 VGND VGND VPWR VPWR _00665_ sky130_fd_sc_hd__mux2_1
XTAP_TAPCELL_ROW_120_2047 VGND VPWR sky130_fd_sc_hd__tapvpwrvgnd_1
XFILLER_70_557 VGND VGND VPWR VPWR sky130_fd_sc_hd__decap_6
XTAP_TAPCELL_ROW_41_906 VGND VPWR sky130_fd_sc_hd__tapvpwrvgnd_1
X_08469_ picorv32_core.mem_rdata_q\[10\] _04282_ VGND VGND VPWR VPWR _04316_ sky130_fd_sc_hd__and2_1
X_10500_ clknet_leaf_62_clk _00386_ VGND VGND VPWR VPWR net191 sky130_fd_sc_hd__dfxtp_2
XTAP_TAPCELL_ROW_102_1791 VGND VPWR sky130_fd_sc_hd__tapvpwrvgnd_1
XTAP_TAPCELL_ROW_102_1780 VGND VPWR sky130_fd_sc_hd__tapvpwrvgnd_1
XFILLER_137_821 VPWR VGND VPWR VGND sky130_ef_sc_hd__decap_12
X_11480_ clknet_leaf_60_clk _01316_ VGND VGND VPWR VPWR picorv32_core.cpuregs\[24\]\[31\]
+ sky130_fd_sc_hd__dfxtp_1
XFILLER_11_668 VGND VGND VPWR VPWR sky130_fd_sc_hd__decap_4
XFILLER_7_617 VGND VGND VPWR VPWR sky130_fd_sc_hd__decap_3
X_10431_ clknet_leaf_60_clk _01563_ VGND VGND VPWR VPWR picorv32_core.reg_out\[24\]
+ sky130_fd_sc_hd__dfxtp_1
XFILLER_12_41 VPWR VGND VPWR VGND sky130_ef_sc_hd__decap_12
XFILLER_128_41 VPWR VGND VPWR VGND sky130_ef_sc_hd__decap_12
X_10362_ clknet_leaf_77_clk _00281_ VGND VGND VPWR VPWR picorv32_core.count_cycle\[20\]
+ sky130_fd_sc_hd__dfxtp_1
XFILLER_12_85 VGND VGND VPWR VPWR sky130_fd_sc_hd__decap_4
XFILLER_128_85 VGND VGND VPWR VPWR sky130_fd_sc_hd__decap_3
X_10293_ clknet_leaf_89_clk _00212_ VGND VGND VPWR VPWR picorv32_core.reg_pc\[14\]
+ sky130_fd_sc_hd__dfxtp_2
XTAP_TAPCELL_ROW_131_2198 VGND VPWR sky130_fd_sc_hd__tapvpwrvgnd_1
XFILLER_88_67 VGND VGND VPWR VPWR sky130_fd_sc_hd__fill_1
XFILLER_120_721 VPWR VGND VPWR VGND sky130_ef_sc_hd__decap_12
Xhold190 picorv32_core.cpuregs\[7\]\[11\] VGND VGND VPWR VPWR net1299 sky130_fd_sc_hd__dlygate4sd3_1
XFILLER_78_668 VGND VGND VPWR VPWR sky130_fd_sc_hd__fill_1
Xfanout670 net671 VGND VGND VPWR VPWR net670 sky130_fd_sc_hd__buf_2
Xfanout681 net683 VGND VGND VPWR VPWR net681 sky130_fd_sc_hd__buf_4
Xfanout692 net693 VGND VGND VPWR VPWR net692 sky130_fd_sc_hd__clkbuf_4
XFILLER_74_830 VGND VGND VPWR VPWR sky130_fd_sc_hd__fill_1
XTAP_TAPCELL_ROW_29_730 VGND VPWR sky130_fd_sc_hd__tapvpwrvgnd_1
XPHY_EDGE_ROW_16_Right_16 VGND VGND VPWR VPWR sky130_fd_sc_hd__decap_3
XTAP_TAPCELL_ROW_64_1230 VGND VPWR sky130_fd_sc_hd__tapvpwrvgnd_1
XTAP_TAPCELL_ROW_138_2308 VGND VPWR sky130_fd_sc_hd__tapvpwrvgnd_1
X_11678_ clknet_leaf_41_clk _01509_ VGND VGND VPWR VPWR picorv32_core.cpuregs\[26\]\[27\]
+ sky130_fd_sc_hd__dfxtp_1
X_10629_ clknet_leaf_83_clk _00483_ VGND VGND VPWR VPWR picorv32_core.decoded_imm_j\[14\]
+ sky130_fd_sc_hd__dfxtp_1
XPHY_EDGE_ROW_25_Right_25 VGND VGND VPWR VPWR sky130_fd_sc_hd__decap_3
XFILLER_5_193 VPWR VGND VPWR VGND sky130_ef_sc_hd__decap_12
XFILLER_45_3 VPWR VGND VPWR VGND sky130_ef_sc_hd__decap_12
XFILLER_123_581 VGND VGND VPWR VPWR sky130_fd_sc_hd__fill_1
XTAP_TAPCELL_ROW_75_1392 VGND VPWR sky130_fd_sc_hd__tapvpwrvgnd_1
XFILLER_68_112 VGND VGND VPWR VPWR sky130_fd_sc_hd__fill_1
XFILLER_111_765 VPWR VGND VPWR VGND sky130_ef_sc_hd__decap_12
XFILLER_96_432 VGND VGND VPWR VPWR sky130_fd_sc_hd__decap_8
X_07840_ picorv32_core.cpuregs\[4\]\[18\] picorv32_core.cpuregs\[5\]\[18\] picorv32_core.cpuregs\[6\]\[18\]
+ picorv32_core.cpuregs\[7\]\[18\] net750 net717 VGND VGND VPWR VPWR _03927_ sky130_fd_sc_hd__mux4_1
XFILLER_68_145 VGND VGND VPWR VPWR sky130_fd_sc_hd__fill_1
XFILLER_110_253 VGND VGND VPWR VPWR sky130_fd_sc_hd__fill_2
X_07771_ net630 _03861_ VGND VGND VPWR VPWR _03862_ sky130_fd_sc_hd__or2_1
XFILLER_68_167 VGND VGND VPWR VPWR sky130_fd_sc_hd__fill_1
X_09510_ _03423_ _03424_ _03425_ _03489_ VGND VGND VPWR VPWR _04694_ sky130_fd_sc_hd__o211ai_1
XPHY_EDGE_ROW_34_Right_34 VGND VGND VPWR VPWR sky130_fd_sc_hd__decap_3
X_06722_ picorv32_core.decoded_imm_j\[3\] _02915_ VGND VGND VPWR VPWR _02955_ sky130_fd_sc_hd__nor2_1
XFILLER_92_671 VGND VGND VPWR VPWR sky130_fd_sc_hd__decap_6
X_06653_ _02678_ picorv32_core.reg_next_pc\[4\] net555 VGND VGND VPWR VPWR _02916_
+ sky130_fd_sc_hd__mux2_2
X_09441_ _04619_ _04627_ _04628_ net825 net648 VGND VGND VPWR VPWR _04629_ sky130_fd_sc_hd__a221o_1
X_05604_ picorv32_core.reg_pc\[29\] picorv32_core.decoded_imm\[29\] VGND VGND VPWR
+ VPWR _02091_ sky130_fd_sc_hd__nor2_1
X_06584_ net2364 _02869_ _02871_ VGND VGND VPWR VPWR _00177_ sky130_fd_sc_hd__o21a_1
X_09372_ _04553_ _04561_ _04562_ net825 net648 VGND VGND VPWR VPWR _04563_ sky130_fd_sc_hd__a221o_1
X_05535_ net922 _02020_ _02021_ _02027_ VGND VGND VPWR VPWR _01562_ sky130_fd_sc_hd__a31o_1
X_08323_ picorv32_core.mem_do_wdata _03584_ VGND VGND VPWR VPWR _04236_ sky130_fd_sc_hd__nand2_2
XFILLER_119_821 VPWR VGND VPWR VGND sky130_ef_sc_hd__decap_12
X_05466_ net578 _01962_ _01963_ net786 net917 VGND VGND VPWR VPWR _01964_ sky130_fd_sc_hd__a32o_1
X_08254_ picorv32_core.decoded_imm_j\[10\] _00771_ net440 VGND VGND VPWR VPWR _00480_
+ sky130_fd_sc_hd__mux2_1
XPHY_EDGE_ROW_43_Right_43 VGND VGND VPWR VPWR sky130_fd_sc_hd__decap_3
XFILLER_118_320 VGND VGND VPWR VPWR sky130_fd_sc_hd__decap_3
X_07205_ _03359_ _03360_ VGND VGND VPWR VPWR _00309_ sky130_fd_sc_hd__nor2_1
X_05397_ picorv32_core.count_cycle\[13\] net601 net578 _01899_ VGND VGND VPWR VPWR
+ _01900_ sky130_fd_sc_hd__o211a_1
X_08185_ net2232 net523 _04187_ _04197_ VGND VGND VPWR VPWR _00443_ sky130_fd_sc_hd__a22o_1
XFILLER_134_813 VPWR VGND VPWR VGND sky130_ef_sc_hd__decap_12
X_07136_ picorv32_core.count_cycle\[22\] _03314_ picorv32_core.count_cycle\[23\] VGND
+ VGND VPWR VPWR _03317_ sky130_fd_sc_hd__a21o_1
X_07067_ _02943_ _03263_ VGND VGND VPWR VPWR _03272_ sky130_fd_sc_hd__or2_1
X_06018_ net781 net955 net569 VGND VGND VPWR VPWR _02482_ sky130_fd_sc_hd__and3_1
XTAP_TAPCELL_ROW_7_403 VGND VPWR sky130_fd_sc_hd__tapvpwrvgnd_1
XFILLER_0_804 VGND VGND VPWR VPWR sky130_fd_sc_hd__decap_4
XFILLER_114_581 VGND VGND VPWR VPWR sky130_fd_sc_hd__fill_1
XFILLER_99_281 VGND VGND VPWR VPWR sky130_fd_sc_hd__decap_6
XFILLER_101_275 VGND VGND VPWR VPWR sky130_fd_sc_hd__decap_4
XFILLER_59_178 VGND VGND VPWR VPWR sky130_fd_sc_hd__fill_2
XPHY_EDGE_ROW_52_Right_52 VGND VGND VPWR VPWR sky130_fd_sc_hd__decap_3
X_07969_ picorv32_core.cpuregs\[0\]\[25\] picorv32_core.cpuregs\[1\]\[25\] picorv32_core.cpuregs\[2\]\[25\]
+ picorv32_core.cpuregs\[3\]\[25\] net763 net730 VGND VGND VPWR VPWR _04049_ sky130_fd_sc_hd__mux4_1
X_09708_ picorv32_core.reg_pc\[23\] net537 _04883_ net483 VGND VGND VPWR VPWR _04884_
+ sky130_fd_sc_hd__a211o_1
XFILLER_59_189 VGND VGND VPWR VPWR sky130_fd_sc_hd__decap_3
X_10980_ clknet_leaf_45_clk _00831_ VGND VGND VPWR VPWR picorv32_core.cpuregs\[13\]\[26\]
+ sky130_fd_sc_hd__dfxtp_1
XFILLER_74_47 VGND VGND VPWR VPWR sky130_fd_sc_hd__fill_1
X_09639_ _04809_ _04816_ _04817_ net645 net650 VGND VGND VPWR VPWR _04818_ sky130_fd_sc_hd__a221o_1
XPHY_EDGE_ROW_27_Left_169 VGND VGND VPWR VPWR sky130_fd_sc_hd__decap_3
XFILLER_28_598 VPWR VGND VPWR VGND sky130_ef_sc_hd__decap_12
XFILLER_130_53 VPWR VGND VPWR VGND sky130_ef_sc_hd__decap_12
XTAP_TAPCELL_ROW_104_1820 VGND VPWR sky130_fd_sc_hd__tapvpwrvgnd_1
XFILLER_70_343 VGND VGND VPWR VPWR sky130_fd_sc_hd__decap_3
XFILLER_130_97 VGND VGND VPWR VPWR sky130_fd_sc_hd__decap_6
X_11601_ clknet_leaf_7_clk _01432_ VGND VGND VPWR VPWR picorv32_core.cpuregs\[23\]\[14\]
+ sky130_fd_sc_hd__dfxtp_1
XFILLER_30_218 VGND VGND VPWR VPWR sky130_fd_sc_hd__decap_4
XPHY_EDGE_ROW_61_Right_61 VGND VGND VPWR VPWR sky130_fd_sc_hd__decap_3
XFILLER_23_281 VGND VGND VPWR VPWR sky130_fd_sc_hd__fill_1
XFILLER_24_793 VGND VGND VPWR VPWR sky130_fd_sc_hd__fill_2
X_11532_ clknet_leaf_13_clk _01363_ VGND VGND VPWR VPWR picorv32_core.cpuregs\[30\]\[13\]
+ sky130_fd_sc_hd__dfxtp_1
XFILLER_11_465 VGND VGND VPWR VPWR sky130_fd_sc_hd__fill_2
XFILLER_23_51 VGND VGND VPWR VPWR sky130_fd_sc_hd__decap_4
XFILLER_139_51 VGND VGND VPWR VPWR sky130_fd_sc_hd__decap_4
XTAP_TAPCELL_ROW_133_2227 VGND VPWR sky130_fd_sc_hd__tapvpwrvgnd_1
X_11463_ clknet_leaf_23_clk _01299_ VGND VGND VPWR VPWR picorv32_core.cpuregs\[24\]\[14\]
+ sky130_fd_sc_hd__dfxtp_1
XTAP_TAPCELL_ROW_133_2238 VGND VPWR sky130_fd_sc_hd__tapvpwrvgnd_1
XFILLER_109_353 VGND VGND VPWR VPWR sky130_fd_sc_hd__fill_1
X_10414_ clknet_leaf_123_clk _01576_ VGND VGND VPWR VPWR picorv32_core.reg_out\[7\]
+ sky130_fd_sc_hd__dfxtp_1
X_11394_ clknet_leaf_140_clk _01230_ VGND VGND VPWR VPWR picorv32_core.cpuregs\[31\]\[9\]
+ sky130_fd_sc_hd__dfxtp_1
XPHY_EDGE_ROW_36_Left_178 VGND VGND VPWR VPWR sky130_fd_sc_hd__decap_3
XFILLER_140_805 VGND VGND VPWR VPWR sky130_fd_sc_hd__decap_6
XTAP_TAPCELL_ROW_115_1971 VGND VPWR sky130_fd_sc_hd__tapvpwrvgnd_1
X_10345_ clknet_leaf_104_clk _00264_ VGND VGND VPWR VPWR picorv32_core.count_cycle\[3\]
+ sky130_fd_sc_hd__dfxtp_1
X_10276_ clknet_leaf_74_clk _00195_ VGND VGND VPWR VPWR picorv32_core.count_instr\[60\]
+ sky130_fd_sc_hd__dfxtp_1
XFILLER_78_421 VGND VGND VPWR VPWR sky130_fd_sc_hd__decap_3
XPHY_EDGE_ROW_70_Right_70 VGND VGND VPWR VPWR sky130_fd_sc_hd__decap_3
XFILLER_2_141 VPWR VGND VPWR VGND sky130_ef_sc_hd__decap_12
XFILLER_105_592 VGND VGND VPWR VPWR sky130_fd_sc_hd__decap_6
XFILLER_93_424 VGND VGND VPWR VPWR sky130_fd_sc_hd__fill_1
XPHY_EDGE_ROW_45_Left_187 VGND VGND VPWR VPWR sky130_fd_sc_hd__decap_3
XFILLER_46_373 VGND VGND VPWR VPWR sky130_fd_sc_hd__fill_2
X_05320_ _01727_ _01827_ VGND VGND VPWR VPWR _01828_ sky130_fd_sc_hd__or2_1
XFILLER_9_42 VPWR VGND VPWR VGND sky130_ef_sc_hd__decap_12
XTAP_TAPCELL_ROW_32_769 VGND VPWR sky130_fd_sc_hd__tapvpwrvgnd_1
XPHY_EDGE_ROW_54_Left_196 VGND VGND VPWR VPWR sky130_fd_sc_hd__decap_3
X_05251_ net920 _01755_ _01756_ _01763_ VGND VGND VPWR VPWR _01572_ sky130_fd_sc_hd__a31o_1
XFILLER_134_109 VGND VGND VPWR VPWR sky130_fd_sc_hd__fill_2
XFILLER_116_813 VPWR VGND VPWR VGND sky130_ef_sc_hd__decap_12
Xhold904 picorv32_core.cpuregs\[2\]\[17\] VGND VGND VPWR VPWR net2013 sky130_fd_sc_hd__dlygate4sd3_1
XTAP_TAPCELL_ROW_77_1421 VGND VPWR sky130_fd_sc_hd__tapvpwrvgnd_1
XTAP_TAPCELL_ROW_12_482 VGND VPWR sky130_fd_sc_hd__tapvpwrvgnd_1
X_05182_ picorv32_core.mem_do_prefetch _01637_ _01668_ _01580_ _01698_ VGND VGND VPWR
+ VPWR _01704_ sky130_fd_sc_hd__o221a_1
XFILLER_115_334 VGND VGND VPWR VPWR sky130_fd_sc_hd__fill_2
Xhold926 picorv32_core.cpuregs\[25\]\[31\] VGND VGND VPWR VPWR net2035 sky130_fd_sc_hd__dlygate4sd3_1
Xhold937 picorv32_core.count_cycle\[57\] VGND VGND VPWR VPWR net2046 sky130_fd_sc_hd__dlygate4sd3_1
Xhold915 picorv32_core.cpuregs\[4\]\[8\] VGND VGND VPWR VPWR net2024 sky130_fd_sc_hd__dlygate4sd3_1
Xhold959 picorv32_core.cpuregs\[29\]\[21\] VGND VGND VPWR VPWR net2068 sky130_fd_sc_hd__dlygate4sd3_1
XTAP_TAPCELL_ROW_90_1610 VGND VPWR sky130_fd_sc_hd__tapvpwrvgnd_1
X_09990_ net1771 net262 net314 VGND VGND VPWR VPWR _01467_ sky130_fd_sc_hd__mux2_1
Xhold948 picorv32_core.cpuregs\[29\]\[10\] VGND VGND VPWR VPWR net2057 sky130_fd_sc_hd__dlygate4sd3_1
X_08941_ net244 net2170 net355 VGND VGND VPWR VPWR _01114_ sky130_fd_sc_hd__mux2_1
XFILLER_103_529 VGND VGND VPWR VPWR sky130_fd_sc_hd__decap_8
XFILLER_97_752 VGND VGND VPWR VPWR sky130_fd_sc_hd__decap_3
X_08872_ net257 net1854 net363 VGND VGND VPWR VPWR _01047_ sky130_fd_sc_hd__mux2_1
XFILLER_69_454 VGND VGND VPWR VPWR sky130_fd_sc_hd__decap_8
X_07823_ picorv32_core.cpuregs\[12\]\[17\] picorv32_core.cpuregs\[13\]\[17\] picorv32_core.cpuregs\[14\]\[17\]
+ picorv32_core.cpuregs\[15\]\[17\] net747 net714 VGND VGND VPWR VPWR _03911_ sky130_fd_sc_hd__mux4_1
XFILLER_28_29 VGND VGND VPWR VPWR sky130_fd_sc_hd__decap_8
XFILLER_111_595 VGND VGND VPWR VPWR sky130_fd_sc_hd__fill_2
XFILLER_84_424 VGND VGND VPWR VPWR sky130_fd_sc_hd__decap_8
XFILLER_69_498 VGND VGND VPWR VPWR sky130_fd_sc_hd__decap_6
X_07754_ picorv32_core.cpuregs\[20\]\[13\] picorv32_core.cpuregs\[21\]\[13\] picorv32_core.cpuregs\[22\]\[13\]
+ picorv32_core.cpuregs\[23\]\[13\] net740 net707 VGND VGND VPWR VPWR _03846_ sky130_fd_sc_hd__mux4_1
X_06705_ _02787_ picorv32_core.reg_next_pc\[30\] net559 VGND VGND VPWR VPWR _02942_
+ sky130_fd_sc_hd__mux2_2
XTAP_TAPCELL_ROW_88_1583 VGND VPWR sky130_fd_sc_hd__tapvpwrvgnd_1
X_07685_ net693 _03777_ _03776_ net617 VGND VGND VPWR VPWR _03781_ sky130_fd_sc_hd__o211a_1
X_06636_ picorv32_core.count_instr\[61\] picorv32_core.count_instr\[60\] picorv32_core.count_instr\[59\]
+ _02900_ VGND VGND VPWR VPWR _02905_ sky130_fd_sc_hd__and4_1
X_09424_ net792 net547 VGND VGND VPWR VPWR _04612_ sky130_fd_sc_hd__or2_1
Xclkbuf_leaf_91_clk clknet_4_9_0_clk VGND VGND VPWR VPWR clknet_leaf_91_clk sky130_fd_sc_hd__clkbuf_8
XFILLER_52_365 VPWR VGND VPWR VGND sky130_ef_sc_hd__decap_12
XFILLER_12_218 VGND VGND VPWR VPWR sky130_fd_sc_hd__fill_1
XFILLER_21_741 VPWR VGND VPWR VGND sky130_ef_sc_hd__decap_12
XFILLER_40_538 VGND VGND VPWR VPWR sky130_fd_sc_hd__decap_4
X_06567_ picorv32_core.count_instr\[36\] _02859_ net973 VGND VGND VPWR VPWR _02861_
+ sky130_fd_sc_hd__a21oi_1
X_09355_ _03479_ _03481_ VGND VGND VPWR VPWR _04546_ sky130_fd_sc_hd__xnor2_1
X_05518_ picorv32_core.count_instr\[54\] net937 net941 picorv32_core.count_instr\[22\]
+ VGND VGND VPWR VPWR _02012_ sky130_fd_sc_hd__a22o_1
X_06498_ picorv32_core.count_instr\[11\] _02815_ net974 VGND VGND VPWR VPWR _02817_
+ sky130_fd_sc_hd__a21oi_1
XFILLER_60_27 VGND VGND VPWR VPWR sky130_fd_sc_hd__fill_1
X_09286_ _03470_ _03472_ VGND VGND VPWR VPWR _04480_ sky130_fd_sc_hd__nand2_1
X_08306_ picorv32_core.decoded_imm\[0\] net526 _04228_ VGND VGND VPWR VPWR _00531_
+ sky130_fd_sc_hd__o21a_1
X_05449_ _01946_ _01947_ VGND VGND VPWR VPWR _01948_ sky130_fd_sc_hd__nor2_1
X_08237_ _04211_ _04221_ net940 net523 VGND VGND VPWR VPWR _00471_ sky130_fd_sc_hd__a2bb2o_1
XFILLER_21_785 VPWR VGND VPWR VGND sky130_ef_sc_hd__decap_12
XFILLER_107_813 VGND VGND VPWR VPWR sky130_fd_sc_hd__decap_8
XFILLER_20_295 VGND VGND VPWR VPWR sky130_fd_sc_hd__decap_3
X_08168_ net2324 net476 _04185_ _04189_ VGND VGND VPWR VPWR _00437_ sky130_fd_sc_hd__a22o_1
XFILLER_122_805 VGND VGND VPWR VPWR sky130_fd_sc_hd__decap_6
X_07119_ picorv32_core.count_cycle\[16\] _03304_ _03306_ VGND VGND VPWR VPWR _00277_
+ sky130_fd_sc_hd__o21a_1
X_08099_ net920 picorv32_core.latched_branch net924 net981 _04169_ VGND VGND VPWR
+ VPWR _00394_ sky130_fd_sc_hd__o311a_1
XFILLER_134_698 VGND VGND VPWR VPWR sky130_fd_sc_hd__fill_2
X_10130_ clknet_leaf_9_clk _00052_ VGND VGND VPWR VPWR picorv32_core.cpuregs\[22\]\[13\]
+ sky130_fd_sc_hd__dfxtp_1
X_10061_ net1326 net243 net306 VGND VGND VPWR VPWR _01536_ sky130_fd_sc_hd__mux2_1
XFILLER_102_540 VGND VGND VPWR VPWR sky130_fd_sc_hd__decap_3
XFILLER_0_645 VPWR VGND VPWR VGND sky130_ef_sc_hd__decap_12
XFILLER_102_551 VPWR VGND VPWR VGND sky130_ef_sc_hd__decap_12
XFILLER_87_251 VGND VGND VPWR VPWR sky130_fd_sc_hd__fill_1
XFILLER_0_678 VGND VGND VPWR VPWR sky130_fd_sc_hd__decap_4
XFILLER_85_57 VGND VGND VPWR VPWR sky130_fd_sc_hd__decap_3
XFILLER_141_41 VPWR VGND VPWR VGND sky130_ef_sc_hd__decap_12
XFILLER_56_671 VGND VGND VPWR VPWR sky130_fd_sc_hd__decap_3
X_10963_ clknet_leaf_141_clk _00814_ VGND VGND VPWR VPWR picorv32_core.cpuregs\[13\]\[9\]
+ sky130_fd_sc_hd__dfxtp_1
XTAP_TAPCELL_ROW_48_1000 VGND VPWR sky130_fd_sc_hd__tapvpwrvgnd_1
XFILLER_141_85 VPWR VGND VPWR VGND sky130_ef_sc_hd__decap_12
Xclkbuf_leaf_82_clk clknet_4_14_0_clk VGND VGND VPWR VPWR clknet_leaf_82_clk sky130_fd_sc_hd__clkbuf_8
X_10894_ clknet_leaf_99_clk _00745_ VGND VGND VPWR VPWR picorv32_core.mem_rdata_q\[4\]
+ sky130_fd_sc_hd__dfxtp_1
XFILLER_31_505 VPWR VGND VPWR VGND sky130_ef_sc_hd__decap_12
XFILLER_12_741 VPWR VGND VPWR VGND sky130_ef_sc_hd__decap_12
X_11515_ clknet_leaf_112_clk _00021_ VGND VGND VPWR VPWR _00001_ sky130_fd_sc_hd__dfxtp_4
X_11446_ clknet_leaf_72_clk _01282_ VGND VGND VPWR VPWR picorv32_core.cpuregs\[1\]\[29\]
+ sky130_fd_sc_hd__dfxtp_1
X_11377_ clknet_leaf_65_clk _01218_ VGND VGND VPWR VPWR picorv32_core.cpuregs\[18\]\[29\]
+ sky130_fd_sc_hd__dfxtp_1
XTAP_TAPCELL_ROW_59_1162 VGND VPWR sky130_fd_sc_hd__tapvpwrvgnd_1
X_10328_ clknet_leaf_84_clk _00247_ VGND VGND VPWR VPWR picorv32_core.reg_next_pc\[18\]
+ sky130_fd_sc_hd__dfxtp_1
XFILLER_124_197 VGND VGND VPWR VPWR sky130_fd_sc_hd__fill_1
XFILLER_124_186 VGND VGND VPWR VPWR sky130_fd_sc_hd__fill_2
XFILLER_79_752 VGND VGND VPWR VPWR sky130_fd_sc_hd__decap_8
XTAP_TAPCELL_ROW_72_1351 VGND VPWR sky130_fd_sc_hd__tapvpwrvgnd_1
X_10259_ clknet_leaf_100_clk _00178_ VGND VGND VPWR VPWR picorv32_core.count_instr\[43\]
+ sky130_fd_sc_hd__dfxtp_1
XFILLER_94_755 VGND VGND VPWR VPWR sky130_fd_sc_hd__fill_1
XFILLER_94_777 VGND VGND VPWR VPWR sky130_fd_sc_hd__fill_2
XFILLER_53_129 VGND VGND VPWR VPWR sky130_fd_sc_hd__fill_1
XFILLER_53_107 VGND VGND VPWR VPWR sky130_fd_sc_hd__decap_4
XTAP_TAPCELL_ROW_37_839 VGND VPWR sky130_fd_sc_hd__tapvpwrvgnd_1
Xclkbuf_leaf_73_clk clknet_4_15_0_clk VGND VGND VPWR VPWR clknet_leaf_73_clk sky130_fd_sc_hd__clkbuf_8
XFILLER_81_449 VGND VGND VPWR VPWR sky130_fd_sc_hd__decap_3
X_07470_ picorv32_core.reg_out\[10\] picorv32_core.reg_next_pc\[10\] net557 VGND VGND
+ VPWR VPWR _03601_ sky130_fd_sc_hd__mux2_1
XTAP_TAPCELL_ROW_17_552 VGND VPWR sky130_fd_sc_hd__tapvpwrvgnd_1
XFILLER_34_376 VGND VGND VPWR VPWR sky130_fd_sc_hd__fill_1
X_06421_ net258 net1370 net424 VGND VGND VPWR VPWR _00089_ sky130_fd_sc_hd__mux2_1
X_09140_ net1848 net246 net330 VGND VGND VPWR VPWR _01306_ sky130_fd_sc_hd__mux2_1
X_06352_ _02754_ _02755_ VGND VGND VPWR VPWR _02756_ sky130_fd_sc_hd__nor2_1
XPHY_EDGE_ROW_62_Left_204 VGND VGND VPWR VPWR sky130_fd_sc_hd__decap_3
X_09071_ net1219 net256 net338 VGND VGND VPWR VPWR _01239_ sky130_fd_sc_hd__mux2_1
X_05303_ net821 net10 _01718_ _01811_ VGND VGND VPWR VPWR _01812_ sky130_fd_sc_hd__o211a_1
X_06283_ picorv32_core.reg_pc\[8\] _02693_ picorv32_core.reg_pc\[9\] VGND VGND VPWR
+ VPWR _02700_ sky130_fd_sc_hd__a21oi_1
X_08022_ net637 _04098_ VGND VGND VPWR VPWR _04099_ sky130_fd_sc_hd__or2_1
Xhold712 picorv32_core.cpuregs\[25\]\[23\] VGND VGND VPWR VPWR net1821 sky130_fd_sc_hd__dlygate4sd3_1
Xhold701 picorv32_core.cpuregs\[4\]\[10\] VGND VGND VPWR VPWR net1810 sky130_fd_sc_hd__dlygate4sd3_1
X_05234_ picorv32_core.count_instr\[2\] net939 net943 picorv32_core.count_cycle\[34\]
+ VGND VGND VPWR VPWR _01748_ sky130_fd_sc_hd__a22o_1
Xhold734 picorv32_core.cpuregs\[26\]\[28\] VGND VGND VPWR VPWR net1843 sky130_fd_sc_hd__dlygate4sd3_1
Xhold745 picorv32_core.cpuregs\[6\]\[18\] VGND VGND VPWR VPWR net1854 sky130_fd_sc_hd__dlygate4sd3_1
Xhold723 picorv32_core.count_instr\[17\] VGND VGND VPWR VPWR net1832 sky130_fd_sc_hd__dlygate4sd3_1
X_05165_ _01591_ _01688_ VGND VGND VPWR VPWR _01690_ sky130_fd_sc_hd__nor2_1
Xhold778 picorv32_core.cpuregs\[19\]\[21\] VGND VGND VPWR VPWR net1887 sky130_fd_sc_hd__dlygate4sd3_1
Xhold756 picorv32_core.instr_andi VGND VGND VPWR VPWR net1865 sky130_fd_sc_hd__dlygate4sd3_1
Xhold767 picorv32_core.cpuregs\[8\]\[3\] VGND VGND VPWR VPWR net1876 sky130_fd_sc_hd__dlygate4sd3_1
X_09973_ net1332 net502 net312 VGND VGND VPWR VPWR _01450_ sky130_fd_sc_hd__mux2_1
X_05096_ picorv32_core.mem_state\[0\] picorv32_core.mem_state\[1\] VGND VGND VPWR
+ VPWR _01628_ sky130_fd_sc_hd__or2_1
XFILLER_130_112 VGND VGND VPWR VPWR sky130_fd_sc_hd__fill_1
Xhold789 picorv32_core.cpuregs\[10\]\[25\] VGND VGND VPWR VPWR net1898 sky130_fd_sc_hd__dlygate4sd3_1
X_08924_ net467 net1973 net357 VGND VGND VPWR VPWR _01097_ sky130_fd_sc_hd__mux2_1
XPHY_EDGE_ROW_71_Left_213 VGND VGND VPWR VPWR sky130_fd_sc_hd__decap_3
XFILLER_69_295 VGND VGND VPWR VPWR sky130_fd_sc_hd__decap_6
X_08855_ net500 net2008 net365 VGND VGND VPWR VPWR _01030_ sky130_fd_sc_hd__mux2_1
X_07806_ picorv32_core.cpuregs\[8\]\[16\] picorv32_core.cpuregs\[9\]\[16\] picorv32_core.cpuregs\[10\]\[16\]
+ picorv32_core.cpuregs\[11\]\[16\] net751 net718 VGND VGND VPWR VPWR _03895_ sky130_fd_sc_hd__mux4_1
XFILLER_55_16 VGND VGND VPWR VPWR sky130_fd_sc_hd__decap_6
XPHY_EDGE_ROW_2_Right_2 VGND VGND VPWR VPWR sky130_fd_sc_hd__decap_3
X_08786_ _02797_ _04225_ VGND VGND VPWR VPWR _04339_ sky130_fd_sc_hd__or2_4
X_05998_ _02461_ _02462_ VGND VGND VPWR VPWR _02463_ sky130_fd_sc_hd__nand2b_1
X_07737_ net629 _03829_ VGND VGND VPWR VPWR _03830_ sky130_fd_sc_hd__or2_1
XFILLER_38_660 VGND VGND VPWR VPWR sky130_fd_sc_hd__fill_1
Xclkbuf_leaf_64_clk clknet_4_13_0_clk VGND VGND VPWR VPWR clknet_leaf_64_clk sky130_fd_sc_hd__clkbuf_8
XFILLER_25_321 VGND VGND VPWR VPWR sky130_fd_sc_hd__fill_1
XFILLER_80_471 VGND VGND VPWR VPWR sky130_fd_sc_hd__decap_4
X_07668_ net682 _03763_ net623 VGND VGND VPWR VPWR _03765_ sky130_fd_sc_hd__a21o_1
X_06619_ picorv32_core.count_instr\[55\] picorv32_core.count_instr\[54\] _02887_ _02890_
+ VGND VGND VPWR VPWR _02894_ sky130_fd_sc_hd__and4_1
XPHY_EDGE_ROW_80_Left_222 VGND VGND VPWR VPWR sky130_fd_sc_hd__decap_3
XFILLER_52_195 VGND VGND VPWR VPWR sky130_fd_sc_hd__fill_1
X_07599_ net693 _03698_ VGND VGND VPWR VPWR _03699_ sky130_fd_sc_hd__or2_1
X_09407_ picorv32_core.cpuregs\[28\]\[10\] picorv32_core.cpuregs\[29\]\[10\] picorv32_core.cpuregs\[30\]\[10\]
+ picorv32_core.cpuregs\[31\]\[10\] net878 net845 VGND VGND VPWR VPWR _04596_ sky130_fd_sc_hd__mux4_1
X_09338_ picorv32_core.cpuregs\[24\]\[7\] picorv32_core.cpuregs\[25\]\[7\] picorv32_core.cpuregs\[26\]\[7\]
+ picorv32_core.cpuregs\[27\]\[7\] net876 net843 VGND VGND VPWR VPWR _04530_ sky130_fd_sc_hd__mux4_1
XTAP_TAPCELL_ROW_117_2008 VGND VPWR sky130_fd_sc_hd__tapvpwrvgnd_1
Xpicorv32_axi_1100 VGND VGND VPWR VPWR picorv32_axi_1100/HI trace_data[27] sky130_fd_sc_hd__conb_1
X_11300_ clknet_leaf_43_clk _01148_ VGND VGND VPWR VPWR picorv32_core.cpuregs\[3\]\[23\]
+ sky130_fd_sc_hd__dfxtp_1
X_09269_ picorv32_core.cpuregs\[0\]\[4\] picorv32_core.cpuregs\[1\]\[4\] picorv32_core.cpuregs\[2\]\[4\]
+ picorv32_core.cpuregs\[3\]\[4\] net887 net854 VGND VGND VPWR VPWR _04464_ sky130_fd_sc_hd__mux4_1
XFILLER_138_289 VGND VGND VPWR VPWR sky130_fd_sc_hd__decap_3
XFILLER_112_3 VPWR VGND VPWR VGND sky130_ef_sc_hd__decap_12
X_11231_ clknet_leaf_50_clk _01082_ VGND VGND VPWR VPWR picorv32_core.cpuregs\[5\]\[21\]
+ sky130_fd_sc_hd__dfxtp_1
XFILLER_107_654 VGND VGND VPWR VPWR sky130_fd_sc_hd__decap_8
XFILLER_20_41 VPWR VGND VPWR VGND sky130_ef_sc_hd__decap_12
XFILLER_136_41 VPWR VGND VPWR VGND sky130_ef_sc_hd__decap_12
X_11162_ clknet_leaf_22_clk _01013_ VGND VGND VPWR VPWR picorv32_core.cpuregs\[7\]\[16\]
+ sky130_fd_sc_hd__dfxtp_1
XFILLER_20_85 VGND VGND VPWR VPWR sky130_fd_sc_hd__fill_1
X_10113_ net1143 VGND VGND VPWR VPWR _00963_ sky130_fd_sc_hd__clkbuf_1
XFILLER_136_85 VPWR VGND VPWR VGND sky130_ef_sc_hd__decap_12
XTAP_TAPCELL_ROW_112_1930 VGND VPWR sky130_fd_sc_hd__tapvpwrvgnd_1
XFILLER_106_197 VGND VGND VPWR VPWR sky130_fd_sc_hd__decap_4
XFILLER_121_167 VGND VGND VPWR VPWR sky130_fd_sc_hd__fill_1
XTAP_TAPCELL_ROW_54_1081 VGND VPWR sky130_fd_sc_hd__tapvpwrvgnd_1
X_11093_ clknet_leaf_4_clk _00944_ VGND VGND VPWR VPWR picorv32_core.cpuregs\[0\]\[11\]
+ sky130_fd_sc_hd__dfxtp_1
XTAP_TAPCELL_ROW_128_2159 VGND VPWR sky130_fd_sc_hd__tapvpwrvgnd_1
Xhold50 net119 VGND VGND VPWR VPWR net1159 sky130_fd_sc_hd__dlygate4sd3_1
XTAP_TAPCELL_ROW_54_1092 VGND VPWR sky130_fd_sc_hd__tapvpwrvgnd_1
XFILLER_0_475 VGND VGND VPWR VPWR sky130_fd_sc_hd__fill_1
X_10044_ net1344 net449 net304 VGND VGND VPWR VPWR _01519_ sky130_fd_sc_hd__mux2_1
Xhold61 net125 VGND VGND VPWR VPWR net1170 sky130_fd_sc_hd__dlygate4sd3_1
Xhold72 net120 VGND VGND VPWR VPWR net1181 sky130_fd_sc_hd__dlygate4sd3_1
Xhold83 picorv32_core.mem_rdata_q\[9\] VGND VGND VPWR VPWR net1192 sky130_fd_sc_hd__dlygate4sd3_1
XFILLER_91_714 VPWR VGND VPWR VGND sky130_ef_sc_hd__decap_12
XFILLER_63_405 VPWR VGND VPWR VGND sky130_ef_sc_hd__decap_12
Xhold94 picorv32_core.cpuregs\[7\]\[0\] VGND VGND VPWR VPWR net1203 sky130_fd_sc_hd__dlygate4sd3_1
XTAP_TAPCELL_ROW_141_2359 VGND VPWR sky130_fd_sc_hd__tapvpwrvgnd_1
XTAP_TAPCELL_ROW_141_2348 VGND VPWR sky130_fd_sc_hd__tapvpwrvgnd_1
Xclkbuf_leaf_55_clk clknet_4_6_0_clk VGND VGND VPWR VPWR clknet_leaf_55_clk sky130_fd_sc_hd__clkbuf_8
XFILLER_63_449 VGND VGND VPWR VPWR sky130_fd_sc_hd__decap_8
X_10946_ clknet_leaf_35_clk _00797_ VGND VGND VPWR VPWR picorv32_core.cpuregs\[19\]\[24\]
+ sky130_fd_sc_hd__dfxtp_1
XPHY_EDGE_ROW_119_Left_261 VGND VGND VPWR VPWR sky130_fd_sc_hd__decap_3
XFILLER_43_151 VGND VGND VPWR VPWR sky130_fd_sc_hd__fill_1
X_10877_ clknet_leaf_48_clk _00728_ VGND VGND VPWR VPWR picorv32_core.cpuregs\[16\]\[21\]
+ sky130_fd_sc_hd__dfxtp_1
XTAP_TAPCELL_ROW_14_511 VGND VPWR sky130_fd_sc_hd__tapvpwrvgnd_1
XFILLER_12_571 VGND VGND VPWR VPWR sky130_fd_sc_hd__fill_1
XANTENNA_3 _01621_ VGND VGND VPWR VPWR sky130_fd_sc_hd__diode_2
XPHY_EDGE_ROW_128_Left_270 VGND VGND VPWR VPWR sky130_fd_sc_hd__decap_3
X_11429_ clknet_leaf_6_clk _01265_ VGND VGND VPWR VPWR picorv32_core.cpuregs\[1\]\[12\]
+ sky130_fd_sc_hd__dfxtp_1
XFILLER_6_65 VPWR VGND VPWR VGND sky130_ef_sc_hd__decap_12
XFILLER_140_421 VGND VGND VPWR VPWR sky130_fd_sc_hd__fill_1
XFILLER_4_781 VPWR VGND VPWR VGND sky130_ef_sc_hd__decap_12
X_06970_ _02933_ _03157_ _02934_ VGND VGND VPWR VPWR _03184_ sky130_fd_sc_hd__a21o_1
X_05921_ net795 _02390_ VGND VGND VPWR VPWR _02392_ sky130_fd_sc_hd__nand2_1
X_08640_ net1263 net257 net392 VGND VGND VPWR VPWR _00791_ sky130_fd_sc_hd__mux2_1
X_05852_ _02254_ _02325_ _02327_ _02328_ VGND VGND VPWR VPWR picorv32_core.alu_out\[7\]
+ sky130_fd_sc_hd__o22a_1
XFILLER_94_585 VGND VGND VPWR VPWR sky130_fd_sc_hd__decap_3
XFILLER_54_416 VGND VGND VPWR VPWR sky130_fd_sc_hd__fill_1
Xclkbuf_leaf_46_clk clknet_4_7_0_clk VGND VGND VPWR VPWR clknet_leaf_46_clk sky130_fd_sc_hd__clkbuf_8
X_08571_ net240 net1508 net400 VGND VGND VPWR VPWR _00696_ sky130_fd_sc_hd__mux2_1
XTAP_TAPCELL_ROW_85_1542 VGND VPWR sky130_fd_sc_hd__tapvpwrvgnd_1
XTAP_TAPCELL_ROW_85_1531 VGND VPWR sky130_fd_sc_hd__tapvpwrvgnd_1
X_05783_ net969 net968 net669 VGND VGND VPWR VPWR _02265_ sky130_fd_sc_hd__o21a_1
X_07522_ net768 _03635_ net535 VGND VGND VPWR VPWR _03636_ sky130_fd_sc_hd__mux2_1
XFILLER_35_663 VGND VGND VPWR VPWR sky130_fd_sc_hd__fill_1
X_07453_ net167 _03589_ net532 VGND VGND VPWR VPWR _03590_ sky130_fd_sc_hd__mux2_1
X_06404_ net499 net2200 net423 VGND VGND VPWR VPWR _00072_ sky130_fd_sc_hd__mux2_1
X_07384_ _03511_ _03523_ _03411_ VGND VGND VPWR VPWR _03524_ sky130_fd_sc_hd__a21oi_1
X_09123_ net1541 net467 net329 VGND VGND VPWR VPWR _01289_ sky130_fd_sc_hd__mux2_1
X_06335_ picorv32_core.reg_pc\[19\] picorv32_core.reg_pc\[18\] _02734_ VGND VGND VPWR
+ VPWR _02742_ sky130_fd_sc_hd__and3_1
XFILLER_136_749 VGND VGND VPWR VPWR sky130_fd_sc_hd__decap_6
X_09054_ net1422 net501 net337 VGND VGND VPWR VPWR _01222_ sky130_fd_sc_hd__mux2_1
X_06266_ _02683_ _02686_ net563 VGND VGND VPWR VPWR _02687_ sky130_fd_sc_hd__mux2_2
X_08005_ picorv32_core.cpuregs\[20\]\[27\] picorv32_core.cpuregs\[21\]\[27\] picorv32_core.cpuregs\[22\]\[27\]
+ picorv32_core.cpuregs\[23\]\[27\] net756 net723 VGND VGND VPWR VPWR _04083_ sky130_fd_sc_hd__mux4_1
XFILLER_116_440 VGND VGND VPWR VPWR sky130_fd_sc_hd__fill_1
X_05217_ net12 _01717_ _01722_ net15 _01731_ VGND VGND VPWR VPWR _01732_ sky130_fd_sc_hd__a221o_1
Xhold520 picorv32_core.cpuregs\[6\]\[11\] VGND VGND VPWR VPWR net1629 sky130_fd_sc_hd__dlygate4sd3_1
Xhold542 picorv32_core.cpuregs\[9\]\[20\] VGND VGND VPWR VPWR net1651 sky130_fd_sc_hd__dlygate4sd3_1
Xhold531 picorv32_core.cpuregs\[20\]\[18\] VGND VGND VPWR VPWR net1640 sky130_fd_sc_hd__dlygate4sd3_1
XTAP_TAPCELL_ROW_96_1693 VGND VPWR sky130_fd_sc_hd__tapvpwrvgnd_1
Xhold553 picorv32_core.cpuregs\[13\]\[16\] VGND VGND VPWR VPWR net1662 sky130_fd_sc_hd__dlygate4sd3_1
X_06197_ net632 _02625_ net624 VGND VGND VPWR VPWR _02628_ sky130_fd_sc_hd__o21a_1
Xhold597 picorv32_core.cpuregs\[12\]\[2\] VGND VGND VPWR VPWR net1706 sky130_fd_sc_hd__dlygate4sd3_1
Xhold564 picorv32_core.cpuregs\[2\]\[6\] VGND VGND VPWR VPWR net1673 sky130_fd_sc_hd__dlygate4sd3_1
XFILLER_1_217 VGND VGND VPWR VPWR sky130_fd_sc_hd__decap_6
Xhold575 picorv32_core.cpuregs\[24\]\[0\] VGND VGND VPWR VPWR net1684 sky130_fd_sc_hd__dlygate4sd3_1
X_05148_ _01674_ _01675_ VGND VGND VPWR VPWR _01676_ sky130_fd_sc_hd__nor2_1
Xhold586 picorv32_core.cpuregs\[12\]\[11\] VGND VGND VPWR VPWR net1695 sky130_fd_sc_hd__dlygate4sd3_1
XFILLER_131_476 VGND VGND VPWR VPWR sky130_fd_sc_hd__decap_4
X_05079_ net192 VGND VGND VPWR VPWR _01614_ sky130_fd_sc_hd__inv_2
XFILLER_89_379 VPWR VGND VPWR VGND sky130_ef_sc_hd__decap_12
X_09956_ net1553 net264 net318 VGND VGND VPWR VPWR _01434_ sky130_fd_sc_hd__mux2_1
X_09887_ net1223 net230 net327 VGND VGND VPWR VPWR _01375_ sky130_fd_sc_hd__mux2_1
XFILLER_112_690 VGND VGND VPWR VPWR sky130_fd_sc_hd__fill_2
X_08907_ net248 net1923 net360 VGND VGND VPWR VPWR _01081_ sky130_fd_sc_hd__mux2_1
XFILLER_58_722 VGND VGND VPWR VPWR sky130_fd_sc_hd__decap_6
Xhold1242 picorv32_core.count_instr\[24\] VGND VGND VPWR VPWR net2351 sky130_fd_sc_hd__dlygate4sd3_1
X_08838_ net1365 net260 net367 VGND VGND VPWR VPWR _01014_ sky130_fd_sc_hd__mux2_1
XFILLER_73_703 VGND VGND VPWR VPWR sky130_fd_sc_hd__decap_8
Xhold1231 picorv32_core.decoded_imm_j\[14\] VGND VGND VPWR VPWR net2340 sky130_fd_sc_hd__dlygate4sd3_1
XFILLER_58_766 VGND VGND VPWR VPWR sky130_fd_sc_hd__decap_6
Xhold1220 picorv32_core.mem_do_rdata VGND VGND VPWR VPWR net2329 sky130_fd_sc_hd__dlygate4sd3_1
Xhold1253 picorv32_core.count_instr\[27\] VGND VGND VPWR VPWR net2362 sky130_fd_sc_hd__dlygate4sd3_1
XFILLER_58_788 VGND VGND VPWR VPWR sky130_fd_sc_hd__decap_4
Xclkbuf_leaf_37_clk clknet_4_5_0_clk VGND VGND VPWR VPWR clknet_leaf_37_clk sky130_fd_sc_hd__clkbuf_8
X_08769_ net268 net1972 net375 VGND VGND VPWR VPWR _00916_ sky130_fd_sc_hd__mux2_1
XFILLER_45_438 VGND VGND VPWR VPWR sky130_fd_sc_hd__fill_1
XFILLER_45_449 VGND VGND VPWR VPWR sky130_fd_sc_hd__decap_6
XTAP_TAPCELL_ROW_123_2089 VGND VPWR sky130_fd_sc_hd__tapvpwrvgnd_1
X_10800_ clknet_leaf_0_clk _00651_ VGND VGND VPWR VPWR picorv32_core.cpuregs\[15\]\[9\]
+ sky130_fd_sc_hd__dfxtp_1
X_10731_ clknet_leaf_87_clk _00582_ VGND VGND VPWR VPWR picorv32_core.decoded_imm\[28\]
+ sky130_fd_sc_hd__dfxtp_2
XTAP_TAPCELL_ROW_0_294 VGND VPWR sky130_fd_sc_hd__tapvpwrvgnd_1
XFILLER_14_825 VGND VGND VPWR VPWR sky130_fd_sc_hd__decap_6
XFILLER_15_30 VPWR VGND VPWR VGND sky130_ef_sc_hd__decap_12
XFILLER_41_611 VGND VGND VPWR VPWR sky130_fd_sc_hd__decap_4
XFILLER_13_335 VGND VGND VPWR VPWR sky130_fd_sc_hd__fill_1
X_10662_ clknet_leaf_66_clk _00516_ VGND VGND VPWR VPWR picorv32_core.cpuregs\[20\]\[30\]
+ sky130_fd_sc_hd__dfxtp_1
XFILLER_41_688 VGND VGND VPWR VPWR sky130_fd_sc_hd__fill_1
X_10593_ clknet_leaf_93_clk _00447_ VGND VGND VPWR VPWR picorv32_core.instr_xori sky130_fd_sc_hd__dfxtp_1
XFILLER_31_73 VGND VGND VPWR VPWR sky130_fd_sc_hd__fill_2
XTAP_TAPCELL_ROW_56_1121 VGND VPWR sky130_fd_sc_hd__tapvpwrvgnd_1
XTAP_TAPCELL_ROW_56_1110 VGND VPWR sky130_fd_sc_hd__tapvpwrvgnd_1
X_11214_ clknet_leaf_110_clk _01065_ VGND VGND VPWR VPWR picorv32_core.cpuregs\[5\]\[4\]
+ sky130_fd_sc_hd__dfxtp_1
Xoutput51 net51 VGND VGND VPWR VPWR mem_axi_araddr[22] sky130_fd_sc_hd__buf_2
XFILLER_107_484 VGND VGND VPWR VPWR sky130_fd_sc_hd__fill_1
Xoutput40 net40 VGND VGND VPWR VPWR mem_axi_araddr[11] sky130_fd_sc_hd__buf_2
Xoutput84 net84 VGND VGND VPWR VPWR mem_axi_awaddr[23] sky130_fd_sc_hd__buf_2
X_11145_ clknet_leaf_62_clk _00996_ VGND VGND VPWR VPWR picorv32_core.cpuregs\[8\]\[31\]
+ sky130_fd_sc_hd__dfxtp_1
Xoutput73 net73 VGND VGND VPWR VPWR mem_axi_awaddr[12] sky130_fd_sc_hd__buf_2
Xoutput62 net62 VGND VGND VPWR VPWR mem_axi_araddr[3] sky130_fd_sc_hd__buf_2
X_11076_ clknet_leaf_46_clk _00927_ VGND VGND VPWR VPWR picorv32_core.cpuregs\[10\]\[26\]
+ sky130_fd_sc_hd__dfxtp_1
XFILLER_110_627 VGND VGND VPWR VPWR sky130_fd_sc_hd__decap_4
Xoutput95 net95 VGND VGND VPWR VPWR mem_axi_awaddr[4] sky130_fd_sc_hd__buf_2
X_10027_ net1616 net246 net310 VGND VGND VPWR VPWR _01503_ sky130_fd_sc_hd__mux2_1
XFILLER_91_522 VGND VGND VPWR VPWR sky130_fd_sc_hd__fill_2
Xclkbuf_leaf_28_clk clknet_4_4_0_clk VGND VGND VPWR VPWR clknet_leaf_28_clk sky130_fd_sc_hd__clkbuf_8
XFILLER_64_747 VGND VGND VPWR VPWR sky130_fd_sc_hd__decap_8
XFILLER_63_246 VGND VGND VPWR VPWR sky130_fd_sc_hd__fill_2
XFILLER_63_279 VGND VGND VPWR VPWR sky130_fd_sc_hd__fill_1
XFILLER_63_257 VGND VGND VPWR VPWR sky130_fd_sc_hd__fill_2
XFILLER_32_600 VGND VGND VPWR VPWR sky130_fd_sc_hd__fill_2
XTAP_TAPCELL_ROW_47_989 VGND VPWR sky130_fd_sc_hd__tapvpwrvgnd_1
XTAP_TAPCELL_ROW_67_1283 VGND VPWR sky130_fd_sc_hd__tapvpwrvgnd_1
XTAP_TAPCELL_ROW_67_1272 VGND VPWR sky130_fd_sc_hd__tapvpwrvgnd_1
X_10929_ clknet_leaf_130_clk _00780_ VGND VGND VPWR VPWR picorv32_core.cpuregs\[19\]\[7\]
+ sky130_fd_sc_hd__dfxtp_1
XTAP_TAPCELL_ROW_27_691 VGND VPWR sky130_fd_sc_hd__tapvpwrvgnd_1
XFILLER_32_666 VGND VGND VPWR VPWR sky130_fd_sc_hd__decap_8
XTAP_TAPCELL_ROW_80_1472 VGND VPWR sky130_fd_sc_hd__tapvpwrvgnd_1
XTAP_TAPCELL_ROW_80_1461 VGND VPWR sky130_fd_sc_hd__tapvpwrvgnd_1
XFILLER_20_828 VGND VGND VPWR VPWR sky130_fd_sc_hd__fill_1
XFILLER_75_3 VGND VGND VPWR VPWR sky130_fd_sc_hd__fill_1
X_06120_ net765 net954 net570 _02574_ VGND VGND VPWR VPWR _02575_ sky130_fd_sc_hd__a31o_1
X_06051_ _02510_ _02511_ VGND VGND VPWR VPWR _02512_ sky130_fd_sc_hd__or2_1
XFILLER_141_741 VGND VGND VPWR VPWR sky130_fd_sc_hd__decap_4
XFILLER_126_793 VPWR VGND VPWR VGND sky130_ef_sc_hd__decap_12
XFILLER_125_281 VGND VGND VPWR VPWR sky130_fd_sc_hd__fill_1
XFILLER_125_270 VGND VGND VPWR VPWR sky130_fd_sc_hd__fill_2
XPHY_EDGE_ROW_99_Right_99 VGND VGND VPWR VPWR sky130_fd_sc_hd__decap_3
X_09810_ picorv32_core.cpuregs\[28\]\[28\] picorv32_core.cpuregs\[29\]\[28\] picorv32_core.cpuregs\[30\]\[28\]
+ picorv32_core.cpuregs\[31\]\[28\] net896 net862 VGND VGND VPWR VPWR _04981_ sky130_fd_sc_hd__mux4_1
Xfanout307 _05042_ VGND VGND VPWR VPWR net307 sky130_fd_sc_hd__buf_4
Xfanout318 _05039_ VGND VGND VPWR VPWR net318 sky130_fd_sc_hd__clkbuf_8
XFILLER_98_154 VGND VGND VPWR VPWR sky130_fd_sc_hd__fill_1
Xfanout329 _04351_ VGND VGND VPWR VPWR net329 sky130_fd_sc_hd__buf_4
XFILLER_141_785 VGND VGND VPWR VPWR sky130_fd_sc_hd__fill_2
X_09741_ picorv32_core.cpuregs\[4\]\[25\] picorv32_core.cpuregs\[5\]\[25\] picorv32_core.cpuregs\[6\]\[25\]
+ picorv32_core.cpuregs\[7\]\[25\] net905 net870 VGND VGND VPWR VPWR _04915_ sky130_fd_sc_hd__mux4_1
XFILLER_98_187 VGND VGND VPWR VPWR sky130_fd_sc_hd__fill_1
X_06953_ _03141_ _03152_ VGND VGND VPWR VPWR _03168_ sky130_fd_sc_hd__nand2_1
XFILLER_140_295 VGND VGND VPWR VPWR sky130_fd_sc_hd__decap_4
XFILLER_67_541 VGND VGND VPWR VPWR sky130_fd_sc_hd__fill_2
X_05904_ net957 _02375_ VGND VGND VPWR VPWR _02376_ sky130_fd_sc_hd__xnor2_1
X_09672_ net611 _03517_ _04844_ _04848_ net487 VGND VGND VPWR VPWR _04849_ sky130_fd_sc_hd__a311o_1
X_06884_ net667 picorv32_core.reg_next_pc\[15\] _02927_ net490 VGND VGND VPWR VPWR
+ _03105_ sky130_fd_sc_hd__a22o_1
Xclkbuf_leaf_19_clk clknet_4_6_0_clk VGND VGND VPWR VPWR clknet_leaf_19_clk sky130_fd_sc_hd__clkbuf_8
X_08623_ net2076 net499 net391 VGND VGND VPWR VPWR _00774_ sky130_fd_sc_hd__mux2_1
XFILLER_27_449 VGND VGND VPWR VPWR sky130_fd_sc_hd__fill_1
XFILLER_36_29 VGND VGND VPWR VPWR sky130_fd_sc_hd__decap_4
X_05835_ _02311_ _02312_ VGND VGND VPWR VPWR _02313_ sky130_fd_sc_hd__and2b_1
XFILLER_82_577 VGND VGND VPWR VPWR sky130_fd_sc_hd__decap_6
X_08554_ net447 net1820 net398 VGND VGND VPWR VPWR _00679_ sky130_fd_sc_hd__mux2_1
X_05766_ net823 picorv32_core.mem_la_wdata\[0\] net573 VGND VGND VPWR VPWR _02250_
+ sky130_fd_sc_hd__a21oi_1
X_07505_ net2308 _03624_ net462 VGND VGND VPWR VPWR _00345_ sky130_fd_sc_hd__mux2_1
XFILLER_63_780 VGND VGND VPWR VPWR sky130_fd_sc_hd__decap_4
X_05697_ _02148_ _02151_ _02169_ _02180_ VGND VGND VPWR VPWR _02181_ sky130_fd_sc_hd__or4_1
X_08485_ net1652 net447 net406 VGND VGND VPWR VPWR _00615_ sky130_fd_sc_hd__mux2_1
X_07436_ _03558_ _03572_ net481 net483 VGND VGND VPWR VPWR _03576_ sky130_fd_sc_hd__a31o_1
XTAP_TAPCELL_ROW_98_1722 VGND VPWR sky130_fd_sc_hd__tapvpwrvgnd_1
X_07367_ net785 picorv32_core.decoded_imm\[18\] VGND VGND VPWR VPWR _03507_ sky130_fd_sc_hd__nand2_1
X_09106_ net248 net1788 net334 VGND VGND VPWR VPWR _01273_ sky130_fd_sc_hd__mux2_1
XTAP_TAPCELL_ROW_98_1733 VGND VPWR sky130_fd_sc_hd__tapvpwrvgnd_1
X_06318_ net1650 net269 net433 VGND VGND VPWR VPWR _00054_ sky130_fd_sc_hd__mux2_1
XFILLER_6_309 VGND VGND VPWR VPWR sky130_fd_sc_hd__decap_3
XFILLER_108_259 VGND VGND VPWR VPWR sky130_fd_sc_hd__fill_1
X_09037_ net259 net2101 net342 VGND VGND VPWR VPWR _01206_ sky130_fd_sc_hd__mux2_1
X_07298_ net801 picorv32_core.decoded_imm\[10\] VGND VGND VPWR VPWR _03438_ sky130_fd_sc_hd__or2_1
X_06249_ picorv32_core.reg_out\[2\] picorv32_core.alu_out_q\[2\] net950 VGND VGND
+ VPWR VPWR _02673_ sky130_fd_sc_hd__mux2_1
Xhold350 picorv32_core.cpuregs\[12\]\[31\] VGND VGND VPWR VPWR net1459 sky130_fd_sc_hd__dlygate4sd3_1
Xhold361 picorv32_core.cpuregs\[30\]\[21\] VGND VGND VPWR VPWR net1470 sky130_fd_sc_hd__dlygate4sd3_1
XFILLER_104_421 VPWR VGND VPWR VGND sky130_ef_sc_hd__decap_12
XFILLER_7_6 VPWR VGND VPWR VGND sky130_ef_sc_hd__decap_12
Xhold394 picorv32_core.cpuregs\[11\]\[30\] VGND VGND VPWR VPWR net1503 sky130_fd_sc_hd__dlygate4sd3_1
XFILLER_89_132 VGND VGND VPWR VPWR sky130_fd_sc_hd__decap_6
Xhold383 picorv32_core.cpuregs\[4\]\[15\] VGND VGND VPWR VPWR net1492 sky130_fd_sc_hd__dlygate4sd3_1
Xhold372 picorv32_core.cpuregs\[31\]\[12\] VGND VGND VPWR VPWR net1481 sky130_fd_sc_hd__dlygate4sd3_1
Xfanout852 net854 VGND VGND VPWR VPWR net852 sky130_fd_sc_hd__clkbuf_2
Xfanout841 net850 VGND VGND VPWR VPWR net841 sky130_fd_sc_hd__clkbuf_4
Xfanout830 net831 VGND VGND VPWR VPWR net830 sky130_fd_sc_hd__buf_4
Xfanout863 net865 VGND VGND VPWR VPWR net863 sky130_fd_sc_hd__clkbuf_4
Xclkbuf_4_13_0_clk clknet_0_clk VGND VGND VPWR VPWR clknet_4_13_0_clk sky130_fd_sc_hd__clkbuf_8
XTAP_TAPCELL_ROW_51_1051 VGND VPWR sky130_fd_sc_hd__tapvpwrvgnd_1
XTAP_TAPCELL_ROW_51_1040 VGND VPWR sky130_fd_sc_hd__tapvpwrvgnd_1
Xfanout885 net907 VGND VGND VPWR VPWR net885 sky130_fd_sc_hd__clkbuf_4
Xfanout874 net883 VGND VGND VPWR VPWR net874 sky130_fd_sc_hd__buf_4
X_09939_ _02664_ _04325_ VGND VGND VPWR VPWR _05039_ sky130_fd_sc_hd__nor2_4
XTAP_TAPCELL_ROW_125_2118 VGND VPWR sky130_fd_sc_hd__tapvpwrvgnd_1
Xfanout896 net900 VGND VGND VPWR VPWR net896 sky130_fd_sc_hd__buf_4
XFILLER_100_660 VGND VGND VPWR VPWR sky130_fd_sc_hd__fill_2
Xhold1050 picorv32_core.cpuregs\[10\]\[18\] VGND VGND VPWR VPWR net2159 sky130_fd_sc_hd__dlygate4sd3_1
XFILLER_93_13 VGND VGND VPWR VPWR sky130_fd_sc_hd__decap_3
XFILLER_85_371 VGND VGND VPWR VPWR sky130_fd_sc_hd__fill_2
XTAP_TAPCELL_ROW_5_375 VGND VPWR sky130_fd_sc_hd__tapvpwrvgnd_1
Xhold1083 picorv32_core.cpuregs\[11\]\[31\] VGND VGND VPWR VPWR net2192 sky130_fd_sc_hd__dlygate4sd3_1
Xhold1072 picorv32_core.cpuregs\[25\]\[30\] VGND VGND VPWR VPWR net2181 sky130_fd_sc_hd__dlygate4sd3_1
Xhold1061 picorv32_core.cpuregs\[4\]\[21\] VGND VGND VPWR VPWR net2170 sky130_fd_sc_hd__dlygate4sd3_1
XFILLER_100_682 VGND VGND VPWR VPWR sky130_fd_sc_hd__decap_4
Xhold1094 picorv32_core.cpuregs\[16\]\[8\] VGND VGND VPWR VPWR net2203 sky130_fd_sc_hd__dlygate4sd3_1
XTAP_TAPCELL_ROW_107_1862 VGND VPWR sky130_fd_sc_hd__tapvpwrvgnd_1
XTAP_TAPCELL_ROW_107_1851 VGND VPWR sky130_fd_sc_hd__tapvpwrvgnd_1
X_11832_ net65 VGND VGND VPWR VPWR net97 sky130_fd_sc_hd__clkbuf_1
XTAP_TAPCELL_ROW_44_937 VGND VPWR sky130_fd_sc_hd__tapvpwrvgnd_1
XTAP_TAPCELL_ROW_44_948 VGND VPWR sky130_fd_sc_hd__tapvpwrvgnd_1
X_10714_ clknet_leaf_6_clk _00565_ VGND VGND VPWR VPWR net120 sky130_fd_sc_hd__dfxtp_1
X_11694_ clknet_leaf_11_clk _01525_ VGND VGND VPWR VPWR picorv32_core.cpuregs\[27\]\[11\]
+ sky130_fd_sc_hd__dfxtp_1
XFILLER_14_699 VGND VGND VPWR VPWR sky130_fd_sc_hd__fill_1
XTAP_TAPCELL_ROW_24_650 VGND VPWR sky130_fd_sc_hd__tapvpwrvgnd_1
X_10645_ clknet_leaf_14_clk _00499_ VGND VGND VPWR VPWR picorv32_core.cpuregs\[20\]\[13\]
+ sky130_fd_sc_hd__dfxtp_1
X_10576_ clknet_leaf_98_clk _00430_ VGND VGND VPWR VPWR picorv32_core.instr_lui sky130_fd_sc_hd__dfxtp_1
XFILLER_107_281 VGND VGND VPWR VPWR sky130_fd_sc_hd__fill_2
XFILLER_107_270 VGND VGND VPWR VPWR sky130_fd_sc_hd__fill_1
XFILLER_47_7 VPWR VGND VPWR VGND sky130_ef_sc_hd__decap_12
XFILLER_123_741 VPWR VGND VPWR VGND sky130_ef_sc_hd__decap_12
XFILLER_123_785 VPWR VGND VPWR VGND sky130_ef_sc_hd__decap_12
XFILLER_110_402 VGND VGND VPWR VPWR sky130_fd_sc_hd__fill_2
XFILLER_95_113 VGND VGND VPWR VPWR sky130_fd_sc_hd__decap_4
X_11128_ clknet_leaf_23_clk _00979_ VGND VGND VPWR VPWR picorv32_core.cpuregs\[8\]\[14\]
+ sky130_fd_sc_hd__dfxtp_1
XFILLER_3_55 VGND VGND VPWR VPWR sky130_fd_sc_hd__fill_1
XFILLER_84_809 VGND VGND VPWR VPWR sky130_fd_sc_hd__decap_3
XFILLER_49_530 VGND VGND VPWR VPWR sky130_fd_sc_hd__fill_2
XFILLER_110_468 VGND VGND VPWR VPWR sky130_fd_sc_hd__fill_2
XTAP_TAPCELL_ROW_69_1312 VGND VPWR sky130_fd_sc_hd__tapvpwrvgnd_1
XTAP_TAPCELL_ROW_69_1301 VGND VPWR sky130_fd_sc_hd__tapvpwrvgnd_1
X_11059_ clknet_leaf_0_clk _00910_ VGND VGND VPWR VPWR picorv32_core.cpuregs\[10\]\[9\]
+ sky130_fd_sc_hd__dfxtp_1
X_05620_ _02102_ _02103_ _02104_ _02092_ VGND VGND VPWR VPWR _02106_ sky130_fd_sc_hd__a211o_1
XFILLER_52_717 VGND VGND VPWR VPWR sky130_fd_sc_hd__decap_3
XTAP_TAPCELL_ROW_82_1501 VGND VPWR sky130_fd_sc_hd__tapvpwrvgnd_1
XFILLER_17_482 VGND VGND VPWR VPWR sky130_fd_sc_hd__decap_4
X_05551_ picorv32_core.reg_pc\[25\] picorv32_core.decoded_imm\[25\] VGND VGND VPWR
+ VPWR _02042_ sky130_fd_sc_hd__or2_1
XFILLER_17_493 VGND VGND VPWR VPWR sky130_fd_sc_hd__decap_3
X_05482_ picorv32_core.reg_pc\[20\] picorv32_core.decoded_imm\[20\] VGND VGND VPWR
+ VPWR _01978_ sky130_fd_sc_hd__or2_1
XFILLER_32_463 VGND VGND VPWR VPWR sky130_fd_sc_hd__decap_4
X_08270_ net1382 net426 net410 VGND VGND VPWR VPWR _00494_ sky130_fd_sc_hd__mux2_1
X_07221_ net2266 _03369_ net994 VGND VGND VPWR VPWR _03371_ sky130_fd_sc_hd__o21ai_1
X_07152_ picorv32_core.count_cycle\[28\] _03324_ picorv32_core.count_cycle\[29\] VGND
+ VGND VPWR VPWR _03327_ sky130_fd_sc_hd__a21o_1
X_06103_ _02159_ net571 _02557_ _02559_ VGND VGND VPWR VPWR picorv32_core.alu_out\[27\]
+ sky130_fd_sc_hd__a211o_1
Xclkbuf_leaf_8_clk clknet_4_1_0_clk VGND VGND VPWR VPWR clknet_leaf_8_clk sky130_fd_sc_hd__clkbuf_8
X_07083_ picorv32_core.count_cycle\[0\] picorv32_core.count_cycle\[1\] picorv32_core.count_cycle\[2\]
+ picorv32_core.count_cycle\[3\] VGND VGND VPWR VPWR _03284_ sky130_fd_sc_hd__and4_1
X_06034_ net187 _02495_ VGND VGND VPWR VPWR _02496_ sky130_fd_sc_hd__xnor2_1
XTAP_TAPCELL_ROW_93_1652 VGND VPWR sky130_fd_sc_hd__tapvpwrvgnd_1
XFILLER_86_102 VGND VGND VPWR VPWR sky130_fd_sc_hd__fill_1
X_07985_ picorv32_core.cpuregs\[0\]\[26\] picorv32_core.cpuregs\[1\]\[26\] picorv32_core.cpuregs\[2\]\[26\]
+ picorv32_core.cpuregs\[3\]\[26\] net760 net727 VGND VGND VPWR VPWR _04064_ sky130_fd_sc_hd__mux4_1
X_09724_ picorv32_core.cpuregs\[0\]\[24\] picorv32_core.cpuregs\[1\]\[24\] picorv32_core.cpuregs\[2\]\[24\]
+ picorv32_core.cpuregs\[3\]\[24\] net894 net860 VGND VGND VPWR VPWR _04899_ sky130_fd_sc_hd__mux4_1
X_06936_ net934 _02932_ VGND VGND VPWR VPWR _03152_ sky130_fd_sc_hd__or2_1
X_09655_ picorv32_core.cpuregs\[0\]\[21\] picorv32_core.cpuregs\[1\]\[21\] picorv32_core.cpuregs\[2\]\[21\]
+ picorv32_core.cpuregs\[3\]\[21\] net897 net863 VGND VGND VPWR VPWR _04833_ sky130_fd_sc_hd__mux4_1
XFILLER_95_680 VPWR VGND VPWR VGND sky130_ef_sc_hd__decap_12
X_06867_ net676 _03087_ _03088_ VGND VGND VPWR VPWR _03089_ sky130_fd_sc_hd__or3_1
XFILLER_67_393 VGND VGND VPWR VPWR sky130_fd_sc_hd__fill_1
XFILLER_55_511 VGND VGND VPWR VPWR sky130_fd_sc_hd__fill_1
XTAP_TAPCELL_ROW_2_334 VGND VPWR sky130_fd_sc_hd__tapvpwrvgnd_1
X_08606_ net240 net1870 net396 VGND VGND VPWR VPWR _00729_ sky130_fd_sc_hd__mux2_1
XFILLER_27_246 VGND VGND VPWR VPWR sky130_fd_sc_hd__decap_4
XFILLER_28_769 VPWR VGND VPWR VGND sky130_ef_sc_hd__decap_12
X_05818_ net811 _02295_ VGND VGND VPWR VPWR _02297_ sky130_fd_sc_hd__nor2_1
X_09586_ net659 _04766_ VGND VGND VPWR VPWR _04767_ sky130_fd_sc_hd__or2_1
XFILLER_63_49 VGND VGND VPWR VPWR sky130_fd_sc_hd__decap_6
X_06798_ _03001_ _03016_ _03017_ VGND VGND VPWR VPWR _03025_ sky130_fd_sc_hd__o21a_1
XTAP_TAPCELL_ROW_120_2048 VGND VPWR sky130_fd_sc_hd__tapvpwrvgnd_1
X_08537_ net1396 net241 net404 VGND VGND VPWR VPWR _00664_ sky130_fd_sc_hd__mux2_1
X_05749_ net783 _01610_ _02148_ _02231_ _02232_ VGND VGND VPWR VPWR _02233_ sky130_fd_sc_hd__o221a_1
XFILLER_51_772 VGND VGND VPWR VPWR sky130_fd_sc_hd__decap_8
XFILLER_11_614 VGND VGND VPWR VPWR sky130_fd_sc_hd__fill_2
X_08468_ picorv32_core.decoded_imm\[4\] net527 _04314_ _04315_ VGND VGND VPWR VPWR
+ _00606_ sky130_fd_sc_hd__o22a_1
X_07419_ picorv32_core.cpuregs\[28\]\[31\] picorv32_core.cpuregs\[29\]\[31\] picorv32_core.cpuregs\[30\]\[31\]
+ picorv32_core.cpuregs\[31\]\[31\] net902 net868 VGND VGND VPWR VPWR _03559_ sky130_fd_sc_hd__mux4_1
XTAP_TAPCELL_ROW_102_1781 VGND VPWR sky130_fd_sc_hd__tapvpwrvgnd_1
XFILLER_137_833 VGND VGND VPWR VPWR sky130_fd_sc_hd__fill_1
X_10430_ clknet_leaf_58_clk _01562_ VGND VGND VPWR VPWR picorv32_core.reg_out\[23\]
+ sky130_fd_sc_hd__dfxtp_1
Xwire549 net550 VGND VGND VPWR VPWR net549 sky130_fd_sc_hd__buf_1
X_08399_ net925 net824 net822 VGND VGND VPWR VPWR _04276_ sky130_fd_sc_hd__o21ai_1
XFILLER_12_53 VPWR VGND VPWR VGND sky130_ef_sc_hd__decap_12
XFILLER_6_139 VGND VGND VPWR VPWR sky130_fd_sc_hd__fill_1
XFILLER_128_53 VPWR VGND VPWR VGND sky130_ef_sc_hd__decap_12
X_10361_ clknet_leaf_82_clk _00280_ VGND VGND VPWR VPWR picorv32_core.count_cycle\[19\]
+ sky130_fd_sc_hd__dfxtp_1
X_10292_ clknet_leaf_90_clk _00211_ VGND VGND VPWR VPWR picorv32_core.reg_pc\[13\]
+ sky130_fd_sc_hd__dfxtp_1
XTAP_TAPCELL_ROW_131_2199 VGND VPWR sky130_fd_sc_hd__tapvpwrvgnd_1
XFILLER_104_240 VGND VGND VPWR VPWR sky130_fd_sc_hd__decap_4
Xhold180 picorv32_core.cpuregs\[3\]\[5\] VGND VGND VPWR VPWR net1289 sky130_fd_sc_hd__dlygate4sd3_1
XFILLER_105_796 VGND VGND VPWR VPWR sky130_fd_sc_hd__fill_2
XFILLER_105_785 VGND VGND VPWR VPWR sky130_fd_sc_hd__decap_4
Xhold191 picorv32_core.cpuregs\[31\]\[19\] VGND VGND VPWR VPWR net1300 sky130_fd_sc_hd__dlygate4sd3_1
XFILLER_78_636 VGND VGND VPWR VPWR sky130_fd_sc_hd__decap_8
XFILLER_77_113 VGND VGND VPWR VPWR sky130_fd_sc_hd__decap_4
XFILLER_120_733 VPWR VGND VPWR VGND sky130_ef_sc_hd__decap_12
Xfanout660 net662 VGND VGND VPWR VPWR net660 sky130_fd_sc_hd__buf_4
Xfanout671 net672 VGND VGND VPWR VPWR net671 sky130_fd_sc_hd__clkbuf_2
XFILLER_77_157 VGND VGND VPWR VPWR sky130_fd_sc_hd__decap_3
Xfanout693 net694 VGND VGND VPWR VPWR net693 sky130_fd_sc_hd__clkbuf_4
Xfanout682 net683 VGND VGND VPWR VPWR net682 sky130_fd_sc_hd__clkbuf_4
XTAP_TAPCELL_ROW_29_720 VGND VPWR sky130_fd_sc_hd__tapvpwrvgnd_1
XTAP_TAPCELL_ROW_29_731 VGND VPWR sky130_fd_sc_hd__tapvpwrvgnd_1
XFILLER_46_522 VGND VGND VPWR VPWR sky130_fd_sc_hd__decap_3
XTAP_TAPCELL_ROW_64_1231 VGND VPWR sky130_fd_sc_hd__tapvpwrvgnd_1
XFILLER_14_441 VGND VGND VPWR VPWR sky130_fd_sc_hd__decap_4
XTAP_TAPCELL_ROW_138_2309 VGND VPWR sky130_fd_sc_hd__tapvpwrvgnd_1
XFILLER_128_811 VGND VGND VPWR VPWR sky130_fd_sc_hd__fill_1
X_11677_ clknet_leaf_47_clk _01508_ VGND VGND VPWR VPWR picorv32_core.cpuregs\[26\]\[26\]
+ sky130_fd_sc_hd__dfxtp_1
XFILLER_139_181 VPWR VGND VPWR VGND sky130_ef_sc_hd__decap_12
XFILLER_127_310 VGND VGND VPWR VPWR sky130_fd_sc_hd__fill_1
X_10628_ clknet_leaf_98_clk _00482_ VGND VGND VPWR VPWR picorv32_core.decoded_imm_j\[13\]
+ sky130_fd_sc_hd__dfxtp_1
X_10559_ clknet_leaf_16_clk _00413_ VGND VGND VPWR VPWR picorv32_core.cpuregs\[25\]\[15\]
+ sky130_fd_sc_hd__dfxtp_1
XFILLER_5_161 VGND VGND VPWR VPWR sky130_fd_sc_hd__decap_6
XTAP_TAPCELL_ROW_75_1393 VGND VPWR sky130_fd_sc_hd__tapvpwrvgnd_1
XFILLER_69_614 VGND VGND VPWR VPWR sky130_fd_sc_hd__fill_2
XFILLER_38_3 VGND VGND VPWR VPWR sky130_fd_sc_hd__decap_4
XFILLER_111_777 VGND VGND VPWR VPWR sky130_fd_sc_hd__decap_6
XFILLER_96_477 VGND VGND VPWR VPWR sky130_fd_sc_hd__fill_1
XFILLER_84_606 VPWR VGND VPWR VGND sky130_ef_sc_hd__decap_12
X_07770_ picorv32_core.cpuregs\[12\]\[14\] picorv32_core.cpuregs\[13\]\[14\] picorv32_core.cpuregs\[14\]\[14\]
+ picorv32_core.cpuregs\[15\]\[14\] net737 net704 VGND VGND VPWR VPWR _03861_ sky130_fd_sc_hd__mux4_1
X_06721_ picorv32_core.decoded_imm_j\[3\] _02915_ VGND VGND VPWR VPWR _02954_ sky130_fd_sc_hd__and2_1
XFILLER_92_650 VPWR VGND VPWR VGND sky130_ef_sc_hd__decap_12
X_09440_ _04624_ _04625_ net654 VGND VGND VPWR VPWR _04628_ sky130_fd_sc_hd__mux2_1
XFILLER_92_683 VGND VGND VPWR VPWR sky130_fd_sc_hd__fill_1
XFILLER_80_823 VGND VGND VPWR VPWR sky130_fd_sc_hd__fill_1
XFILLER_64_385 VGND VGND VPWR VPWR sky130_fd_sc_hd__decap_4
XFILLER_64_363 VGND VGND VPWR VPWR sky130_fd_sc_hd__fill_1
X_06652_ picorv32_core.reg_pc\[3\] net551 _02915_ net514 VGND VGND VPWR VPWR _00201_
+ sky130_fd_sc_hd__a22o_1
X_05603_ net2357 _02083_ _02084_ _02090_ VGND VGND VPWR VPWR _01567_ sky130_fd_sc_hd__a31o_1
XFILLER_91_193 VGND VGND VPWR VPWR sky130_fd_sc_hd__fill_2
X_06583_ picorv32_core.count_instr\[42\] _02869_ net974 VGND VGND VPWR VPWR _02871_
+ sky130_fd_sc_hd__a21oi_1
X_09371_ _04558_ _04559_ net655 VGND VGND VPWR VPWR _04562_ sky130_fd_sc_hd__mux2_1
X_05534_ net912 net302 _02022_ _02026_ VGND VGND VPWR VPWR _02027_ sky130_fd_sc_hd__a31o_1
X_08322_ picorv32_core.mem_do_wdata _03584_ VGND VGND VPWR VPWR _04235_ sky130_fd_sc_hd__and2_4
X_08253_ picorv32_core.mem_rdata_q\[30\] net27 net520 VGND VGND VPWR VPWR _00771_
+ sky130_fd_sc_hd__mux2_1
X_05465_ picorv32_core.count_cycle\[18\] net601 VGND VGND VPWR VPWR _01963_ sky130_fd_sc_hd__or2_1
X_07204_ net2268 _03358_ net991 VGND VGND VPWR VPWR _03360_ sky130_fd_sc_hd__o21ai_1
XFILLER_119_833 VGND VGND VPWR VPWR sky130_fd_sc_hd__fill_1
X_05396_ picorv32_core.count_instr\[13\] net940 net602 _01898_ VGND VGND VPWR VPWR
+ _01899_ sky130_fd_sc_hd__a211o_1
X_08184_ net1164 net522 _04186_ _04197_ VGND VGND VPWR VPWR _00442_ sky130_fd_sc_hd__a22o_1
XFILLER_20_477 VGND VGND VPWR VPWR sky130_fd_sc_hd__fill_2
XFILLER_20_488 VGND VGND VPWR VPWR sky130_fd_sc_hd__fill_1
XFILLER_134_825 VGND VGND VPWR VPWR sky130_fd_sc_hd__decap_8
XFILLER_106_505 VGND VGND VPWR VPWR sky130_fd_sc_hd__fill_1
X_07135_ net2334 _03314_ _03316_ VGND VGND VPWR VPWR _00283_ sky130_fd_sc_hd__o21a_1
XFILLER_133_313 VGND VGND VPWR VPWR sky130_fd_sc_hd__fill_2
X_07066_ _03270_ _03271_ net990 VGND VGND VPWR VPWR _00259_ sky130_fd_sc_hd__o21a_1
X_06017_ net507 _02479_ _02480_ VGND VGND VPWR VPWR _02481_ sky130_fd_sc_hd__and3_1
XTAP_TAPCELL_ROW_7_404 VGND VPWR sky130_fd_sc_hd__tapvpwrvgnd_1
XFILLER_59_113 VGND VGND VPWR VPWR sky130_fd_sc_hd__decap_3
X_07968_ picorv32_core.cpuregs\[4\]\[25\] picorv32_core.cpuregs\[5\]\[25\] picorv32_core.cpuregs\[6\]\[25\]
+ picorv32_core.cpuregs\[7\]\[25\] net763 net730 VGND VGND VPWR VPWR _04048_ sky130_fd_sc_hd__mux4_1
XFILLER_102_777 VGND VGND VPWR VPWR sky130_fd_sc_hd__decap_4
XFILLER_87_466 VGND VGND VPWR VPWR sky130_fd_sc_hd__fill_1
X_09707_ net833 _04880_ _04882_ net480 VGND VGND VPWR VPWR _04883_ sky130_fd_sc_hd__o211a_1
X_06919_ _03135_ _03136_ VGND VGND VPWR VPWR _03137_ sky130_fd_sc_hd__or2_1
X_07899_ picorv32_core.cpuregs\[12\]\[21\] picorv32_core.cpuregs\[13\]\[21\] picorv32_core.cpuregs\[14\]\[21\]
+ picorv32_core.cpuregs\[15\]\[21\] net757 net724 VGND VGND VPWR VPWR _03983_ sky130_fd_sc_hd__mux4_1
XTAP_TAPCELL_ROW_104_1810 VGND VPWR sky130_fd_sc_hd__tapvpwrvgnd_1
X_09638_ _04811_ _04812_ net838 VGND VGND VPWR VPWR _04817_ sky130_fd_sc_hd__mux2_1
XFILLER_43_514 VGND VGND VPWR VPWR sky130_fd_sc_hd__fill_1
X_09569_ net657 _04747_ net650 VGND VGND VPWR VPWR _04751_ sky130_fd_sc_hd__o21a_1
XFILLER_43_536 VGND VGND VPWR VPWR sky130_fd_sc_hd__fill_1
XFILLER_130_65 VPWR VGND VPWR VGND sky130_ef_sc_hd__decap_12
X_11600_ clknet_leaf_10_clk _01431_ VGND VGND VPWR VPWR picorv32_core.cpuregs\[23\]\[13\]
+ sky130_fd_sc_hd__dfxtp_1
X_11531_ clknet_leaf_10_clk _01362_ VGND VGND VPWR VPWR picorv32_core.cpuregs\[30\]\[12\]
+ sky130_fd_sc_hd__dfxtp_1
XFILLER_11_400 VGND VGND VPWR VPWR sky130_fd_sc_hd__fill_1
XFILLER_7_415 VGND VGND VPWR VPWR sky130_fd_sc_hd__fill_1
X_11462_ clknet_leaf_13_clk _01298_ VGND VGND VPWR VPWR picorv32_core.cpuregs\[24\]\[13\]
+ sky130_fd_sc_hd__dfxtp_1
XTAP_TAPCELL_ROW_133_2239 VGND VPWR sky130_fd_sc_hd__tapvpwrvgnd_1
XTAP_TAPCELL_ROW_133_2228 VGND VPWR sky130_fd_sc_hd__tapvpwrvgnd_1
X_11393_ clknet_leaf_129_clk _01229_ VGND VGND VPWR VPWR picorv32_core.cpuregs\[31\]\[8\]
+ sky130_fd_sc_hd__dfxtp_1
X_10413_ clknet_leaf_123_clk _01575_ VGND VGND VPWR VPWR picorv32_core.reg_out\[6\]
+ sky130_fd_sc_hd__dfxtp_1
X_10344_ clknet_leaf_104_clk _00263_ VGND VGND VPWR VPWR picorv32_core.count_cycle\[2\]
+ sky130_fd_sc_hd__dfxtp_1
XTAP_TAPCELL_ROW_115_1972 VGND VPWR sky130_fd_sc_hd__tapvpwrvgnd_1
X_10275_ clknet_leaf_74_clk _00194_ VGND VGND VPWR VPWR picorv32_core.count_instr\[59\]
+ sky130_fd_sc_hd__dfxtp_1
XFILLER_2_153 VPWR VGND VPWR VGND sky130_ef_sc_hd__decap_12
XFILLER_2_197 VPWR VGND VPWR VGND sky130_ef_sc_hd__decap_12
XFILLER_78_477 VGND VGND VPWR VPWR sky130_fd_sc_hd__decap_3
XFILLER_93_447 VGND VGND VPWR VPWR sky130_fd_sc_hd__fill_1
Xfanout490 _02973_ VGND VGND VPWR VPWR net490 sky130_fd_sc_hd__clkbuf_4
XFILLER_62_801 VGND VGND VPWR VPWR sky130_fd_sc_hd__decap_6
XFILLER_0_12 VPWR VGND VPWR VGND sky130_ef_sc_hd__decap_12
XPHY_EDGE_ROW_100_Left_242 VGND VGND VPWR VPWR sky130_fd_sc_hd__decap_3
XFILLER_64_81 VGND VGND VPWR VPWR sky130_fd_sc_hd__decap_3
XFILLER_9_54 VGND VGND VPWR VPWR sky130_fd_sc_hd__fill_2
XFILLER_15_783 VGND VGND VPWR VPWR sky130_fd_sc_hd__fill_1
XTAP_TAPCELL_ROW_12_472 VGND VPWR sky130_fd_sc_hd__tapvpwrvgnd_1
X_05250_ net915 net166 _01759_ net908 _01762_ VGND VGND VPWR VPWR _01763_ sky130_fd_sc_hd__a221o_1
XTAP_TAPCELL_ROW_77_1422 VGND VPWR sky130_fd_sc_hd__tapvpwrvgnd_1
XTAP_TAPCELL_ROW_12_483 VGND VPWR sky130_fd_sc_hd__tapvpwrvgnd_1
X_05181_ net980 _01671_ _01703_ VGND VGND VPWR VPWR _00012_ sky130_fd_sc_hd__and3_1
Xhold927 picorv32_core.cpuregs\[12\]\[23\] VGND VGND VPWR VPWR net2036 sky130_fd_sc_hd__dlygate4sd3_1
XFILLER_127_184 VGND VGND VPWR VPWR sky130_fd_sc_hd__decap_6
XFILLER_116_825 VGND VGND VPWR VPWR sky130_fd_sc_hd__decap_4
Xhold905 picorv32_core.cpuregs\[1\]\[5\] VGND VGND VPWR VPWR net2014 sky130_fd_sc_hd__dlygate4sd3_1
Xhold916 picorv32_core.cpuregs\[18\]\[5\] VGND VGND VPWR VPWR net2025 sky130_fd_sc_hd__dlygate4sd3_1
Xhold949 picorv32_core.cpuregs\[2\]\[30\] VGND VGND VPWR VPWR net2058 sky130_fd_sc_hd__dlygate4sd3_1
Xhold938 picorv32_core.cpuregs\[15\]\[21\] VGND VGND VPWR VPWR net2047 sky130_fd_sc_hd__dlygate4sd3_1
X_08940_ net248 net2124 net355 VGND VGND VPWR VPWR _01113_ sky130_fd_sc_hd__mux2_1
XTAP_TAPCELL_ROW_90_1611 VGND VPWR sky130_fd_sc_hd__tapvpwrvgnd_1
X_08871_ net259 net2031 net363 VGND VGND VPWR VPWR _01046_ sky130_fd_sc_hd__mux2_1
X_07822_ picorv32_core.cpuregs\[0\]\[17\] picorv32_core.cpuregs\[1\]\[17\] picorv32_core.cpuregs\[2\]\[17\]
+ picorv32_core.cpuregs\[3\]\[17\] net747 net714 VGND VGND VPWR VPWR _03910_ sky130_fd_sc_hd__mux4_1
XFILLER_69_488 VGND VGND VPWR VPWR sky130_fd_sc_hd__fill_2
X_07753_ picorv32_core.cpuregs\[0\]\[13\] picorv32_core.cpuregs\[1\]\[13\] picorv32_core.cpuregs\[2\]\[13\]
+ picorv32_core.cpuregs\[3\]\[13\] net740 net707 VGND VGND VPWR VPWR _03845_ sky130_fd_sc_hd__mux4_1
X_06704_ picorv32_core.reg_pc\[29\] net553 _02941_ net516 VGND VGND VPWR VPWR _00227_
+ sky130_fd_sc_hd__a22o_1
XTAP_TAPCELL_ROW_88_1584 VGND VPWR sky130_fd_sc_hd__tapvpwrvgnd_1
X_07684_ _03770_ _03778_ _03779_ net617 net687 VGND VGND VPWR VPWR _03780_ sky130_fd_sc_hd__a221o_1
X_06635_ _02904_ net997 _02903_ VGND VGND VPWR VPWR _00195_ sky130_fd_sc_hd__and3b_1
X_09423_ _03436_ _04610_ VGND VGND VPWR VPWR _04611_ sky130_fd_sc_hd__xnor2_1
XFILLER_37_396 VGND VGND VPWR VPWR sky130_fd_sc_hd__decap_4
XFILLER_44_29 VGND VGND VPWR VPWR sky130_fd_sc_hd__decap_3
XFILLER_52_377 VGND VGND VPWR VPWR sky130_fd_sc_hd__fill_1
X_09354_ net282 _04529_ _04544_ _04545_ VGND VGND VPWR VPWR _01326_ sky130_fd_sc_hd__a31o_1
XFILLER_40_517 VPWR VGND VPWR VGND sky130_ef_sc_hd__decap_12
X_06566_ _02859_ _02860_ VGND VGND VPWR VPWR _00170_ sky130_fd_sc_hd__nor2_1
X_08305_ picorv32_core.is_sb_sh_sw picorv32_core.mem_rdata_q\[7\] picorv32_core.mem_rdata_q\[20\]
+ _04227_ net525 VGND VGND VPWR VPWR _04228_ sky130_fd_sc_hd__a221o_1
X_05517_ net18 net583 net574 VGND VGND VPWR VPWR _02011_ sky130_fd_sc_hd__a21o_1
X_06497_ _02815_ _02816_ VGND VGND VPWR VPWR _00145_ sky130_fd_sc_hd__nor2_1
XFILLER_21_753 VPWR VGND VPWR VGND sky130_ef_sc_hd__decap_12
X_09285_ net814 net281 _04478_ _04479_ VGND VGND VPWR VPWR _01323_ sky130_fd_sc_hd__a22o_1
X_05448_ picorv32_core.reg_pc\[16\] picorv32_core.decoded_imm\[16\] _01944_ VGND VGND
+ VPWR VPWR _01947_ sky130_fd_sc_hd__and3_1
X_08236_ _04217_ _04220_ VGND VGND VPWR VPWR _04221_ sky130_fd_sc_hd__or2_1
XFILLER_21_797 VGND VGND VPWR VPWR sky130_fd_sc_hd__fill_1
X_08167_ net930 picorv32_core.mem_rdata_q\[13\] net929 VGND VGND VPWR VPWR _04189_
+ sky130_fd_sc_hd__and3_1
XFILLER_107_836 VGND VGND VPWR VPWR sky130_fd_sc_hd__fill_1
X_07118_ picorv32_core.count_cycle\[16\] _03304_ net976 VGND VGND VPWR VPWR _03306_
+ sky130_fd_sc_hd__a21oi_1
X_05379_ _01804_ _01809_ _01831_ _01837_ _01882_ VGND VGND VPWR VPWR _01883_ sky130_fd_sc_hd__o2111a_1
XFILLER_106_357 VGND VGND VPWR VPWR sky130_fd_sc_hd__decap_6
X_08098_ _01580_ net675 net970 _04165_ _04168_ VGND VGND VPWR VPWR _04169_ sky130_fd_sc_hd__a311o_1
X_07049_ net933 _02941_ VGND VGND VPWR VPWR _03256_ sky130_fd_sc_hd__and2_1
X_10060_ net1386 net246 net306 VGND VGND VPWR VPWR _01535_ sky130_fd_sc_hd__mux2_1
XFILLER_102_530 VGND VGND VPWR VPWR sky130_fd_sc_hd__fill_2
XFILLER_88_742 VGND VGND VPWR VPWR sky130_fd_sc_hd__decap_6
XFILLER_88_731 VGND VGND VPWR VPWR sky130_fd_sc_hd__fill_1
XFILLER_102_563 VPWR VGND VPWR VGND sky130_ef_sc_hd__decap_12
XFILLER_0_657 VGND VGND VPWR VPWR sky130_fd_sc_hd__decap_4
XFILLER_29_831 VGND VGND VPWR VPWR sky130_fd_sc_hd__decap_3
XFILLER_18_41 VPWR VGND VPWR VGND sky130_ef_sc_hd__decap_12
XFILLER_28_330 VGND VGND VPWR VPWR sky130_fd_sc_hd__decap_4
XFILLER_141_53 VGND VGND VPWR VPWR sky130_fd_sc_hd__decap_3
X_10962_ clknet_leaf_12_clk _00813_ VGND VGND VPWR VPWR picorv32_core.cpuregs\[13\]\[8\]
+ sky130_fd_sc_hd__dfxtp_1
XTAP_TAPCELL_ROW_39_870 VGND VPWR sky130_fd_sc_hd__tapvpwrvgnd_1
XFILLER_44_801 VGND VGND VPWR VPWR sky130_fd_sc_hd__fill_1
XTAP_TAPCELL_ROW_48_1001 VGND VPWR sky130_fd_sc_hd__tapvpwrvgnd_1
XFILLER_141_97 VPWR VGND VPWR VGND sky130_ef_sc_hd__decap_12
XFILLER_43_333 VGND VGND VPWR VPWR sky130_fd_sc_hd__decap_3
X_10893_ clknet_leaf_99_clk _00744_ VGND VGND VPWR VPWR picorv32_core.mem_rdata_q\[3\]
+ sky130_fd_sc_hd__dfxtp_1
XFILLER_31_517 VGND VGND VPWR VPWR sky130_fd_sc_hd__decap_6
XFILLER_43_377 VGND VGND VPWR VPWR sky130_fd_sc_hd__decap_3
XFILLER_12_753 VGND VGND VPWR VPWR sky130_fd_sc_hd__decap_3
X_11514_ clknet_leaf_95_clk _00020_ VGND VGND VPWR VPWR _00000_ sky130_fd_sc_hd__dfxtp_2
X_11445_ clknet_leaf_37_clk _01281_ VGND VGND VPWR VPWR picorv32_core.cpuregs\[1\]\[28\]
+ sky130_fd_sc_hd__dfxtp_1
XFILLER_8_757 VPWR VGND VPWR VGND sky130_ef_sc_hd__decap_12
X_11376_ clknet_leaf_36_clk _01217_ VGND VGND VPWR VPWR picorv32_core.cpuregs\[18\]\[28\]
+ sky130_fd_sc_hd__dfxtp_1
XTAP_TAPCELL_ROW_59_1163 VGND VPWR sky130_fd_sc_hd__tapvpwrvgnd_1
X_10327_ clknet_leaf_88_clk _00246_ VGND VGND VPWR VPWR picorv32_core.reg_next_pc\[17\]
+ sky130_fd_sc_hd__dfxtp_1
XTAP_TAPCELL_ROW_72_1352 VGND VPWR sky130_fd_sc_hd__tapvpwrvgnd_1
X_10258_ clknet_leaf_100_clk _00177_ VGND VGND VPWR VPWR picorv32_core.count_instr\[42\]
+ sky130_fd_sc_hd__dfxtp_1
XFILLER_94_701 VPWR VGND VPWR VGND sky130_ef_sc_hd__decap_12
X_10189_ clknet_leaf_138_clk _00108_ VGND VGND VPWR VPWR picorv32_core.cpuregs\[9\]\[5\]
+ sky130_fd_sc_hd__dfxtp_1
XFILLER_38_116 VGND VGND VPWR VPWR sky130_fd_sc_hd__fill_1
X_06420_ net260 net2019 net423 VGND VGND VPWR VPWR _00088_ sky130_fd_sc_hd__mux2_1
XTAP_TAPCELL_ROW_17_553 VGND VPWR sky130_fd_sc_hd__tapvpwrvgnd_1
X_06351_ picorv32_core.reg_pc\[22\] _02750_ VGND VGND VPWR VPWR _02755_ sky130_fd_sc_hd__and2_1
X_09070_ net1317 net261 net338 VGND VGND VPWR VPWR _01238_ sky130_fd_sc_hd__mux2_1
X_05302_ net28 net821 VGND VGND VPWR VPWR _01811_ sky130_fd_sc_hd__nand2b_1
X_06282_ picorv32_core.reg_out\[9\] picorv32_core.alu_out_q\[9\] net951 VGND VGND
+ VPWR VPWR _02699_ sky130_fd_sc_hd__mux2_1
X_08021_ picorv32_core.cpuregs\[12\]\[28\] picorv32_core.cpuregs\[13\]\[28\] picorv32_core.cpuregs\[14\]\[28\]
+ picorv32_core.cpuregs\[15\]\[28\] net754 net721 VGND VGND VPWR VPWR _04098_ sky130_fd_sc_hd__mux4_1
X_05233_ _01746_ VGND VGND VPWR VPWR _01747_ sky130_fd_sc_hd__inv_2
Xhold702 picorv32_core.cpuregs\[5\]\[25\] VGND VGND VPWR VPWR net1811 sky130_fd_sc_hd__dlygate4sd3_1
Xhold746 picorv32_core.cpuregs\[22\]\[23\] VGND VGND VPWR VPWR net1855 sky130_fd_sc_hd__dlygate4sd3_1
Xhold713 picorv32_core.cpuregs\[28\]\[30\] VGND VGND VPWR VPWR net1822 sky130_fd_sc_hd__dlygate4sd3_1
Xhold724 _00152_ VGND VGND VPWR VPWR net1833 sky130_fd_sc_hd__dlygate4sd3_1
Xhold735 picorv32_core.cpuregs\[18\]\[14\] VGND VGND VPWR VPWR net1844 sky130_fd_sc_hd__dlygate4sd3_1
X_05164_ picorv32_core.reg_sh\[4\] _01687_ VGND VGND VPWR VPWR _01689_ sky130_fd_sc_hd__or2_4
Xhold768 picorv32_core.cpuregs\[3\]\[23\] VGND VGND VPWR VPWR net1877 sky130_fd_sc_hd__dlygate4sd3_1
Xhold779 picorv32_core.cpuregs\[1\]\[21\] VGND VGND VPWR VPWR net1888 sky130_fd_sc_hd__dlygate4sd3_1
XPHY_EDGE_ROW_123_Right_123 VGND VGND VPWR VPWR sky130_fd_sc_hd__decap_3
Xhold757 net41 VGND VGND VPWR VPWR net1866 sky130_fd_sc_hd__dlygate4sd3_1
X_09972_ _04225_ _04346_ VGND VGND VPWR VPWR _05040_ sky130_fd_sc_hd__nor2_2
X_05095_ picorv32_core.mem_state\[0\] picorv32_core.mem_state\[1\] VGND VGND VPWR
+ VPWR _01627_ sky130_fd_sc_hd__nor2_1
XFILLER_130_124 VGND VGND VPWR VPWR sky130_fd_sc_hd__decap_6
X_08923_ net493 net2236 net354 VGND VGND VPWR VPWR _01096_ sky130_fd_sc_hd__mux2_1
XFILLER_131_669 VGND VGND VPWR VPWR sky130_fd_sc_hd__decap_3
XFILLER_97_561 VPWR VGND VPWR VGND sky130_ef_sc_hd__decap_12
XFILLER_85_701 VGND VGND VPWR VPWR sky130_fd_sc_hd__decap_3
XFILLER_69_285 VGND VGND VPWR VPWR sky130_fd_sc_hd__fill_1
XFILLER_57_436 VGND VGND VPWR VPWR sky130_fd_sc_hd__decap_4
X_08854_ net504 net1469 net365 VGND VGND VPWR VPWR _01029_ sky130_fd_sc_hd__mux2_1
X_08785_ net206 net1978 net376 VGND VGND VPWR VPWR _00932_ sky130_fd_sc_hd__mux2_1
X_05997_ net783 _02460_ VGND VGND VPWR VPWR _02462_ sky130_fd_sc_hd__nand2_1
X_07805_ net638 _03893_ VGND VGND VPWR VPWR _03894_ sky130_fd_sc_hd__or2_1
XFILLER_45_609 VGND VGND VPWR VPWR sky130_fd_sc_hd__fill_1
X_07736_ picorv32_core.cpuregs\[12\]\[12\] picorv32_core.cpuregs\[13\]\[12\] picorv32_core.cpuregs\[14\]\[12\]
+ picorv32_core.cpuregs\[15\]\[12\] net737 net704 VGND VGND VPWR VPWR _03829_ sky130_fd_sc_hd__mux4_1
XFILLER_52_141 VGND VGND VPWR VPWR sky130_fd_sc_hd__fill_1
X_07667_ net692 _03759_ _03758_ net618 VGND VGND VPWR VPWR _03764_ sky130_fd_sc_hd__o211a_1
X_06618_ _02892_ _02893_ VGND VGND VPWR VPWR _00189_ sky130_fd_sc_hd__nor2_1
XFILLER_71_38 VGND VGND VPWR VPWR sky130_fd_sc_hd__fill_2
X_07598_ picorv32_core.cpuregs\[8\]\[5\] picorv32_core.cpuregs\[9\]\[5\] picorv32_core.cpuregs\[10\]\[5\]
+ picorv32_core.cpuregs\[11\]\[5\] net733 net700 VGND VGND VPWR VPWR _03698_ sky130_fd_sc_hd__mux4_1
X_09406_ picorv32_core.cpuregs\[16\]\[10\] picorv32_core.cpuregs\[17\]\[10\] picorv32_core.cpuregs\[18\]\[10\]
+ picorv32_core.cpuregs\[19\]\[10\] net878 net845 VGND VGND VPWR VPWR _04595_ sky130_fd_sc_hd__mux4_1
X_06549_ net2267 _02848_ net997 VGND VGND VPWR VPWR _02850_ sky130_fd_sc_hd__o21ai_1
X_09337_ net610 _04524_ _04526_ _04528_ net485 VGND VGND VPWR VPWR _04529_ sky130_fd_sc_hd__a2111o_1
X_09268_ net662 _04462_ net644 VGND VGND VPWR VPWR _04463_ sky130_fd_sc_hd__a21o_1
XFILLER_21_561 VGND VGND VPWR VPWR sky130_fd_sc_hd__decap_6
X_08219_ picorv32_core.mem_rdata_q\[30\] _04187_ _04202_ _04203_ VGND VGND VPWR VPWR
+ _04210_ sky130_fd_sc_hd__and4_1
Xpicorv32_axi_1101 VGND VGND VPWR VPWR picorv32_axi_1101/HI trace_data[28] sky130_fd_sc_hd__conb_1
XFILLER_5_727 VGND VGND VPWR VPWR sky130_fd_sc_hd__fill_1
X_09199_ _01689_ _04395_ _04396_ net469 VGND VGND VPWR VPWR _04397_ sky130_fd_sc_hd__o22a_1
X_11230_ clknet_leaf_40_clk _01081_ VGND VGND VPWR VPWR picorv32_core.cpuregs\[5\]\[20\]
+ sky130_fd_sc_hd__dfxtp_1
XFILLER_105_3 VPWR VGND VPWR VGND sky130_ef_sc_hd__decap_12
XFILLER_136_53 VPWR VGND VPWR VGND sky130_ef_sc_hd__decap_12
X_11161_ clknet_leaf_18_clk _01012_ VGND VGND VPWR VPWR picorv32_core.cpuregs\[7\]\[15\]
+ sky130_fd_sc_hd__dfxtp_1
XFILLER_20_53 VPWR VGND VPWR VGND sky130_ef_sc_hd__decap_12
X_10112_ net1110 VGND VGND VPWR VPWR _00962_ sky130_fd_sc_hd__clkbuf_1
XFILLER_121_113 VGND VGND VPWR VPWR sky130_fd_sc_hd__decap_6
XTAP_TAPCELL_ROW_112_1931 VGND VPWR sky130_fd_sc_hd__tapvpwrvgnd_1
XFILLER_0_421 VGND VGND VPWR VPWR sky130_fd_sc_hd__decap_8
XFILLER_136_97 VPWR VGND VPWR VGND sky130_ef_sc_hd__decap_12
XFILLER_121_135 VGND VGND VPWR VPWR sky130_fd_sc_hd__fill_2
X_11092_ clknet_leaf_3_clk _00943_ VGND VGND VPWR VPWR picorv32_core.cpuregs\[0\]\[10\]
+ sky130_fd_sc_hd__dfxtp_1
XFILLER_102_382 VGND VGND VPWR VPWR sky130_fd_sc_hd__decap_4
XFILLER_76_745 VGND VGND VPWR VPWR sky130_fd_sc_hd__decap_8
Xhold40 picorv32_core.instr_beq VGND VGND VPWR VPWR net1149 sky130_fd_sc_hd__dlygate4sd3_1
XTAP_TAPCELL_ROW_54_1093 VGND VPWR sky130_fd_sc_hd__tapvpwrvgnd_1
XTAP_TAPCELL_ROW_54_1082 VGND VPWR sky130_fd_sc_hd__tapvpwrvgnd_1
X_10043_ net1641 net466 net305 VGND VGND VPWR VPWR _01518_ sky130_fd_sc_hd__mux2_1
Xhold73 net109 VGND VGND VPWR VPWR net1182 sky130_fd_sc_hd__dlygate4sd3_1
Xhold51 net116 VGND VGND VPWR VPWR net1160 sky130_fd_sc_hd__dlygate4sd3_1
Xhold62 net132 VGND VGND VPWR VPWR net1171 sky130_fd_sc_hd__dlygate4sd3_1
Xhold95 picorv32_core.cpuregs\[19\]\[28\] VGND VGND VPWR VPWR net1204 sky130_fd_sc_hd__dlygate4sd3_1
Xhold84 net185 VGND VGND VPWR VPWR net1193 sky130_fd_sc_hd__dlygate4sd3_1
XFILLER_91_726 VGND VGND VPWR VPWR sky130_fd_sc_hd__fill_2
XFILLER_63_417 VGND VGND VPWR VPWR sky130_fd_sc_hd__decap_4
XTAP_TAPCELL_ROW_141_2349 VGND VPWR sky130_fd_sc_hd__tapvpwrvgnd_1
X_10945_ clknet_leaf_44_clk _00796_ VGND VGND VPWR VPWR picorv32_core.cpuregs\[19\]\[23\]
+ sky130_fd_sc_hd__dfxtp_1
XFILLER_44_664 VGND VGND VPWR VPWR sky130_fd_sc_hd__fill_1
X_10876_ clknet_leaf_40_clk _00727_ VGND VGND VPWR VPWR picorv32_core.cpuregs\[16\]\[20\]
+ sky130_fd_sc_hd__dfxtp_1
XTAP_TAPCELL_ROW_14_501 VGND VPWR sky130_fd_sc_hd__tapvpwrvgnd_1
XTAP_TAPCELL_ROW_14_512 VGND VPWR sky130_fd_sc_hd__tapvpwrvgnd_1
XFILLER_45_94 VGND VGND VPWR VPWR sky130_fd_sc_hd__fill_1
XFILLER_8_598 VGND VGND VPWR VPWR sky130_fd_sc_hd__decap_3
XANTENNA_4 _01690_ VGND VGND VPWR VPWR sky130_fd_sc_hd__diode_2
X_11428_ clknet_leaf_4_clk _01264_ VGND VGND VPWR VPWR picorv32_core.cpuregs\[1\]\[11\]
+ sky130_fd_sc_hd__dfxtp_1
XFILLER_6_77 VGND VGND VPWR VPWR sky130_fd_sc_hd__decap_6
X_11359_ clknet_leaf_4_clk _01200_ VGND VGND VPWR VPWR picorv32_core.cpuregs\[18\]\[11\]
+ sky130_fd_sc_hd__dfxtp_1
XFILLER_4_793 VPWR VGND VPWR VGND sky130_ef_sc_hd__decap_12
XFILLER_79_561 VPWR VGND VPWR VGND sky130_ef_sc_hd__decap_12
XFILLER_79_594 VPWR VGND VPWR VGND sky130_ef_sc_hd__decap_12
XFILLER_67_734 VPWR VGND VPWR VGND sky130_ef_sc_hd__decap_12
X_05920_ net795 _02390_ VGND VGND VPWR VPWR _02391_ sky130_fd_sc_hd__nor2_1
XFILLER_39_447 VGND VGND VPWR VPWR sky130_fd_sc_hd__fill_1
X_05851_ net807 picorv32_core.mem_la_wdata\[7\] net567 net506 VGND VGND VPWR VPWR
+ _02328_ sky130_fd_sc_hd__a31o_1
X_08570_ net245 net2225 net400 VGND VGND VPWR VPWR _00695_ sky130_fd_sc_hd__mux2_1
XFILLER_94_597 VPWR VGND VPWR VGND sky130_ef_sc_hd__decap_12
X_07521_ picorv32_core.reg_out\[27\] picorv32_core.reg_next_pc\[27\] net559 VGND VGND
+ VPWR VPWR _03635_ sky130_fd_sc_hd__mux2_1
XTAP_TAPCELL_ROW_85_1532 VGND VPWR sky130_fd_sc_hd__tapvpwrvgnd_1
XFILLER_81_225 VGND VGND VPWR VPWR sky130_fd_sc_hd__fill_1
XFILLER_19_182 VGND VGND VPWR VPWR sky130_fd_sc_hd__fill_1
XFILLER_35_642 VGND VGND VPWR VPWR sky130_fd_sc_hd__fill_2
X_05782_ _02254_ _02261_ _02262_ _02264_ VGND VGND VPWR VPWR picorv32_core.alu_out\[1\]
+ sky130_fd_sc_hd__o22a_1
XTAP_TAPCELL_ROW_85_1543 VGND VPWR sky130_fd_sc_hd__tapvpwrvgnd_1
XFILLER_62_472 VGND VGND VPWR VPWR sky130_fd_sc_hd__decap_4
XFILLER_35_686 VGND VGND VPWR VPWR sky130_fd_sc_hd__fill_2
X_07452_ picorv32_core.reg_out\[4\] picorv32_core.reg_next_pc\[4\] net555 VGND VGND
+ VPWR VPWR _03589_ sky130_fd_sc_hd__mux2_1
X_07383_ _03520_ _03522_ _03419_ _03512_ VGND VGND VPWR VPWR _03523_ sky130_fd_sc_hd__and4b_1
XFILLER_50_645 VGND VGND VPWR VPWR sky130_fd_sc_hd__decap_4
X_06403_ net504 net1483 net423 VGND VGND VPWR VPWR _00071_ sky130_fd_sc_hd__mux2_1
X_06334_ picorv32_core.reg_pc\[18\] _02734_ picorv32_core.reg_pc\[19\] VGND VGND VPWR
+ VPWR _02741_ sky130_fd_sc_hd__a21oi_1
X_09122_ net1197 net494 net329 VGND VGND VPWR VPWR _01288_ sky130_fd_sc_hd__mux2_1
XFILLER_41_19 VGND VGND VPWR VPWR sky130_fd_sc_hd__fill_1
XFILLER_108_419 VGND VGND VPWR VPWR sky130_fd_sc_hd__fill_1
X_09053_ net1603 net502 net336 VGND VGND VPWR VPWR _01221_ sky130_fd_sc_hd__mux2_1
X_06265_ _02684_ _02685_ VGND VGND VPWR VPWR _02686_ sky130_fd_sc_hd__nor2_1
X_08004_ picorv32_core.cpuregs\[0\]\[27\] picorv32_core.cpuregs\[1\]\[27\] picorv32_core.cpuregs\[2\]\[27\]
+ picorv32_core.cpuregs\[3\]\[27\] net756 net723 VGND VGND VPWR VPWR _04082_ sky130_fd_sc_hd__mux4_1
Xhold510 picorv32_core.cpuregs\[1\]\[31\] VGND VGND VPWR VPWR net1619 sky130_fd_sc_hd__dlygate4sd3_1
X_05216_ net820 net35 _01718_ _01730_ VGND VGND VPWR VPWR _01731_ sky130_fd_sc_hd__o211a_1
X_06196_ net694 _02626_ VGND VGND VPWR VPWR _02627_ sky130_fd_sc_hd__or2_1
Xhold554 picorv32_core.cpuregs\[10\]\[30\] VGND VGND VPWR VPWR net1663 sky130_fd_sc_hd__dlygate4sd3_1
XTAP_TAPCELL_ROW_96_1694 VGND VPWR sky130_fd_sc_hd__tapvpwrvgnd_1
Xhold521 picorv32_core.cpuregs\[27\]\[15\] VGND VGND VPWR VPWR net1630 sky130_fd_sc_hd__dlygate4sd3_1
Xhold543 picorv32_core.cpuregs\[14\]\[5\] VGND VGND VPWR VPWR net1652 sky130_fd_sc_hd__dlygate4sd3_1
Xhold532 picorv32_core.cpuregs\[27\]\[4\] VGND VGND VPWR VPWR net1641 sky130_fd_sc_hd__dlygate4sd3_1
X_05147_ picorv32_core.mem_do_prefetch _01630_ VGND VGND VPWR VPWR _01675_ sky130_fd_sc_hd__nor2_1
Xhold587 picorv32_core.cpuregs\[12\]\[21\] VGND VGND VPWR VPWR net1696 sky130_fd_sc_hd__dlygate4sd3_1
Xhold576 picorv32_core.cpuregs\[16\]\[1\] VGND VGND VPWR VPWR net1685 sky130_fd_sc_hd__dlygate4sd3_1
Xhold565 picorv32_core.cpuregs\[30\]\[4\] VGND VGND VPWR VPWR net1674 sky130_fd_sc_hd__dlygate4sd3_1
X_05078_ net190 VGND VGND VPWR VPWR _01613_ sky130_fd_sc_hd__inv_2
X_09955_ net1302 net269 net317 VGND VGND VPWR VPWR _01433_ sky130_fd_sc_hd__mux2_1
XFILLER_58_701 VGND VGND VPWR VPWR sky130_fd_sc_hd__fill_1
Xhold598 picorv32_core.cpuregs\[23\]\[6\] VGND VGND VPWR VPWR net1707 sky130_fd_sc_hd__dlygate4sd3_1
X_09886_ net1232 net234 net326 VGND VGND VPWR VPWR _01374_ sky130_fd_sc_hd__mux2_1
X_08906_ net251 net1808 net360 VGND VGND VPWR VPWR _01080_ sky130_fd_sc_hd__mux2_1
Xhold1210 picorv32_core.count_cycle\[62\] VGND VGND VPWR VPWR net2319 sky130_fd_sc_hd__dlygate4sd3_1
Xhold1243 picorv32_core.count_instr\[59\] VGND VGND VPWR VPWR net2352 sky130_fd_sc_hd__dlygate4sd3_1
XFILLER_97_391 VGND VGND VPWR VPWR sky130_fd_sc_hd__fill_1
Xhold1221 picorv32_core.count_instr\[21\] VGND VGND VPWR VPWR net2330 sky130_fd_sc_hd__dlygate4sd3_1
X_08837_ net1784 net266 net367 VGND VGND VPWR VPWR _01013_ sky130_fd_sc_hd__mux2_1
Xhold1232 picorv32_core.decoded_imm\[14\] VGND VGND VPWR VPWR net2341 sky130_fd_sc_hd__dlygate4sd3_1
Xhold1254 picorv32_core.count_cycle\[55\] VGND VGND VPWR VPWR net2363 sky130_fd_sc_hd__dlygate4sd3_1
X_08768_ net273 net2144 net375 VGND VGND VPWR VPWR _00915_ sky130_fd_sc_hd__mux2_1
X_08699_ net1695 net292 net383 VGND VGND VPWR VPWR _00848_ sky130_fd_sc_hd__mux2_1
XFILLER_26_642 VGND VGND VPWR VPWR sky130_fd_sc_hd__fill_2
X_07719_ picorv32_core.cpuregs\[8\]\[11\] picorv32_core.cpuregs\[9\]\[11\] picorv32_core.cpuregs\[10\]\[11\]
+ picorv32_core.cpuregs\[11\]\[11\] net738 net705 VGND VGND VPWR VPWR _03813_ sky130_fd_sc_hd__mux4_1
X_10730_ clknet_leaf_89_clk _00581_ VGND VGND VPWR VPWR picorv32_core.decoded_imm\[29\]
+ sky130_fd_sc_hd__dfxtp_2
XTAP_TAPCELL_ROW_0_284 VGND VPWR sky130_fd_sc_hd__tapvpwrvgnd_1
XTAP_TAPCELL_ROW_0_295 VGND VPWR sky130_fd_sc_hd__tapvpwrvgnd_1
X_10661_ clknet_leaf_67_clk _00515_ VGND VGND VPWR VPWR picorv32_core.cpuregs\[20\]\[29\]
+ sky130_fd_sc_hd__dfxtp_1
XFILLER_80_280 VGND VGND VPWR VPWR sky130_fd_sc_hd__fill_1
XFILLER_15_42 VPWR VGND VPWR VGND sky130_ef_sc_hd__decap_12
X_10592_ clknet_leaf_88_clk _00446_ VGND VGND VPWR VPWR picorv32_core.instr_sltiu
+ sky130_fd_sc_hd__dfxtp_1
XFILLER_21_391 VGND VGND VPWR VPWR sky130_fd_sc_hd__fill_1
XFILLER_135_783 VGND VGND VPWR VPWR sky130_fd_sc_hd__fill_1
XTAP_TAPCELL_ROW_56_1122 VGND VPWR sky130_fd_sc_hd__tapvpwrvgnd_1
XTAP_TAPCELL_ROW_56_1111 VGND VPWR sky130_fd_sc_hd__tapvpwrvgnd_1
X_11213_ clknet_leaf_116_clk _01064_ VGND VGND VPWR VPWR picorv32_core.cpuregs\[5\]\[3\]
+ sky130_fd_sc_hd__dfxtp_1
Xoutput52 net52 VGND VGND VPWR VPWR mem_axi_araddr[23] sky130_fd_sc_hd__buf_2
Xoutput41 net41 VGND VGND VPWR VPWR mem_axi_araddr[12] sky130_fd_sc_hd__buf_2
Xoutput85 net85 VGND VGND VPWR VPWR mem_axi_awaddr[24] sky130_fd_sc_hd__buf_2
X_11144_ clknet_leaf_65_clk _00995_ VGND VGND VPWR VPWR picorv32_core.cpuregs\[8\]\[30\]
+ sky130_fd_sc_hd__dfxtp_1
XFILLER_122_455 VGND VGND VPWR VPWR sky130_fd_sc_hd__fill_1
Xoutput74 net74 VGND VGND VPWR VPWR mem_axi_awaddr[13] sky130_fd_sc_hd__buf_2
Xoutput63 net63 VGND VGND VPWR VPWR mem_axi_araddr[4] sky130_fd_sc_hd__buf_2
XFILLER_1_741 VPWR VGND VPWR VGND sky130_ef_sc_hd__decap_12
X_11075_ clknet_leaf_68_clk _00926_ VGND VGND VPWR VPWR picorv32_core.cpuregs\[10\]\[25\]
+ sky130_fd_sc_hd__dfxtp_1
XFILLER_49_712 VGND VGND VPWR VPWR sky130_fd_sc_hd__decap_4
Xoutput96 net96 VGND VGND VPWR VPWR mem_axi_awaddr[5] sky130_fd_sc_hd__buf_2
XFILLER_1_785 VPWR VGND VPWR VGND sky130_ef_sc_hd__decap_12
X_10026_ net1711 net250 net311 VGND VGND VPWR VPWR _01502_ sky130_fd_sc_hd__mux2_1
XFILLER_76_531 VGND VGND VPWR VPWR sky130_fd_sc_hd__fill_1
XFILLER_49_767 VPWR VGND VPWR VGND sky130_ef_sc_hd__decap_12
XFILLER_76_586 VGND VGND VPWR VPWR sky130_fd_sc_hd__fill_2
XFILLER_91_545 VGND VGND VPWR VPWR sky130_fd_sc_hd__fill_1
XTAP_TAPCELL_ROW_67_1273 VGND VPWR sky130_fd_sc_hd__tapvpwrvgnd_1
X_10928_ clknet_leaf_0_clk _00779_ VGND VGND VPWR VPWR picorv32_core.cpuregs\[19\]\[6\]
+ sky130_fd_sc_hd__dfxtp_1
XTAP_TAPCELL_ROW_27_692 VGND VPWR sky130_fd_sc_hd__tapvpwrvgnd_1
XFILLER_32_645 VGND VGND VPWR VPWR sky130_fd_sc_hd__decap_4
XTAP_TAPCELL_ROW_80_1462 VGND VPWR sky130_fd_sc_hd__tapvpwrvgnd_1
X_10859_ clknet_leaf_116_clk _00710_ VGND VGND VPWR VPWR picorv32_core.cpuregs\[16\]\[3\]
+ sky130_fd_sc_hd__dfxtp_1
XFILLER_8_362 VGND VGND VPWR VPWR sky130_fd_sc_hd__fill_2
X_06050_ net775 _02509_ VGND VGND VPWR VPWR _02511_ sky130_fd_sc_hd__and2_1
XFILLER_99_612 VGND VGND VPWR VPWR sky130_fd_sc_hd__decap_4
XFILLER_141_720 VGND VGND VPWR VPWR sky130_fd_sc_hd__decap_4
XFILLER_125_260 VGND VGND VPWR VPWR sky130_fd_sc_hd__fill_1
Xfanout319 _05039_ VGND VGND VPWR VPWR net319 sky130_fd_sc_hd__buf_2
XFILLER_101_606 VGND VGND VPWR VPWR sky130_fd_sc_hd__decap_8
Xfanout308 net309 VGND VGND VPWR VPWR net308 sky130_fd_sc_hd__buf_4
XFILLER_141_797 VGND VGND VPWR VPWR sky130_fd_sc_hd__decap_4
X_09740_ picorv32_core.cpuregs\[24\]\[25\] picorv32_core.cpuregs\[25\]\[25\] picorv32_core.cpuregs\[26\]\[25\]
+ picorv32_core.cpuregs\[27\]\[25\] net903 net871 VGND VGND VPWR VPWR _04914_ sky130_fd_sc_hd__mux4_1
XFILLER_101_617 VGND VGND VPWR VPWR sky130_fd_sc_hd__decap_3
X_06952_ _03130_ _03144_ VGND VGND VPWR VPWR _03167_ sky130_fd_sc_hd__nand2_1
.ends
